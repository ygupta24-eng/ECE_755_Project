* NGSPICE file created from top.ext - technology: sky130A

* Black-box entry subcircuit for sky130_fd_sc_hd__diode_2 abstract view
.subckt sky130_fd_sc_hd__diode_2 DIODE VGND VNB VPB VPWR
.ends

* Black-box entry subcircuit for sky130_fd_sc_hd__fill_2 abstract view
.subckt sky130_fd_sc_hd__fill_2 VGND VNB VPB VPWR
.ends

* Black-box entry subcircuit for sky130_fd_sc_hd__dfrtp_4 abstract view
.subckt sky130_fd_sc_hd__dfrtp_4 CLK D RESET_B VGND VNB VPB VPWR Q
.ends

* Black-box entry subcircuit for sky130_fd_sc_hd__clkbuf_1 abstract view
.subckt sky130_fd_sc_hd__clkbuf_1 A VGND VNB VPB VPWR X
.ends

* Black-box entry subcircuit for sky130_fd_sc_hd__nand4_1 abstract view
.subckt sky130_fd_sc_hd__nand4_1 A B C D VGND VNB VPB VPWR Y
.ends

* Black-box entry subcircuit for sky130_fd_sc_hd__a22o_1 abstract view
.subckt sky130_fd_sc_hd__a22o_1 A1 A2 B1 B2 VGND VNB VPB VPWR X
.ends

* Black-box entry subcircuit for sky130_fd_sc_hd__decap_4 abstract view
.subckt sky130_fd_sc_hd__decap_4 VGND VNB VPB VPWR
.ends

* Black-box entry subcircuit for sky130_fd_sc_hd__fill_1 abstract view
.subckt sky130_fd_sc_hd__fill_1 VGND VNB VPB VPWR
.ends

* Black-box entry subcircuit for sky130_fd_sc_hd__nand2_1 abstract view
.subckt sky130_fd_sc_hd__nand2_1 A B VGND VNB VPB VPWR Y
.ends

* Black-box entry subcircuit for sky130_fd_sc_hd__or2b_1 abstract view
.subckt sky130_fd_sc_hd__or2b_1 A B_N VGND VNB VPB VPWR X
.ends

* Black-box entry subcircuit for sky130_fd_sc_hd__decap_3 abstract view
.subckt sky130_fd_sc_hd__decap_3 VGND VNB VPB VPWR
.ends

* Black-box entry subcircuit for sky130_fd_sc_hd__dlygate4sd3_1 abstract view
.subckt sky130_fd_sc_hd__dlygate4sd3_1 A VGND VNB VPB VPWR X
.ends

* Black-box entry subcircuit for sky130_fd_sc_hd__decap_8 abstract view
.subckt sky130_fd_sc_hd__decap_8 VGND VNB VPB VPWR
.ends

* Black-box entry subcircuit for sky130_fd_sc_hd__dfrtp_1 abstract view
.subckt sky130_fd_sc_hd__dfrtp_1 CLK D RESET_B VGND VNB VPB VPWR Q
.ends

* Black-box entry subcircuit for sky130_fd_sc_hd__decap_6 abstract view
.subckt sky130_fd_sc_hd__decap_6 VGND VNB VPB VPWR
.ends

* Black-box entry subcircuit for sky130_ef_sc_hd__decap_12 abstract view
.subckt sky130_ef_sc_hd__decap_12 VPWR VGND VPB VNB
.ends

* Black-box entry subcircuit for sky130_fd_sc_hd__mux2_1 abstract view
.subckt sky130_fd_sc_hd__mux2_1 A0 A1 S VGND VNB VPB VPWR X
.ends

* Black-box entry subcircuit for sky130_fd_sc_hd__o21ai_1 abstract view
.subckt sky130_fd_sc_hd__o21ai_1 A1 A2 B1 VGND VNB VPB VPWR Y
.ends

* Black-box entry subcircuit for sky130_fd_sc_hd__a41o_1 abstract view
.subckt sky130_fd_sc_hd__a41o_1 A1 A2 A3 A4 B1 VGND VNB VPB VPWR X
.ends

* Black-box entry subcircuit for sky130_fd_sc_hd__a21oi_1 abstract view
.subckt sky130_fd_sc_hd__a21oi_1 A1 A2 B1 VGND VNB VPB VPWR Y
.ends

* Black-box entry subcircuit for sky130_fd_sc_hd__and2_1 abstract view
.subckt sky130_fd_sc_hd__and2_1 A B VGND VNB VPB VPWR X
.ends

* Black-box entry subcircuit for sky130_fd_sc_hd__a32o_1 abstract view
.subckt sky130_fd_sc_hd__a32o_1 A1 A2 A3 B1 B2 VGND VNB VPB VPWR X
.ends

* Black-box entry subcircuit for sky130_fd_sc_hd__a221o_1 abstract view
.subckt sky130_fd_sc_hd__a221o_1 A1 A2 B1 B2 C1 VGND VNB VPB VPWR X
.ends

* Black-box entry subcircuit for sky130_fd_sc_hd__dfrtp_2 abstract view
.subckt sky130_fd_sc_hd__dfrtp_2 CLK D RESET_B VGND VNB VPB VPWR Q
.ends

* Black-box entry subcircuit for sky130_fd_sc_hd__xnor2_1 abstract view
.subckt sky130_fd_sc_hd__xnor2_1 A B VGND VNB VPB VPWR Y
.ends

* Black-box entry subcircuit for sky130_fd_sc_hd__and2b_1 abstract view
.subckt sky130_fd_sc_hd__and2b_1 A_N B VGND VNB VPB VPWR X
.ends

* Black-box entry subcircuit for sky130_fd_sc_hd__tapvpwrvgnd_1 abstract view
.subckt sky130_fd_sc_hd__tapvpwrvgnd_1 VGND VPWR
.ends

* Black-box entry subcircuit for sky130_fd_sc_hd__nor2_1 abstract view
.subckt sky130_fd_sc_hd__nor2_1 A B VGND VNB VPB VPWR Y
.ends

* Black-box entry subcircuit for sky130_fd_sc_hd__inv_2 abstract view
.subckt sky130_fd_sc_hd__inv_2 A VGND VNB VPB VPWR Y
.ends

* Black-box entry subcircuit for sky130_fd_sc_hd__dfxtp_1 abstract view
.subckt sky130_fd_sc_hd__dfxtp_1 CLK D VGND VNB VPB VPWR Q
.ends

* Black-box entry subcircuit for sky130_fd_sc_hd__nand3_1 abstract view
.subckt sky130_fd_sc_hd__nand3_1 A B C VGND VNB VPB VPWR Y
.ends

* Black-box entry subcircuit for sky130_fd_sc_hd__clkbuf_8 abstract view
.subckt sky130_fd_sc_hd__clkbuf_8 A VGND VNB VPB VPWR X
.ends

* Black-box entry subcircuit for sky130_fd_sc_hd__o211a_1 abstract view
.subckt sky130_fd_sc_hd__o211a_1 A1 A2 B1 C1 VGND VNB VPB VPWR X
.ends

* Black-box entry subcircuit for sky130_fd_sc_hd__or2_2 abstract view
.subckt sky130_fd_sc_hd__or2_2 A B VGND VNB VPB VPWR X
.ends

* Black-box entry subcircuit for sky130_fd_sc_hd__dlymetal6s2s_1 abstract view
.subckt sky130_fd_sc_hd__dlymetal6s2s_1 A VGND VNB VPB VPWR X
.ends

* Black-box entry subcircuit for sky130_fd_sc_hd__nor3_1 abstract view
.subckt sky130_fd_sc_hd__nor3_1 A B C VGND VNB VPB VPWR Y
.ends

* Black-box entry subcircuit for sky130_fd_sc_hd__or2_1 abstract view
.subckt sky130_fd_sc_hd__or2_1 A B VGND VNB VPB VPWR X
.ends

* Black-box entry subcircuit for sky130_fd_sc_hd__and3_1 abstract view
.subckt sky130_fd_sc_hd__and3_1 A B C VGND VNB VPB VPWR X
.ends

* Black-box entry subcircuit for sky130_fd_sc_hd__a21o_1 abstract view
.subckt sky130_fd_sc_hd__a21o_1 A1 A2 B1 VGND VNB VPB VPWR X
.ends

* Black-box entry subcircuit for sky130_fd_sc_hd__nor2_8 abstract view
.subckt sky130_fd_sc_hd__nor2_8 A B VGND VNB VPB VPWR Y
.ends

* Black-box entry subcircuit for sky130_fd_sc_hd__or4_1 abstract view
.subckt sky130_fd_sc_hd__or4_1 A B C D VGND VNB VPB VPWR X
.ends

* Black-box entry subcircuit for sky130_fd_sc_hd__o21a_1 abstract view
.subckt sky130_fd_sc_hd__o21a_1 A1 A2 B1 VGND VNB VPB VPWR X
.ends

* Black-box entry subcircuit for sky130_fd_sc_hd__xor2_1 abstract view
.subckt sky130_fd_sc_hd__xor2_1 A B VGND VNB VPB VPWR X
.ends

* Black-box entry subcircuit for sky130_fd_sc_hd__a2bb2o_1 abstract view
.subckt sky130_fd_sc_hd__a2bb2o_1 A1_N A2_N B1 B2 VGND VNB VPB VPWR X
.ends

* Black-box entry subcircuit for sky130_fd_sc_hd__or3_1 abstract view
.subckt sky130_fd_sc_hd__or3_1 A B C VGND VNB VPB VPWR X
.ends

* Black-box entry subcircuit for sky130_fd_sc_hd__nand3_2 abstract view
.subckt sky130_fd_sc_hd__nand3_2 A B C VGND VNB VPB VPWR Y
.ends

* Black-box entry subcircuit for sky130_fd_sc_hd__clkbuf_4 abstract view
.subckt sky130_fd_sc_hd__clkbuf_4 A VGND VNB VPB VPWR X
.ends

* Black-box entry subcircuit for sky130_fd_sc_hd__clkbuf_16 abstract view
.subckt sky130_fd_sc_hd__clkbuf_16 A VGND VNB VPB VPWR X
.ends

* Black-box entry subcircuit for sky130_fd_sc_hd__a31oi_2 abstract view
.subckt sky130_fd_sc_hd__a31oi_2 A1 A2 A3 B1 VGND VNB VPB VPWR Y
.ends

* Black-box entry subcircuit for sky130_fd_sc_hd__nand4_2 abstract view
.subckt sky130_fd_sc_hd__nand4_2 A B C D VGND VNB VPB VPWR Y
.ends

* Black-box entry subcircuit for sky130_fd_sc_hd__and2_2 abstract view
.subckt sky130_fd_sc_hd__and2_2 A B VGND VNB VPB VPWR X
.ends

* Black-box entry subcircuit for sky130_fd_sc_hd__a21oi_2 abstract view
.subckt sky130_fd_sc_hd__a21oi_2 A1 A2 B1 VGND VNB VPB VPWR Y
.ends

* Black-box entry subcircuit for sky130_fd_sc_hd__a22o_4 abstract view
.subckt sky130_fd_sc_hd__a22o_4 A1 A2 B1 B2 VGND VNB VPB VPWR X
.ends

* Black-box entry subcircuit for sky130_fd_sc_hd__and4bb_2 abstract view
.subckt sky130_fd_sc_hd__and4bb_2 A_N B_N C D VGND VNB VPB VPWR X
.ends

* Black-box entry subcircuit for sky130_fd_sc_hd__or4b_1 abstract view
.subckt sky130_fd_sc_hd__or4b_1 A B C D_N VGND VNB VPB VPWR X
.ends

* Black-box entry subcircuit for sky130_fd_sc_hd__and4b_1 abstract view
.subckt sky130_fd_sc_hd__and4b_1 A_N B C D VGND VNB VPB VPWR X
.ends

* Black-box entry subcircuit for sky130_fd_sc_hd__buf_8 abstract view
.subckt sky130_fd_sc_hd__buf_8 A VGND VNB VPB VPWR X
.ends

* Black-box entry subcircuit for sky130_fd_sc_hd__a22oi_2 abstract view
.subckt sky130_fd_sc_hd__a22oi_2 A1 A2 B1 B2 VGND VNB VPB VPWR Y
.ends

* Black-box entry subcircuit for sky130_fd_sc_hd__a31o_1 abstract view
.subckt sky130_fd_sc_hd__a31o_1 A1 A2 A3 B1 VGND VNB VPB VPWR X
.ends

* Black-box entry subcircuit for sky130_fd_sc_hd__and3b_2 abstract view
.subckt sky130_fd_sc_hd__and3b_2 A_N B C VGND VNB VPB VPWR X
.ends

* Black-box entry subcircuit for sky130_fd_sc_hd__buf_4 abstract view
.subckt sky130_fd_sc_hd__buf_4 A VGND VNB VPB VPWR X
.ends

* Black-box entry subcircuit for sky130_fd_sc_hd__a22o_2 abstract view
.subckt sky130_fd_sc_hd__a22o_2 A1 A2 B1 B2 VGND VNB VPB VPWR X
.ends

* Black-box entry subcircuit for sky130_fd_sc_hd__o2bb2a_1 abstract view
.subckt sky130_fd_sc_hd__o2bb2a_1 A1_N A2_N B1 B2 VGND VNB VPB VPWR X
.ends

* Black-box entry subcircuit for sky130_fd_sc_hd__o31a_1 abstract view
.subckt sky130_fd_sc_hd__o31a_1 A1 A2 A3 B1 VGND VNB VPB VPWR X
.ends

* Black-box entry subcircuit for sky130_fd_sc_hd__and3b_1 abstract view
.subckt sky130_fd_sc_hd__and3b_1 A_N B C VGND VNB VPB VPWR X
.ends

* Black-box entry subcircuit for sky130_fd_sc_hd__buf_12 abstract view
.subckt sky130_fd_sc_hd__buf_12 A VGND VNB VPB VPWR X
.ends

* Black-box entry subcircuit for sky130_fd_sc_hd__or4_2 abstract view
.subckt sky130_fd_sc_hd__or4_2 A B C D VGND VNB VPB VPWR X
.ends

* Black-box entry subcircuit for sky130_fd_sc_hd__and4bb_1 abstract view
.subckt sky130_fd_sc_hd__and4bb_1 A_N B_N C D VGND VNB VPB VPWR X
.ends

* Black-box entry subcircuit for sky130_fd_sc_hd__a21bo_1 abstract view
.subckt sky130_fd_sc_hd__a21bo_1 A1 A2 B1_N VGND VNB VPB VPWR X
.ends

* Black-box entry subcircuit for sky130_fd_sc_hd__o211ai_1 abstract view
.subckt sky130_fd_sc_hd__o211ai_1 A1 A2 B1 C1 VGND VNB VPB VPWR Y
.ends

* Black-box entry subcircuit for sky130_fd_sc_hd__or4bb_1 abstract view
.subckt sky130_fd_sc_hd__or4bb_1 A B C_N D_N VGND VNB VPB VPWR X
.ends

* Black-box entry subcircuit for sky130_fd_sc_hd__a221o_2 abstract view
.subckt sky130_fd_sc_hd__a221o_2 A1 A2 B1 B2 C1 VGND VNB VPB VPWR X
.ends

* Black-box entry subcircuit for sky130_fd_sc_hd__o211a_2 abstract view
.subckt sky130_fd_sc_hd__o211a_2 A1 A2 B1 C1 VGND VNB VPB VPWR X
.ends

* Black-box entry subcircuit for sky130_fd_sc_hd__o32ai_1 abstract view
.subckt sky130_fd_sc_hd__o32ai_1 A1 A2 A3 B1 B2 VGND VNB VPB VPWR Y
.ends

* Black-box entry subcircuit for sky130_fd_sc_hd__buf_2 abstract view
.subckt sky130_fd_sc_hd__buf_2 A VGND VNB VPB VPWR X
.ends

* Black-box entry subcircuit for sky130_fd_sc_hd__a211o_1 abstract view
.subckt sky130_fd_sc_hd__a211o_1 A1 A2 B1 C1 VGND VNB VPB VPWR X
.ends

* Black-box entry subcircuit for sky130_fd_sc_hd__buf_6 abstract view
.subckt sky130_fd_sc_hd__buf_6 A VGND VNB VPB VPWR X
.ends

* Black-box entry subcircuit for sky130_fd_sc_hd__o21ai_2 abstract view
.subckt sky130_fd_sc_hd__o21ai_2 A1 A2 B1 VGND VNB VPB VPWR Y
.ends

* Black-box entry subcircuit for sky130_fd_sc_hd__o41a_2 abstract view
.subckt sky130_fd_sc_hd__o41a_2 A1 A2 A3 A4 B1 VGND VNB VPB VPWR X
.ends

* Black-box entry subcircuit for sky130_fd_sc_hd__a21o_2 abstract view
.subckt sky130_fd_sc_hd__a21o_2 A1 A2 B1 VGND VNB VPB VPWR X
.ends

* Black-box entry subcircuit for sky130_fd_sc_hd__nor2_4 abstract view
.subckt sky130_fd_sc_hd__nor2_4 A B VGND VNB VPB VPWR Y
.ends

* Black-box entry subcircuit for sky130_fd_sc_hd__o21ba_1 abstract view
.subckt sky130_fd_sc_hd__o21ba_1 A1 A2 B1_N VGND VNB VPB VPWR X
.ends

* Black-box entry subcircuit for sky130_fd_sc_hd__or3_2 abstract view
.subckt sky130_fd_sc_hd__or3_2 A B C VGND VNB VPB VPWR X
.ends

* Black-box entry subcircuit for sky130_fd_sc_hd__nor3b_1 abstract view
.subckt sky130_fd_sc_hd__nor3b_1 A B C_N VGND VNB VPB VPWR Y
.ends

* Black-box entry subcircuit for sky130_fd_sc_hd__a31o_4 abstract view
.subckt sky130_fd_sc_hd__a31o_4 A1 A2 A3 B1 VGND VNB VPB VPWR X
.ends

* Black-box entry subcircuit for sky130_fd_sc_hd__nor2_2 abstract view
.subckt sky130_fd_sc_hd__nor2_2 A B VGND VNB VPB VPWR Y
.ends

* Black-box entry subcircuit for sky130_fd_sc_hd__and4_1 abstract view
.subckt sky130_fd_sc_hd__and4_1 A B C D VGND VNB VPB VPWR X
.ends

* Black-box entry subcircuit for sky130_fd_sc_hd__buf_1 abstract view
.subckt sky130_fd_sc_hd__buf_1 A VGND VNB VPB VPWR X
.ends

* Black-box entry subcircuit for sky130_fd_sc_hd__a22oi_1 abstract view
.subckt sky130_fd_sc_hd__a22oi_1 A1 A2 B1 B2 VGND VNB VPB VPWR Y
.ends

* Black-box entry subcircuit for sky130_fd_sc_hd__and4b_2 abstract view
.subckt sky130_fd_sc_hd__and4b_2 A_N B C D VGND VNB VPB VPWR X
.ends

* Black-box entry subcircuit for sky130_fd_sc_hd__a21o_4 abstract view
.subckt sky130_fd_sc_hd__a21o_4 A1 A2 B1 VGND VNB VPB VPWR X
.ends

* Black-box entry subcircuit for sky130_fd_sc_hd__o211a_4 abstract view
.subckt sky130_fd_sc_hd__o211a_4 A1 A2 B1 C1 VGND VNB VPB VPWR X
.ends

* Black-box entry subcircuit for sky130_fd_sc_hd__o22ai_1 abstract view
.subckt sky130_fd_sc_hd__o22ai_1 A1 A2 B1 B2 VGND VNB VPB VPWR Y
.ends

* Black-box entry subcircuit for sky130_fd_sc_hd__mux2_2 abstract view
.subckt sky130_fd_sc_hd__mux2_2 A0 A1 S VGND VNB VPB VPWR X
.ends

* Black-box entry subcircuit for sky130_fd_sc_hd__a21boi_1 abstract view
.subckt sky130_fd_sc_hd__a21boi_1 A1 A2 B1_N VGND VNB VPB VPWR Y
.ends

* Black-box entry subcircuit for sky130_fd_sc_hd__xnor2_2 abstract view
.subckt sky130_fd_sc_hd__xnor2_2 A B VGND VNB VPB VPWR Y
.ends

* Black-box entry subcircuit for sky130_fd_sc_hd__clkbuf_2 abstract view
.subckt sky130_fd_sc_hd__clkbuf_2 A VGND VNB VPB VPWR X
.ends

* Black-box entry subcircuit for sky130_fd_sc_hd__and3_2 abstract view
.subckt sky130_fd_sc_hd__and3_2 A B C VGND VNB VPB VPWR X
.ends

* Black-box entry subcircuit for sky130_fd_sc_hd__o31ai_1 abstract view
.subckt sky130_fd_sc_hd__o31ai_1 A1 A2 A3 B1 VGND VNB VPB VPWR Y
.ends

* Black-box entry subcircuit for sky130_fd_sc_hd__nand2_2 abstract view
.subckt sky130_fd_sc_hd__nand2_2 A B VGND VNB VPB VPWR Y
.ends

* Black-box entry subcircuit for sky130_fd_sc_hd__or3b_1 abstract view
.subckt sky130_fd_sc_hd__or3b_1 A B C_N VGND VNB VPB VPWR X
.ends

* Black-box entry subcircuit for sky130_fd_sc_hd__and4_2 abstract view
.subckt sky130_fd_sc_hd__and4_2 A B C D VGND VNB VPB VPWR X
.ends

* Black-box entry subcircuit for sky130_fd_sc_hd__o21ai_4 abstract view
.subckt sky130_fd_sc_hd__o21ai_4 A1 A2 B1 VGND VNB VPB VPWR Y
.ends

* Black-box entry subcircuit for sky130_fd_sc_hd__a311o_1 abstract view
.subckt sky130_fd_sc_hd__a311o_1 A1 A2 A3 B1 C1 VGND VNB VPB VPWR X
.ends

* Black-box entry subcircuit for sky130_fd_sc_hd__nor3_2 abstract view
.subckt sky130_fd_sc_hd__nor3_2 A B C VGND VNB VPB VPWR Y
.ends

* Black-box entry subcircuit for sky130_fd_sc_hd__nor4_1 abstract view
.subckt sky130_fd_sc_hd__nor4_1 A B C D VGND VNB VPB VPWR Y
.ends

* Black-box entry subcircuit for sky130_fd_sc_hd__o2bb2a_2 abstract view
.subckt sky130_fd_sc_hd__o2bb2a_2 A1_N A2_N B1 B2 VGND VNB VPB VPWR X
.ends

* Black-box entry subcircuit for sky130_fd_sc_hd__o211ai_2 abstract view
.subckt sky130_fd_sc_hd__o211ai_2 A1 A2 B1 C1 VGND VNB VPB VPWR Y
.ends

* Black-box entry subcircuit for sky130_fd_sc_hd__nand2_4 abstract view
.subckt sky130_fd_sc_hd__nand2_4 A B VGND VNB VPB VPWR Y
.ends

* Black-box entry subcircuit for sky130_fd_sc_hd__mux2_4 abstract view
.subckt sky130_fd_sc_hd__mux2_4 A0 A1 S VGND VNB VPB VPWR X
.ends

* Black-box entry subcircuit for sky130_fd_sc_hd__xor2_2 abstract view
.subckt sky130_fd_sc_hd__xor2_2 A B VGND VNB VPB VPWR X
.ends

* Black-box entry subcircuit for sky130_fd_sc_hd__nor3_4 abstract view
.subckt sky130_fd_sc_hd__nor3_4 A B C VGND VNB VPB VPWR Y
.ends

* Black-box entry subcircuit for sky130_fd_sc_hd__nor2b_1 abstract view
.subckt sky130_fd_sc_hd__nor2b_1 A B_N VGND VNB VPB VPWR Y
.ends

.subckt top VGND VPWR clk done h_in0[0] h_in0[1] h_in0[2] h_in0[3] h_in0[4] h_in0[5]
+ h_in1[0] h_in1[1] h_in1[2] h_in1[3] h_in1[4] h_in1[5] psum_out0[0] psum_out0[10]
+ psum_out0[11] psum_out0[12] psum_out0[1] psum_out0[2] psum_out0[3] psum_out0[4]
+ psum_out0[5] psum_out0[6] psum_out0[7] psum_out0[8] psum_out0[9] psum_out1[0] psum_out1[10]
+ psum_out1[11] psum_out1[12] psum_out1[1] psum_out1[2] psum_out1[3] psum_out1[4]
+ psum_out1[5] psum_out1[6] psum_out1[7] psum_out1[8] psum_out1[9] rst_n start v_in0[0]
+ v_in0[1] v_in0[2] v_in0[3] v_in0[4] v_in0[5] v_in1[0] v_in1[1] v_in1[2] v_in1[3]
+ v_in1[4] v_in1[5] w_in_flat[0] w_in_flat[1] w_in_flat[2] w_in_flat[3] w_in_flat[4]
+ w_in_flat[5] w_in_flat[6] w_in_flat[7]
XANTENNA__5417__B1 _2071_ VGND VGND VPWR VPWR sky130_fd_sc_hd__diode_2
XFILLER_0_27_93 VGND VGND VPWR VPWR sky130_fd_sc_hd__fill_2
XFILLER_0_89_483 VGND VGND VPWR VPWR sky130_fd_sc_hd__fill_2
X_6914_ clknet_leaf_37_clk _0000_ net813 VGND VGND VPWR VPWR u_fsm.cnt\[0\] sky130_fd_sc_hd__dfrtp_4
X_6845_ _3404_ VGND VGND VPWR VPWR _0684_ sky130_fd_sc_hd__clkbuf_1
XFILLER_0_92_615 VGND VGND VPWR VPWR sky130_fd_sc_hd__fill_2
X_6776_ _3367_ VGND VGND VPWR VPWR _0652_ sky130_fd_sc_hd__clkbuf_1
XANTENNA__5196__A2 _2144_ VGND VGND VPWR VPWR sky130_fd_sc_hd__diode_2
X_3988_ u_pe_array.g_pe_row\[3\].g_pe_col\[1\].u_pe.w_reg\[0\] u_pe_array.g_pe_row\[3\].g_pe_col\[1\].u_pe.act_val\[1\]
+ _1148_ _1149_ VGND VGND VPWR VPWR _1151_ sky130_fd_sc_hd__nand4_1
XFILLER_0_17_222 VGND VGND VPWR VPWR sky130_fd_sc_hd__fill_2
X_5727_ net132 _2600_ _2602_ _2336_ VGND VGND VPWR VPWR _0368_ sky130_fd_sc_hd__a22o_1
XFILLER_0_60_501 VGND VGND VPWR VPWR sky130_fd_sc_hd__decap_4
XFILLER_0_60_512 VGND VGND VPWR VPWR sky130_fd_sc_hd__fill_1
XANTENNA__4156__B1 _0885_ VGND VGND VPWR VPWR sky130_fd_sc_hd__diode_2
X_5658_ _2543_ _2549_ VGND VGND VPWR VPWR _2550_ sky130_fd_sc_hd__nand2_1
XFILLER_0_102_135 VGND VGND VPWR VPWR sky130_fd_sc_hd__fill_1
X_5589_ u_pe_array.g_pe_row\[1\].g_pe_col\[0\].u_pe.act_val\[1\] _2478_ VGND VGND
+ VPWR VPWR _2486_ sky130_fd_sc_hd__or2b_1
X_4609_ net423 _1524_ _1663_ _1399_ VGND VGND VPWR VPWR _0189_ sky130_fd_sc_hd__a22o_1
XFILLER_0_60_589 VGND VGND VPWR VPWR sky130_fd_sc_hd__fill_2
XFILLER_0_102_168 VGND VGND VPWR VPWR sky130_fd_sc_hd__decap_3
Xhold340 u_pe_array.g_pe_row\[0\].g_pe_col\[0\].u_pe.move_reg\[9\] VGND VGND VPWR
+ VPWR net416 sky130_fd_sc_hd__dlygate4sd3_1
Xhold351 u_pe_array.u_fifo1.buffer\[5\]\[3\] VGND VGND VPWR VPWR net427 sky130_fd_sc_hd__dlygate4sd3_1
Xhold362 u_pe_array.g_pe_row\[0\].g_pe_col\[2\].u_pe.psum_out\[12\] VGND VGND VPWR
+ VPWR net438 sky130_fd_sc_hd__dlygate4sd3_1
XFILLER_0_7_81 VGND VGND VPWR VPWR sky130_fd_sc_hd__fill_2
XFILLER_0_7_70 VGND VGND VPWR VPWR sky130_fd_sc_hd__decap_8
X_7328_ clknet_leaf_66_clk _0385_ net13 VGND VGND VPWR VPWR u_pe_array.g_pe_row\[0\].g_pe_col\[3\].u_pe.psum_out\[12\]
+ sky130_fd_sc_hd__dfrtp_1
Xhold395 u_pe_array.u_fifo1.buffer\[1\]\[3\] VGND VGND VPWR VPWR net471 sky130_fd_sc_hd__dlygate4sd3_1
X_7259_ clknet_leaf_56_clk _0320_ net75 VGND VGND VPWR VPWR u_pe_array.g_pe_row\[1\].g_pe_col\[1\].u_pe.psum_out\[3\]
+ sky130_fd_sc_hd__dfrtp_1
Xhold384 u_pe_array.u_fifo1.buffer\[4\]\[2\] VGND VGND VPWR VPWR net460 sky130_fd_sc_hd__dlygate4sd3_1
Xhold373 u_pe_array.g_pe_row\[1\].g_pe_col\[3\].u_pe.psum_out\[4\] VGND VGND VPWR
+ VPWR net449 sky130_fd_sc_hd__dlygate4sd3_1
XFILLER_0_40_291 VGND VGND VPWR VPWR sky130_fd_sc_hd__fill_2
XANTENNA_fanout75_A net817 VGND VGND VPWR VPWR sky130_fd_sc_hd__diode_2
XFILLER_0_99_225 VGND VGND VPWR VPWR sky130_fd_sc_hd__fill_2
XFILLER_0_99_269 VGND VGND VPWR VPWR sky130_fd_sc_hd__decap_3
XFILLER_0_36_520 VGND VGND VPWR VPWR sky130_fd_sc_hd__fill_1
XFILLER_0_82_147 VGND VGND VPWR VPWR sky130_fd_sc_hd__decap_3
XFILLER_0_70_309 VGND VGND VPWR VPWR sky130_fd_sc_hd__decap_4
XFILLER_0_106_441 VGND VGND VPWR VPWR sky130_fd_sc_hd__decap_8
XFILLER_0_3_609 VGND VGND VPWR VPWR sky130_fd_sc_hd__decap_6
XANTENNA__7272__RESET_B net814 VGND VGND VPWR VPWR sky130_fd_sc_hd__diode_2
XANTENNA__6204__B_N _2992_ VGND VGND VPWR VPWR sky130_fd_sc_hd__diode_2
XANTENNA__7201__RESET_B net814 VGND VGND VPWR VPWR sky130_fd_sc_hd__diode_2
XANTENNA_output56_A net56 VGND VGND VPWR VPWR sky130_fd_sc_hd__diode_2
XFILLER_0_3_39 VPWR VGND VPWR VGND sky130_ef_sc_hd__decap_12
XFILLER_0_98_291 VGND VGND VPWR VPWR sky130_fd_sc_hd__fill_2
XFILLER_0_58_111 VGND VGND VPWR VPWR sky130_fd_sc_hd__fill_1
X_4960_ u_pe_array.g_pe_row\[0\].g_pe_col\[3\].u_pe.w_buffer\[1\] net89 _0828_ VGND
+ VGND VPWR VPWR _1957_ sky130_fd_sc_hd__mux2_1
X_4891_ _1884_ _1887_ _1896_ VGND VGND VPWR VPWR _1897_ sky130_fd_sc_hd__o21ai_1
XFILLER_0_86_464 VGND VGND VPWR VPWR sky130_fd_sc_hd__decap_3
X_3911_ _1084_ _1086_ _1087_ _1093_ net72 VGND VGND VPWR VPWR _1095_ sky130_fd_sc_hd__a41o_1
XFILLER_0_104_53 VGND VGND VPWR VPWR sky130_fd_sc_hd__decap_4
XFILLER_0_86_497 VGND VGND VPWR VPWR sky130_fd_sc_hd__fill_2
XFILLER_0_80_79 VGND VGND VPWR VPWR sky130_fd_sc_hd__fill_2
X_6630_ net695 _2738_ _2592_ _3284_ VGND VGND VPWR VPWR _0589_ sky130_fd_sc_hd__a22o_1
X_3842_ _1030_ _1009_ u_pe_array.g_pe_row\[3\].g_pe_col\[2\].u_pe.psum_out\[3\] VGND
+ VGND VPWR VPWR _1031_ sky130_fd_sc_hd__a21oi_1
XFILLER_0_73_169 VGND VGND VPWR VPWR sky130_fd_sc_hd__fill_2
X_6561_ net287 _1812_ _3239_ VGND VGND VPWR VPWR _3248_ sky130_fd_sc_hd__mux2_1
X_5512_ _2345_ u_pe_array.g_pe_row\[1\].g_pe_col\[1\].u_pe.psum_out\[9\] VGND VGND
+ VPWR VPWR _2430_ sky130_fd_sc_hd__and2_1
X_3773_ _0966_ _0971_ _0977_ _0980_ _0976_ VGND VGND VPWR VPWR _0981_ sky130_fd_sc_hd__a32o_1
XFILLER_0_42_501 VGND VGND VPWR VPWR sky130_fd_sc_hd__fill_2
XFILLER_0_14_247 VGND VGND VPWR VPWR sky130_fd_sc_hd__decap_3
X_6492_ net490 _1800_ _3208_ VGND VGND VPWR VPWR _3211_ sky130_fd_sc_hd__mux2_1
X_5443_ _2364_ _2366_ VGND VGND VPWR VPWR _2367_ sky130_fd_sc_hd__nand2_1
XFILLER_0_42_567 VGND VGND VPWR VPWR sky130_fd_sc_hd__decap_6
XFILLER_0_112_477 VPWR VGND VPWR VGND sky130_ef_sc_hd__decap_12
XFILLER_0_112_466 VGND VGND VPWR VPWR sky130_fd_sc_hd__decap_8
XANTENNA__5350__A2 _2273_ VGND VGND VPWR VPWR sky130_fd_sc_hd__diode_2
X_5374_ u_pe_array.u_fifo1.buffer\[5\]\[3\] _2284_ _2285_ u_pe_array.u_fifo1.buffer\[6\]\[3\]
+ _2286_ VGND VGND VPWR VPWR _2311_ sky130_fd_sc_hd__a221o_1
X_7113_ clknet_leaf_36_clk _0184_ net76 VGND VGND VPWR VPWR u_pe_array.g_pe_row\[2\].g_pe_col\[0\].u_pe.act_val\[5\]
+ sky130_fd_sc_hd__dfrtp_2
X_4325_ _1427_ _1429_ VGND VGND VPWR VPWR _1430_ sky130_fd_sc_hd__xnor2_1
XFILLER_0_10_475 VGND VGND VPWR VPWR sky130_fd_sc_hd__fill_1
X_4256_ u_pe_array.g_pe_row\[3\].g_pe_col\[0\].u_pe.psum_out\[10\] _1377_ _1380_ VGND
+ VGND VPWR VPWR _1381_ sky130_fd_sc_hd__a21oi_1
X_7044_ clknet_leaf_36_clk _0119_ net76 VGND VGND VPWR VPWR u_pe_array.g_pe_row\[3\].g_pe_col\[0\].u_pe.psum_out\[11\]
+ sky130_fd_sc_hd__dfrtp_1
XFILLER_0_38_81 VGND VGND VPWR VPWR sky130_fd_sc_hd__decap_3
XANTENNA__6356__S _3110_ VGND VGND VPWR VPWR sky130_fd_sc_hd__diode_2
X_4187_ u_pe_array.g_pe_row\[3\].g_pe_col\[0\].u_pe.act_val\[4\] _1275_ VGND VGND
+ VPWR VPWR _1318_ sky130_fd_sc_hd__and2b_1
XANTENNA__6995__RESET_B net817 VGND VGND VPWR VPWR sky130_fd_sc_hd__diode_2
XFILLER_0_96_206 VGND VGND VPWR VPWR sky130_fd_sc_hd__decap_6
XANTENNA__6924__RESET_B net813 VGND VGND VPWR VPWR sky130_fd_sc_hd__diode_2
XFILLER_0_77_442 VGND VGND VPWR VPWR sky130_fd_sc_hd__fill_2
XTAP_1129 VGND VPWR sky130_fd_sc_hd__tapvpwrvgnd_1
XTAP_1107 VGND VPWR sky130_fd_sc_hd__tapvpwrvgnd_1
XTAP_1118 VGND VPWR sky130_fd_sc_hd__tapvpwrvgnd_1
XFILLER_0_54_80 VGND VGND VPWR VPWR sky130_fd_sc_hd__decap_4
XFILLER_0_49_122 VGND VGND VPWR VPWR sky130_fd_sc_hd__fill_1
XFILLER_0_65_604 VGND VGND VPWR VPWR sky130_fd_sc_hd__fill_2
X_6828_ net230 _3134_ _3382_ VGND VGND VPWR VPWR _3395_ sky130_fd_sc_hd__mux2_1
XFILLER_0_92_467 VGND VGND VPWR VPWR sky130_fd_sc_hd__fill_1
XFILLER_0_52_309 VGND VGND VPWR VPWR sky130_fd_sc_hd__fill_1
XANTENNA__3728__B _0869_ VGND VGND VPWR VPWR sky130_fd_sc_hd__diode_2
XFILLER_0_107_249 VGND VGND VPWR VPWR sky130_fd_sc_hd__fill_2
X_6759_ _3358_ VGND VGND VPWR VPWR _0644_ sky130_fd_sc_hd__clkbuf_1
XANTENNA_clkbuf_leaf_93_clk_A clknet_3_0__leaf_clk VGND VGND VPWR VPWR sky130_fd_sc_hd__diode_2
XFILLER_0_60_375 VGND VGND VPWR VPWR sky130_fd_sc_hd__fill_1
XFILLER_0_33_567 VGND VGND VPWR VPWR sky130_fd_sc_hd__fill_1
XANTENNA__5877__B1 _2592_ VGND VGND VPWR VPWR sky130_fd_sc_hd__diode_2
XFILLER_0_20_217 VGND VGND VPWR VPWR sky130_fd_sc_hd__decap_3
XFILLER_0_20_228 VGND VGND VPWR VPWR sky130_fd_sc_hd__fill_1
Xhold170 u_pe_array.g_pe_row\[0\].g_pe_col\[2\].u_pe.move_reg\[7\] VGND VGND VPWR
+ VPWR net246 sky130_fd_sc_hd__dlygate4sd3_1
Xhold192 u_pe_array.u_fifo1.buffer\[5\]\[10\] VGND VGND VPWR VPWR net268 sky130_fd_sc_hd__dlygate4sd3_1
Xhold181 u_pe_array.u_fifo1.buffer\[5\]\[8\] VGND VGND VPWR VPWR net257 sky130_fd_sc_hd__dlygate4sd3_1
XANTENNA_clkbuf_leaf_31_clk_A clknet_3_3__leaf_clk VGND VGND VPWR VPWR sky130_fd_sc_hd__diode_2
XANTENNA__5170__S _0828_ VGND VGND VPWR VPWR sky130_fd_sc_hd__diode_2
XANTENNA_clkbuf_leaf_46_clk_A clknet_3_7__leaf_clk VGND VGND VPWR VPWR sky130_fd_sc_hd__diode_2
XANTENNA__4604__B2 _1399_ VGND VGND VPWR VPWR sky130_fd_sc_hd__diode_2
XTAP_1630 VGND VPWR sky130_fd_sc_hd__tapvpwrvgnd_1
XFILLER_0_95_250 VGND VGND VPWR VPWR sky130_fd_sc_hd__fill_2
XFILLER_0_68_475 VGND VGND VPWR VPWR sky130_fd_sc_hd__fill_1
XFILLER_0_95_261 VGND VGND VPWR VPWR sky130_fd_sc_hd__decap_4
XFILLER_0_56_626 VGND VGND VPWR VPWR sky130_fd_sc_hd__fill_2
XFILLER_0_55_103 VGND VGND VPWR VPWR sky130_fd_sc_hd__decap_4
XFILLER_0_83_445 VGND VGND VPWR VPWR sky130_fd_sc_hd__decap_3
XFILLER_0_50_27 VGND VGND VPWR VPWR sky130_fd_sc_hd__fill_1
XFILLER_0_55_169 VGND VGND VPWR VPWR sky130_fd_sc_hd__fill_2
XFILLER_0_43_309 VGND VGND VPWR VPWR sky130_fd_sc_hd__fill_2
XFILLER_0_36_350 VGND VGND VPWR VPWR sky130_fd_sc_hd__fill_2
XFILLER_0_36_361 VGND VGND VPWR VPWR sky130_fd_sc_hd__decap_3
XFILLER_0_113_208 VGND VGND VPWR VPWR sky130_fd_sc_hd__fill_2
XFILLER_0_24_589 VGND VGND VPWR VPWR sky130_fd_sc_hd__fill_1
XANTENNA__5853__B _2611_ VGND VGND VPWR VPWR sky130_fd_sc_hd__diode_2
XFILLER_0_11_239 VGND VGND VPWR VPWR sky130_fd_sc_hd__decap_3
XANTENNA__5868__A0 net32 VGND VGND VPWR VPWR sky130_fd_sc_hd__diode_2
XFILLER_0_59_69 VPWR VGND VPWR VGND sky130_ef_sc_hd__decap_12
XFILLER_0_75_35 VGND VGND VPWR VPWR sky130_fd_sc_hd__fill_1
X_5090_ _2066_ _2068_ VGND VGND VPWR VPWR _2069_ sky130_fd_sc_hd__nand2_1
X_4110_ net601 _1138_ _0837_ _1257_ VGND VGND VPWR VPWR _0096_ sky130_fd_sc_hd__a22o_1
X_4041_ _1192_ _1196_ VGND VGND VPWR VPWR _1199_ sky130_fd_sc_hd__nor2_1
XANTENNA__4843__A1 _1725_ VGND VGND VPWR VPWR sky130_fd_sc_hd__diode_2
XANTENNA__3820__C _1009_ VGND VGND VPWR VPWR sky130_fd_sc_hd__diode_2
XFILLER_0_78_217 VGND VGND VPWR VPWR sky130_fd_sc_hd__fill_2
XANTENNA__6904__S _3427_ VGND VGND VPWR VPWR sky130_fd_sc_hd__diode_2
X_5992_ _2826_ VGND VGND VPWR VPWR _2827_ sky130_fd_sc_hd__inv_2
XFILLER_0_91_89 VGND VGND VPWR VPWR sky130_fd_sc_hd__fill_2
X_4943_ _1938_ _1943_ VGND VGND VPWR VPWR _1944_ sky130_fd_sc_hd__and2_1
XFILLER_0_86_250 VGND VGND VPWR VPWR sky130_fd_sc_hd__fill_2
XFILLER_0_47_615 VGND VGND VPWR VPWR sky130_fd_sc_hd__fill_1
X_7662_ clknet_leaf_25_clk _0711_ VGND VGND VPWR VPWR u_pe_array.u_fifo1.buffer\[7\]\[7\]
+ sky130_fd_sc_hd__dfxtp_1
XANTENNA__4424__S _0770_ VGND VGND VPWR VPWR sky130_fd_sc_hd__diode_2
X_4874_ u_pe_array.g_pe_row\[2\].g_pe_col\[0\].u_pe.psum_out\[4\] _1879_ _1880_ VGND
+ VGND VPWR VPWR _1881_ sky130_fd_sc_hd__nand3_1
XFILLER_0_86_294 VGND VGND VPWR VPWR sky130_fd_sc_hd__decap_3
XFILLER_0_46_158 VGND VGND VPWR VPWR sky130_fd_sc_hd__fill_1
X_6613_ net254 _1808_ _3269_ VGND VGND VPWR VPWR _3276_ sky130_fd_sc_hd__mux2_1
X_7593_ clknet_leaf_20_clk _0642_ VGND VGND VPWR VPWR u_pe_array.u_fifo1.buffer\[2\]\[3\]
+ sky130_fd_sc_hd__dfxtp_1
XFILLER_0_62_629 VGND VGND VPWR VPWR sky130_fd_sc_hd__fill_1
XANTENNA__5020__A1 _0836_ VGND VGND VPWR VPWR sky130_fd_sc_hd__diode_2
X_3825_ _0864_ _1014_ _1015_ _0867_ net613 VGND VGND VPWR VPWR _0053_ sky130_fd_sc_hd__a32o_1
X_6544_ _3238_ VGND VGND VPWR VPWR _3239_ sky130_fd_sc_hd__clkbuf_8
XFILLER_0_6_266 VGND VGND VPWR VPWR sky130_fd_sc_hd__fill_2
XFILLER_0_27_383 VGND VGND VPWR VPWR sky130_fd_sc_hd__fill_2
X_3756_ _0959_ _0960_ _0965_ _0962_ _0956_ VGND VGND VPWR VPWR _0966_ sky130_fd_sc_hd__a32o_1
XFILLER_0_40_60 VGND VGND VPWR VPWR sky130_fd_sc_hd__fill_2
XANTENNA__3582__A1 _0819_ VGND VGND VPWR VPWR sky130_fd_sc_hd__diode_2
X_6475_ net304 _1810_ _3194_ VGND VGND VPWR VPWR _3202_ sky130_fd_sc_hd__mux2_1
XANTENNA__7194__RESET_B net815 VGND VGND VPWR VPWR sky130_fd_sc_hd__diode_2
XFILLER_0_71_3 VPWR VGND VPWR VGND sky130_ef_sc_hd__decap_12
X_5426_ _2342_ _2347_ VGND VGND VPWR VPWR _2351_ sky130_fd_sc_hd__and2_1
X_3687_ u_pe_array.g_pe_row\[3\].g_pe_col\[3\].u_pe.act_val\[3\] VGND VGND VPWR VPWR
+ _0903_ sky130_fd_sc_hd__inv_2
XFILLER_0_30_537 VGND VGND VPWR VPWR sky130_fd_sc_hd__fill_2
XANTENNA__7123__RESET_B net816 VGND VGND VPWR VPWR sky130_fd_sc_hd__diode_2
X_5357_ u_pe_array.u_fifo1.buffer\[3\]\[1\] _2282_ _2283_ u_pe_array.u_fifo1.buffer\[2\]\[1\]
+ _2295_ VGND VGND VPWR VPWR _2296_ sky130_fd_sc_hd__a221o_1
X_5288_ u_pe_array.g_pe_row\[1\].g_pe_col\[2\].u_pe.psum_out\[8\] _2158_ VGND VGND
+ VPWR VPWR _2235_ sky130_fd_sc_hd__nand2_1
X_4308_ u_pe_array.g_pe_row\[2\].g_pe_col\[3\].u_pe.w_reg\[0\] u_pe_array.g_pe_row\[2\].g_pe_col\[3\].u_pe.act_val\[2\]
+ VGND VGND VPWR VPWR _1414_ sky130_fd_sc_hd__nand2_1
X_4239_ u_pe_array.g_pe_row\[3\].g_pe_col\[0\].u_pe.psum_out\[7\] u_pe_array.g_pe_row\[3\].g_pe_col\[0\].u_pe.psum_out\[8\]
+ _1361_ _1275_ VGND VGND VPWR VPWR _1365_ sky130_fd_sc_hd__o211a_1
X_7027_ clknet_leaf_78_clk _0104_ net815 VGND VGND VPWR VPWR u_pe_array.g_pe_row\[2\].g_pe_col\[3\].u_pe.move_reg\[9\]
+ sky130_fd_sc_hd__dfrtp_1
XANTENNA__3637__A2 _0834_ VGND VGND VPWR VPWR sky130_fd_sc_hd__diode_2
XANTENNA__6814__S _3382_ VGND VGND VPWR VPWR sky130_fd_sc_hd__diode_2
XANTENNA__6587__A1 _1810_ VGND VGND VPWR VPWR sky130_fd_sc_hd__diode_2
XANTENNA__4598__B1 _1655_ VGND VGND VPWR VPWR sky130_fd_sc_hd__diode_2
XFILLER_0_65_423 VGND VGND VPWR VPWR sky130_fd_sc_hd__fill_1
XFILLER_0_38_637 VGND VGND VPWR VPWR sky130_fd_sc_hd__fill_2
XFILLER_0_92_220 VGND VGND VPWR VPWR sky130_fd_sc_hd__fill_2
XFILLER_0_77_294 VGND VGND VPWR VPWR sky130_fd_sc_hd__fill_2
XFILLER_0_65_445 VGND VGND VPWR VPWR sky130_fd_sc_hd__decap_3
XFILLER_0_37_169 VGND VGND VPWR VPWR sky130_fd_sc_hd__fill_2
XANTENNA__5011__A1 _0836_ VGND VGND VPWR VPWR sky130_fd_sc_hd__diode_2
XFILLER_0_108_569 VPWR VGND VPWR VGND sky130_ef_sc_hd__decap_12
XFILLER_0_52_139 VGND VGND VPWR VPWR sky130_fd_sc_hd__fill_1
XANTENNA__3474__A _0728_ VGND VGND VPWR VPWR sky130_fd_sc_hd__diode_2
XFILLER_0_60_172 VGND VGND VPWR VPWR sky130_fd_sc_hd__decap_3
XANTENNA__3876__A2 _0875_ VGND VGND VPWR VPWR sky130_fd_sc_hd__diode_2
XANTENNA__6275__B1 _0866_ VGND VGND VPWR VPWR sky130_fd_sc_hd__diode_2
XANTENNA__5078__A1 _1725_ VGND VGND VPWR VPWR sky130_fd_sc_hd__diode_2
XANTENNA__3628__A2 _0834_ VGND VGND VPWR VPWR sky130_fd_sc_hd__diode_2
XFILLER_0_88_537 VGND VGND VPWR VPWR sky130_fd_sc_hd__fill_2
XANTENNA__4589__B1 _1258_ VGND VGND VPWR VPWR sky130_fd_sc_hd__diode_2
XFILLER_0_68_250 VGND VGND VPWR VPWR sky130_fd_sc_hd__fill_2
XFILLER_0_61_15 VPWR VGND VPWR VGND sky130_ef_sc_hd__decap_12
XFILLER_0_0_29 VGND VGND VPWR VPWR sky130_fd_sc_hd__fill_2
XTAP_1460 VGND VPWR sky130_fd_sc_hd__tapvpwrvgnd_1
XANTENNA__5250__B2 _0916_ VGND VGND VPWR VPWR sky130_fd_sc_hd__diode_2
XFILLER_0_56_401 VGND VGND VPWR VPWR sky130_fd_sc_hd__fill_2
XFILLER_0_29_615 VGND VGND VPWR VPWR sky130_fd_sc_hd__fill_1
XFILLER_0_29_626 VGND VGND VPWR VPWR sky130_fd_sc_hd__fill_2
XTAP_1493 VGND VPWR sky130_fd_sc_hd__tapvpwrvgnd_1
XTAP_1482 VGND VPWR sky130_fd_sc_hd__tapvpwrvgnd_1
XTAP_1471 VGND VPWR sky130_fd_sc_hd__tapvpwrvgnd_1
XANTENNA__5002__A1 _0836_ VGND VGND VPWR VPWR sky130_fd_sc_hd__diode_2
XFILLER_0_16_309 VGND VGND VPWR VPWR sky130_fd_sc_hd__fill_2
X_4590_ u_pe_array.g_pe_row\[2\].g_pe_col\[1\].u_pe.act_val\[2\] u_pe_array.g_pe_row\[2\].g_pe_col\[1\].u_pe.psum_out\[2\]
+ _0770_ VGND VGND VPWR VPWR _1653_ sky130_fd_sc_hd__mux2_1
X_3610_ net664 _0834_ _0837_ _0841_ VGND VGND VPWR VPWR _0012_ sky130_fd_sc_hd__a22o_1
X_3541_ _0724_ _0787_ VGND VGND VPWR VPWR _0788_ sky130_fd_sc_hd__or2_2
XFILLER_0_3_225 VGND VGND VPWR VPWR sky130_fd_sc_hd__decap_4
XFILLER_0_3_236 VGND VGND VPWR VPWR sky130_fd_sc_hd__fill_2
XFILLER_0_101_76 VGND VGND VPWR VPWR sky130_fd_sc_hd__fill_1
XFILLER_0_3_247 VGND VGND VPWR VPWR sky130_fd_sc_hd__fill_2
XFILLER_0_12_537 VGND VGND VPWR VPWR sky130_fd_sc_hd__decap_6
X_6260_ _3047_ _3048_ _3050_ VGND VGND VPWR VPWR _3052_ sky130_fd_sc_hd__a21oi_1
X_3472_ _0742_ VGND VGND VPWR VPWR net56 sky130_fd_sc_hd__dlymetal6s2s_1
XANTENNA__6502__A1 _1810_ VGND VGND VPWR VPWR sky130_fd_sc_hd__diode_2
XFILLER_0_10_85 VGND VGND VPWR VPWR sky130_fd_sc_hd__decap_3
X_5211_ _2155_ _2160_ VGND VGND VPWR VPWR _2164_ sky130_fd_sc_hd__and2_1
X_6191_ _0785_ _0795_ _2989_ _0719_ net396 VGND VGND VPWR VPWR _0445_ sky130_fd_sc_hd__a32o_1
X_5142_ _2108_ _2110_ _2115_ VGND VGND VPWR VPWR _2116_ sky130_fd_sc_hd__o21ai_1
X_5073_ _2047_ _2048_ _2052_ VGND VGND VPWR VPWR _2053_ sky130_fd_sc_hd__nor3_1
XANTENNA__3619__A2 _0834_ VGND VGND VPWR VPWR sky130_fd_sc_hd__diode_2
XANTENNA__4816__A1 net6 VGND VGND VPWR VPWR sky130_fd_sc_hd__diode_2
X_4024_ _1159_ _1160_ _1171_ _1162_ VGND VGND VPWR VPWR _1184_ sky130_fd_sc_hd__o211a_1
XANTENNA__6018__B1 _2174_ VGND VGND VPWR VPWR sky130_fd_sc_hd__diode_2
XANTENNA__6569__A1 _1820_ VGND VGND VPWR VPWR sky130_fd_sc_hd__diode_2
XANTENNA__4292__A2 _1392_ VGND VGND VPWR VPWR sky130_fd_sc_hd__diode_2
XFILLER_0_35_93 VGND VGND VPWR VPWR sky130_fd_sc_hd__fill_2
X_5975_ u_pe_array.g_pe_row\[0\].g_pe_col\[2\].u_pe.psum_out\[7\] _2743_ VGND VGND
+ VPWR VPWR _2811_ sky130_fd_sc_hd__or2_1
X_4926_ _1919_ _1922_ _1927_ VGND VGND VPWR VPWR _1929_ sky130_fd_sc_hd__and3_1
XFILLER_0_19_125 VGND VGND VPWR VPWR sky130_fd_sc_hd__fill_2
XANTENNA__7375__RESET_B net75 VGND VGND VPWR VPWR sky130_fd_sc_hd__diode_2
X_4857_ u_pe_array.g_pe_row\[2\].g_pe_col\[0\].u_pe.act_val\[2\] VGND VGND VPWR VPWR
+ _1865_ sky130_fd_sc_hd__inv_2
X_7645_ clknet_leaf_19_clk _0694_ VGND VGND VPWR VPWR u_pe_array.u_fifo1.buffer\[6\]\[3\]
+ sky130_fd_sc_hd__dfxtp_1
XFILLER_0_74_264 VGND VGND VPWR VPWR sky130_fd_sc_hd__decap_8
XFILLER_0_19_169 VGND VGND VPWR VPWR sky130_fd_sc_hd__fill_1
XFILLER_0_28_670 VGND VGND VPWR VPWR sky130_fd_sc_hd__fill_2
XFILLER_0_35_629 VGND VGND VPWR VPWR sky130_fd_sc_hd__fill_1
X_7576_ clknet_leaf_27_clk _0625_ VGND VGND VPWR VPWR u_pe_array.u_fifo1.buffer\[0\]\[12\]
+ sky130_fd_sc_hd__dfxtp_1
XFILLER_0_74_286 VGND VGND VPWR VPWR sky130_fd_sc_hd__decap_6
XFILLER_0_7_553 VGND VGND VPWR VPWR sky130_fd_sc_hd__decap_6
X_3808_ u_pe_array.g_pe_row\[3\].g_pe_col\[2\].u_pe.psum_out\[10\] u_pe_array.g_pe_row\[3\].g_pe_col\[2\].u_pe.move_reg\[10\]
+ _0734_ VGND VGND VPWR VPWR _1003_ sky130_fd_sc_hd__mux2_1
XANTENNA__7304__RESET_B net814 VGND VGND VPWR VPWR sky130_fd_sc_hd__diode_2
XANTENNA__6741__A1 _3130_ VGND VGND VPWR VPWR sky130_fd_sc_hd__diode_2
XANTENNA__5544__A2 _2387_ VGND VGND VPWR VPWR sky130_fd_sc_hd__diode_2
XFILLER_0_7_597 VPWR VGND VPWR VGND sky130_ef_sc_hd__decap_12
X_4788_ _1816_ net367 _1796_ VGND VGND VPWR VPWR _1817_ sky130_fd_sc_hd__mux2_1
X_6527_ net498 _1806_ _3224_ VGND VGND VPWR VPWR _3230_ sky130_fd_sc_hd__mux2_1
XFILLER_0_43_673 VGND VGND VPWR VPWR sky130_fd_sc_hd__fill_2
XFILLER_0_15_375 VGND VGND VPWR VPWR sky130_fd_sc_hd__fill_1
X_3739_ u_pe_array.g_pe_row\[3\].g_pe_col\[3\].u_pe.psum_out\[8\] _0869_ VGND VGND
+ VPWR VPWR _0951_ sky130_fd_sc_hd__nand2_1
XFILLER_0_113_561 VPWR VGND VPWR VGND sky130_ef_sc_hd__decap_12
X_6458_ net263 _1820_ net69 VGND VGND VPWR VPWR _3193_ sky130_fd_sc_hd__mux2_1
X_5409_ net191 _2144_ _2338_ _2336_ VGND VGND VPWR VPWR _0314_ sky130_fd_sc_hd__a22o_1
X_6389_ _0819_ _1790_ VGND VGND VPWR VPWR _3153_ sky130_fd_sc_hd__nor2_1
XANTENNA__5713__S _0770_ VGND VGND VPWR VPWR sky130_fd_sc_hd__diode_2
XFILLER_0_100_299 VGND VGND VPWR VPWR sky130_fd_sc_hd__fill_2
XANTENNA__4807__A1 net3 VGND VGND VPWR VPWR sky130_fd_sc_hd__diode_2
XANTENNA__4283__A2 _1392_ VGND VGND VPWR VPWR sky130_fd_sc_hd__diode_2
XFILLER_0_108_300 VGND VGND VPWR VPWR sky130_fd_sc_hd__fill_1
XFILLER_0_93_573 VGND VGND VPWR VPWR sky130_fd_sc_hd__fill_1
XFILLER_0_80_201 VGND VGND VPWR VPWR sky130_fd_sc_hd__fill_2
XFILLER_0_65_275 VGND VGND VPWR VPWR sky130_fd_sc_hd__fill_2
XANTENNA__7045__RESET_B net76 VGND VGND VPWR VPWR sky130_fd_sc_hd__diode_2
XFILLER_0_53_426 VGND VGND VPWR VPWR sky130_fd_sc_hd__fill_2
XANTENNA__4743__B1 _1672_ VGND VGND VPWR VPWR sky130_fd_sc_hd__diode_2
XTAP_507 VGND VPWR sky130_fd_sc_hd__tapvpwrvgnd_1
XTAP_518 VGND VPWR sky130_fd_sc_hd__tapvpwrvgnd_1
XTAP_529 VGND VPWR sky130_fd_sc_hd__tapvpwrvgnd_1
XFILLER_0_56_15 VPWR VGND VPWR VGND sky130_ef_sc_hd__decap_12
XANTENNA__3651__B _0869_ VGND VGND VPWR VPWR sky130_fd_sc_hd__diode_2
XANTENNA__6799__A1 _3134_ VGND VGND VPWR VPWR sky130_fd_sc_hd__diode_2
XFILLER_0_88_301 VGND VGND VPWR VPWR sky130_fd_sc_hd__fill_2
XFILLER_0_76_529 VGND VGND VPWR VPWR sky130_fd_sc_hd__decap_3
XFILLER_0_29_401 VGND VGND VPWR VPWR sky130_fd_sc_hd__fill_2
XFILLER_0_8_328 VGND VGND VPWR VPWR sky130_fd_sc_hd__decap_8
X_5760_ _2618_ _2624_ _2627_ VGND VGND VPWR VPWR _2628_ sky130_fd_sc_hd__a21o_1
XTAP_1290 VGND VPWR sky130_fd_sc_hd__tapvpwrvgnd_1
X_5691_ _2258_ _2578_ _2579_ _2571_ net578 VGND VGND VPWR VPWR _0355_ sky130_fd_sc_hd__a32o_1
XANTENNA__3785__A1 _0988_ VGND VGND VPWR VPWR sky130_fd_sc_hd__diode_2
X_4711_ _1746_ _1749_ _1754_ VGND VGND VPWR VPWR _1755_ sky130_fd_sc_hd__and3_1
XFILLER_0_44_415 VGND VGND VPWR VPWR sky130_fd_sc_hd__fill_2
XFILLER_0_112_53 VPWR VGND VPWR VGND sky130_ef_sc_hd__decap_12
X_4642_ _1672_ _1690_ u_pe_array.g_pe_row\[2\].g_pe_col\[1\].u_pe.act_val\[3\] u_pe_array.g_pe_row\[2\].g_pe_col\[1\].u_pe.w_reg\[0\]
+ VGND VGND VPWR VPWR _1691_ sky130_fd_sc_hd__a22o_1
X_7430_ clknet_leaf_9_clk _0479_ net74 VGND VGND VPWR VPWR u_pe_array.u_fifo2.rd_ptr\[3\]
+ sky130_fd_sc_hd__dfrtp_1
XFILLER_0_4_501 VPWR VGND VPWR VGND sky130_ef_sc_hd__decap_12
XFILLER_0_71_256 VPWR VGND VPWR VGND sky130_ef_sc_hd__decap_12
X_7361_ clknet_leaf_44_clk _0416_ net75 VGND VGND VPWR VPWR u_pe_array.g_pe_row\[0\].g_pe_col\[0\].u_pe.act_val\[0\]
+ sky130_fd_sc_hd__dfrtp_4
XFILLER_0_71_278 VGND VGND VPWR VPWR sky130_fd_sc_hd__fill_2
XANTENNA__4734__B1 _0861_ VGND VGND VPWR VPWR sky130_fd_sc_hd__diode_2
Xhold703 u_pe_array.g_pe_row\[3\].g_pe_col\[1\].u_pe.psum_out\[10\] VGND VGND VPWR
+ VPWR net779 sky130_fd_sc_hd__dlygate4sd3_1
XFILLER_0_4_545 VPWR VGND VPWR VGND sky130_ef_sc_hd__decap_12
XFILLER_0_25_673 VGND VGND VPWR VPWR sky130_fd_sc_hd__fill_2
X_4573_ u_pe_array.g_pe_row\[2\].g_pe_col\[2\].u_pe.psum_out\[10\] _1638_ _1641_ VGND
+ VGND VPWR VPWR _1642_ sky130_fd_sc_hd__a21oi_1
X_6312_ net767 _0867_ _2174_ _3098_ VGND VGND VPWR VPWR _0457_ sky130_fd_sc_hd__a22o_1
Xhold714 u_pe_array.g_pe_row\[0\].g_pe_col\[1\].u_pe.act_val\[5\] VGND VGND VPWR VPWR
+ net790 sky130_fd_sc_hd__dlygate4sd3_1
X_3524_ u_pe_array.g_pe_row\[1\].g_pe_col\[0\].u_pe.psum_out\[10\] _0769_ _0775_ _0754_
+ VGND VGND VPWR VPWR net37 sky130_fd_sc_hd__o211a_1
X_7292_ clknet_leaf_57_clk _0351_ net75 VGND VGND VPWR VPWR u_pe_array.g_pe_row\[1\].g_pe_col\[0\].u_pe.psum_out\[6\]
+ sky130_fd_sc_hd__dfrtp_1
Xhold736 u_pe_array.g_pe_row\[3\].g_pe_col\[2\].u_pe.act_val\[3\] VGND VGND VPWR VPWR
+ net820 sky130_fd_sc_hd__dlygate4sd3_1
XFILLER_0_12_345 VGND VGND VPWR VPWR sky130_fd_sc_hd__fill_2
Xhold725 _1388_ VGND VGND VPWR VPWR net801 sky130_fd_sc_hd__dlygate4sd3_1
XFILLER_0_4_589 VPWR VGND VPWR VGND sky130_ef_sc_hd__decap_12
XFILLER_0_40_643 VGND VGND VPWR VPWR sky130_fd_sc_hd__fill_1
XFILLER_0_110_531 VGND VGND VPWR VPWR sky130_fd_sc_hd__fill_1
X_6243_ u_pe_array.g_pe_row\[0\].g_pe_col\[0\].u_pe.act_val\[5\] u_pe_array.g_pe_row\[0\].g_pe_col\[0\].u_pe.w_reg\[0\]
+ VGND VGND VPWR VPWR _3036_ sky130_fd_sc_hd__nand2_1
X_3455_ _0729_ _0720_ VGND VGND VPWR VPWR _0730_ sky130_fd_sc_hd__nor2_8
Xhold747 u_pe_array.g_pe_row\[1\].g_pe_col\[3\].u_pe.psum_out\[10\] VGND VGND VPWR
+ VPWR net831 sky130_fd_sc_hd__dlygate4sd3_1
XANTENNA__6629__S _0747_ VGND VGND VPWR VPWR sky130_fd_sc_hd__diode_2
XFILLER_0_40_676 VGND VGND VPWR VPWR sky130_fd_sc_hd__fill_1
X_6174_ _2977_ _2967_ VGND VGND VPWR VPWR _2978_ sky130_fd_sc_hd__and2b_1
XANTENNA__4657__B _1672_ VGND VGND VPWR VPWR sky130_fd_sc_hd__diode_2
X_5125_ _2053_ _2066_ _2067_ _2099_ VGND VGND VPWR VPWR _2100_ sky130_fd_sc_hd__or4_1
X_5056_ u_pe_array.g_pe_row\[1\].g_pe_col\[3\].u_pe.act_val\[1\] _2029_ VGND VGND
+ VPWR VPWR _2037_ sky130_fd_sc_hd__or2b_1
XFILLER_0_79_334 VGND VGND VPWR VPWR sky130_fd_sc_hd__fill_2
X_4007_ u_pe_array.g_pe_row\[3\].g_pe_col\[1\].u_pe.psum_out\[3\] _1167_ VGND VGND
+ VPWR VPWR _1168_ sky130_fd_sc_hd__xnor2_1
XFILLER_0_46_81 VGND VGND VPWR VPWR sky130_fd_sc_hd__decap_3
XFILLER_0_79_389 VGND VGND VPWR VPWR sky130_fd_sc_hd__decap_3
XANTENNA__7556__RESET_B net816 VGND VGND VPWR VPWR sky130_fd_sc_hd__diode_2
XFILLER_0_94_337 VGND VGND VPWR VPWR sky130_fd_sc_hd__fill_2
X_5958_ _2793_ _2794_ _0885_ VGND VGND VPWR VPWR _2796_ sky130_fd_sc_hd__o21a_1
X_4909_ u_pe_array.g_pe_row\[2\].g_pe_col\[0\].u_pe.psum_out\[7\] _1847_ VGND VGND
+ VPWR VPWR _1913_ sky130_fd_sc_hd__or2_1
XFILLER_0_35_415 VGND VGND VPWR VPWR sky130_fd_sc_hd__fill_2
X_5889_ net365 _2600_ _2735_ _0722_ VGND VGND VPWR VPWR _0397_ sky130_fd_sc_hd__a22o_1
X_7628_ clknet_leaf_30_clk _0677_ VGND VGND VPWR VPWR u_pe_array.u_fifo1.buffer\[4\]\[12\]
+ sky130_fd_sc_hd__dfxtp_1
XANTENNA__6714__A1 _3130_ VGND VGND VPWR VPWR sky130_fd_sc_hd__diode_2
XFILLER_0_7_383 VGND VGND VPWR VPWR sky130_fd_sc_hd__decap_8
XFILLER_0_35_459 VGND VGND VPWR VPWR sky130_fd_sc_hd__fill_1
X_7559_ clknet_leaf_19_clk _0608_ net816 VGND VGND VPWR VPWR u_pe_array.u_fifo1.rd_ptr\[3\]
+ sky130_fd_sc_hd__dfrtp_1
XFILLER_0_50_429 VGND VGND VPWR VPWR sky130_fd_sc_hd__fill_2
XFILLER_0_50_418 VGND VGND VPWR VPWR sky130_fd_sc_hd__fill_2
XFILLER_0_15_183 VGND VGND VPWR VPWR sky130_fd_sc_hd__fill_2
XFILLER_0_30_120 VPWR VGND VPWR VGND sky130_ef_sc_hd__decap_12
XFILLER_0_113_391 VGND VGND VPWR VPWR sky130_fd_sc_hd__fill_1
XANTENNA__6539__S _3224_ VGND VGND VPWR VPWR sky130_fd_sc_hd__diode_2
XFILLER_0_30_153 VGND VGND VPWR VPWR sky130_fd_sc_hd__fill_2
XANTENNA__3471__B _0741_ VGND VGND VPWR VPWR sky130_fd_sc_hd__diode_2
Xhold41 u_pe_array.g_pe_row\[3\].g_pe_col\[0\].u_pe.move_reg\[8\] VGND VGND VPWR VPWR
+ net117 sky130_fd_sc_hd__dlygate4sd3_1
Xhold30 u_pe_array.g_pe_row\[1\].g_pe_col\[1\].u_pe.w_buffer\[1\] VGND VGND VPWR VPWR
+ net106 sky130_fd_sc_hd__dlygate4sd3_1
Xhold74 u_pe_array.g_pe_row\[2\].g_pe_col\[2\].u_pe.move_reg\[6\] VGND VGND VPWR VPWR
+ net150 sky130_fd_sc_hd__dlygate4sd3_1
XFILLER_0_26_29 VGND VGND VPWR VPWR sky130_fd_sc_hd__fill_2
Xhold63 u_pe_array.g_pe_row\[0\].g_pe_col\[3\].u_pe.move_reg\[7\] VGND VGND VPWR VPWR
+ net139 sky130_fd_sc_hd__dlygate4sd3_1
Xhold52 u_pe_array.g_pe_row\[3\].g_pe_col\[2\].u_pe.move_reg\[6\] VGND VGND VPWR VPWR
+ net128 sky130_fd_sc_hd__dlygate4sd3_1
Xhold85 u_pe_array.g_pe_row\[3\].g_pe_col\[0\].u_pe.move_reg\[7\] VGND VGND VPWR VPWR
+ net161 sky130_fd_sc_hd__dlygate4sd3_1
XANTENNA_input18_A v_in0[3] VGND VGND VPWR VPWR sky130_fd_sc_hd__diode_2
Xhold96 u_pe_array.g_pe_row\[2\].g_pe_col\[3\].u_pe.move_reg\[6\] VGND VGND VPWR VPWR
+ net172 sky130_fd_sc_hd__dlygate4sd3_1
XFILLER_0_98_665 VPWR VGND VPWR VGND sky130_ef_sc_hd__decap_12
XANTENNA__7297__RESET_B net75 VGND VGND VPWR VPWR sky130_fd_sc_hd__diode_2
XFILLER_0_97_197 VGND VGND VPWR VPWR sky130_fd_sc_hd__decap_4
XFILLER_0_85_337 VGND VGND VPWR VPWR sky130_fd_sc_hd__fill_1
XANTENNA__7226__RESET_B net73 VGND VGND VPWR VPWR sky130_fd_sc_hd__diode_2
XFILLER_0_38_253 VGND VGND VPWR VPWR sky130_fd_sc_hd__fill_1
XFILLER_0_109_653 VPWR VGND VPWR VGND sky130_ef_sc_hd__decap_12
XFILLER_0_66_584 VGND VGND VPWR VPWR sky130_fd_sc_hd__fill_2
XFILLER_0_108_163 VGND VGND VPWR VPWR sky130_fd_sc_hd__decap_4
XFILLER_0_53_245 VGND VGND VPWR VPWR sky130_fd_sc_hd__decap_3
XFILLER_0_111_317 VPWR VGND VPWR VGND sky130_ef_sc_hd__decap_12
XFILLER_0_1_548 VPWR VGND VPWR VGND sky130_ef_sc_hd__decap_12
XFILLER_0_21_164 VGND VGND VPWR VPWR sky130_fd_sc_hd__fill_2
XTAP_315 VGND VPWR sky130_fd_sc_hd__tapvpwrvgnd_1
XTAP_304 VGND VPWR sky130_fd_sc_hd__tapvpwrvgnd_1
XTAP_348 VGND VPWR sky130_fd_sc_hd__tapvpwrvgnd_1
XTAP_337 VGND VPWR sky130_fd_sc_hd__tapvpwrvgnd_1
XTAP_326 VGND VPWR sky130_fd_sc_hd__tapvpwrvgnd_1
XTAP_359 VGND VPWR sky130_fd_sc_hd__tapvpwrvgnd_1
XANTENNA__6184__S _0827_ VGND VGND VPWR VPWR sky130_fd_sc_hd__diode_2
XFILLER_0_89_621 VGND VGND VPWR VPWR sky130_fd_sc_hd__fill_2
XFILLER_0_89_665 VGND VGND VPWR VPWR sky130_fd_sc_hd__fill_2
X_6930_ clknet_leaf_92_clk _0013_ net819 VGND VGND VPWR VPWR u_pe_array.g_pe_row\[3\].g_pe_col\[2\].u_pe.act_val\[2\]
+ sky130_fd_sc_hd__dfrtp_2
X_6861_ _3413_ VGND VGND VPWR VPWR _0691_ sky130_fd_sc_hd__clkbuf_1
XANTENNA__6912__S _3427_ VGND VGND VPWR VPWR sky130_fd_sc_hd__diode_2
X_6792_ _3375_ VGND VGND VPWR VPWR _0660_ sky130_fd_sc_hd__clkbuf_1
XANTENNA__4643__D _1672_ VGND VGND VPWR VPWR sky130_fd_sc_hd__diode_2
XFILLER_0_9_615 VGND VGND VPWR VPWR sky130_fd_sc_hd__fill_1
X_5812_ _2258_ _2674_ _2676_ _2571_ net360 VGND VGND VPWR VPWR _0379_ sky130_fd_sc_hd__a32o_1
X_5743_ _2610_ _2612_ VGND VGND VPWR VPWR _2613_ sky130_fd_sc_hd__xor2_1
XFILLER_0_8_169 VGND VGND VPWR VPWR sky130_fd_sc_hd__decap_4
XFILLER_0_29_275 VGND VGND VPWR VPWR sky130_fd_sc_hd__fill_2
XFILLER_0_32_72 VGND VGND VPWR VPWR sky130_fd_sc_hd__decap_3
X_5674_ _2563_ _2564_ net691 _0875_ VGND VGND VPWR VPWR _0353_ sky130_fd_sc_hd__a2bb2o_1
XANTENNA__4432__S _0769_ VGND VGND VPWR VPWR sky130_fd_sc_hd__diode_2
XANTENNA__6949__RESET_B net815 VGND VGND VPWR VPWR sky130_fd_sc_hd__diode_2
XFILLER_0_114_111 VGND VGND VPWR VPWR sky130_fd_sc_hd__fill_1
X_4625_ u_pe_array.g_pe_row\[2\].g_pe_col\[1\].u_pe.psum_out\[1\] _1675_ VGND VGND
+ VPWR VPWR _1676_ sky130_fd_sc_hd__or2_1
X_7413_ clknet_leaf_16_clk _0462_ VGND VGND VPWR VPWR u_pe_array.u_fifo1.buffer\[8\]\[3\]
+ sky130_fd_sc_hd__dfxtp_1
XFILLER_0_44_267 VGND VGND VPWR VPWR sky130_fd_sc_hd__fill_2
XFILLER_0_32_418 VGND VGND VPWR VPWR sky130_fd_sc_hd__fill_2
XFILLER_0_114_177 VGND VGND VPWR VPWR sky130_fd_sc_hd__fill_1
XANTENNA__5380__B1 _0833_ VGND VGND VPWR VPWR sky130_fd_sc_hd__diode_2
Xhold511 u_pe_array.g_pe_row\[2\].g_pe_col\[3\].u_pe.psum_out\[2\] VGND VGND VPWR
+ VPWR net587 sky130_fd_sc_hd__dlygate4sd3_1
XFILLER_0_25_492 VGND VGND VPWR VPWR sky130_fd_sc_hd__fill_2
X_4556_ u_pe_array.g_pe_row\[2\].g_pe_col\[2\].u_pe.psum_out\[7\] u_pe_array.g_pe_row\[2\].g_pe_col\[2\].u_pe.psum_out\[8\]
+ _1622_ _1536_ VGND VGND VPWR VPWR _1626_ sky130_fd_sc_hd__o211a_1
X_7344_ clknet_leaf_80_clk net94 net13 VGND VGND VPWR VPWR u_pe_array.g_pe_row\[0\].g_pe_col\[2\].u_pe.w_reg\[0\]
+ sky130_fd_sc_hd__dfrtp_4
Xhold500 u_pe_array.g_pe_row\[1\].g_pe_col\[3\].u_pe.move_reg\[6\] VGND VGND VPWR
+ VPWR net576 sky130_fd_sc_hd__dlygate4sd3_1
X_3507_ u_pe_array.g_pe_row\[1\].g_pe_col\[0\].u_pe.act_val\[4\] u_pe_array.g_pe_row\[1\].g_pe_col\[0\].u_pe.psum_out\[4\]
+ _0756_ VGND VGND VPWR VPWR _0765_ sky130_fd_sc_hd__mux2_1
Xhold544 u_pe_array.g_pe_row\[2\].g_pe_col\[0\].u_pe.move_reg\[8\] VGND VGND VPWR
+ VPWR net620 sky130_fd_sc_hd__dlygate4sd3_1
Xhold533 u_pe_array.g_pe_row\[2\].g_pe_col\[1\].u_pe.act_val\[4\] VGND VGND VPWR VPWR
+ net609 sky130_fd_sc_hd__dlygate4sd3_1
Xhold522 u_fsm.v_cnt\[1\] VGND VGND VPWR VPWR net598 sky130_fd_sc_hd__dlygate4sd3_1
XANTENNA__6359__S _3110_ VGND VGND VPWR VPWR sky130_fd_sc_hd__diode_2
Xhold555 u_pe_array.g_pe_row\[2\].g_pe_col\[0\].u_pe.move_reg\[6\] VGND VGND VPWR
+ VPWR net631 sky130_fd_sc_hd__dlygate4sd3_1
XFILLER_0_12_197 VGND VGND VPWR VPWR sky130_fd_sc_hd__decap_4
XFILLER_0_12_186 VGND VGND VPWR VPWR sky130_fd_sc_hd__fill_2
X_4487_ _1562_ _1563_ VGND VGND VPWR VPWR _1564_ sky130_fd_sc_hd__and2b_1
Xhold577 u_pe_array.g_pe_row\[2\].g_pe_col\[3\].u_pe.act_val\[5\] VGND VGND VPWR VPWR
+ net653 sky130_fd_sc_hd__dlygate4sd3_1
Xhold588 u_pe_array.g_pe_row\[3\].g_pe_col\[2\].u_pe.act_val\[1\] VGND VGND VPWR VPWR
+ net664 sky130_fd_sc_hd__dlygate4sd3_1
Xhold566 u_pe_array.g_pe_row\[3\].g_pe_col\[3\].u_pe.psum_out\[7\] VGND VGND VPWR
+ VPWR net642 sky130_fd_sc_hd__dlygate4sd3_1
X_7275_ clknet_leaf_69_clk _0336_ net814 VGND VGND VPWR VPWR u_pe_array.g_pe_row\[0\].g_pe_col\[3\].u_pe.act_val\[4\]
+ sky130_fd_sc_hd__dfrtp_1
X_6226_ _3009_ _3018_ _3020_ VGND VGND VPWR VPWR _3021_ sky130_fd_sc_hd__or3_1
Xhold599 u_pe_array.g_pe_row\[1\].g_pe_col\[3\].u_pe.psum_out\[9\] VGND VGND VPWR
+ VPWR net675 sky130_fd_sc_hd__dlygate4sd3_1
X_6157_ _2740_ _2961_ _2962_ _2571_ net746 VGND VGND VPWR VPWR _0438_ sky130_fd_sc_hd__a32o_1
XTAP_871 VGND VPWR sky130_fd_sc_hd__tapvpwrvgnd_1
XTAP_860 VGND VPWR sky130_fd_sc_hd__tapvpwrvgnd_1
XFILLER_0_57_91 VGND VGND VPWR VPWR sky130_fd_sc_hd__fill_1
XTAP_893 VGND VPWR sky130_fd_sc_hd__tapvpwrvgnd_1
XTAP_882 VGND VPWR sky130_fd_sc_hd__tapvpwrvgnd_1
X_5108_ _2029_ _2084_ u_pe_array.g_pe_row\[1\].g_pe_col\[3\].u_pe.psum_out\[6\] VGND
+ VGND VPWR VPWR _2085_ sky130_fd_sc_hd__nand3_2
X_6088_ _2896_ _2898_ VGND VGND VPWR VPWR _2900_ sky130_fd_sc_hd__nand2_1
XFILLER_0_99_429 VGND VGND VPWR VPWR sky130_fd_sc_hd__fill_2
XANTENNA__6632__B1 _0836_ VGND VGND VPWR VPWR sky130_fd_sc_hd__diode_2
X_5039_ net158 _1666_ _2024_ _1665_ VGND VGND VPWR VPWR _0258_ sky130_fd_sc_hd__a22o_1
XANTENNA__7390__RESET_B net817 VGND VGND VPWR VPWR sky130_fd_sc_hd__diode_2
XFILLER_0_95_613 VGND VGND VPWR VPWR sky130_fd_sc_hd__decap_3
XANTENNA__6822__S _3382_ VGND VGND VPWR VPWR sky130_fd_sc_hd__diode_2
XFILLER_0_79_186 VGND VGND VPWR VPWR sky130_fd_sc_hd__fill_1
XFILLER_0_82_318 VGND VGND VPWR VPWR sky130_fd_sc_hd__fill_2
XFILLER_0_35_212 VGND VGND VPWR VPWR sky130_fd_sc_hd__fill_1
XFILLER_0_106_601 VPWR VGND VPWR VGND sky130_ef_sc_hd__decap_12
XFILLER_0_106_645 VPWR VGND VPWR VGND sky130_ef_sc_hd__decap_12
XFILLER_0_23_418 VGND VGND VPWR VPWR sky130_fd_sc_hd__fill_2
XANTENNA__5371__B1 _0833_ VGND VGND VPWR VPWR sky130_fd_sc_hd__diode_2
XFILLER_0_50_248 VGND VGND VPWR VPWR sky130_fd_sc_hd__fill_2
XFILLER_0_50_226 VGND VGND VPWR VPWR sky130_fd_sc_hd__decap_3
XFILLER_0_16_481 VGND VGND VPWR VPWR sky130_fd_sc_hd__fill_2
XFILLER_0_105_199 VGND VGND VPWR VPWR sky130_fd_sc_hd__decap_3
XFILLER_0_105_188 VGND VGND VPWR VPWR sky130_fd_sc_hd__decap_3
Xoutput42 net42 VGND VGND VPWR VPWR psum_out0[3] sky130_fd_sc_hd__clkbuf_4
XFILLER_0_31_484 VGND VGND VPWR VPWR sky130_fd_sc_hd__fill_1
XFILLER_0_101_383 VGND VGND VPWR VPWR sky130_fd_sc_hd__fill_2
XFILLER_0_101_372 VGND VGND VPWR VPWR sky130_fd_sc_hd__decap_4
Xoutput53 net53 VGND VGND VPWR VPWR psum_out1[1] sky130_fd_sc_hd__clkbuf_4
XANTENNA__5123__B1 _2071_ VGND VGND VPWR VPWR sky130_fd_sc_hd__diode_2
XANTENNA__5674__B2 _0875_ VGND VGND VPWR VPWR sky130_fd_sc_hd__diode_2
XFILLER_0_37_17 VGND VGND VPWR VPWR sky130_fd_sc_hd__fill_1
XANTENNA__3685__B1 _0887_ VGND VGND VPWR VPWR sky130_fd_sc_hd__diode_2
XANTENNA__7407__RESET_B net817 VGND VGND VPWR VPWR sky130_fd_sc_hd__diode_2
XFILLER_0_53_27 VGND VGND VPWR VPWR sky130_fd_sc_hd__decap_8
XFILLER_0_86_613 VGND VGND VPWR VPWR sky130_fd_sc_hd__fill_2
XANTENNA__7060__RESET_B net74 VGND VGND VPWR VPWR sky130_fd_sc_hd__diode_2
XANTENNA__5729__A2 _2600_ VGND VGND VPWR VPWR sky130_fd_sc_hd__diode_2
XANTENNA__3657__A _0866_ VGND VGND VPWR VPWR sky130_fd_sc_hd__diode_2
XPHY_170 VGND VGND VPWR VPWR sky130_fd_sc_hd__decap_3
XPHY_192 VGND VGND VPWR VPWR sky130_fd_sc_hd__decap_3
XPHY_181 VGND VGND VPWR VPWR sky130_fd_sc_hd__decap_3
XANTENNA__5362__B1 _0833_ VGND VGND VPWR VPWR sky130_fd_sc_hd__diode_2
X_4410_ _1506_ _1497_ VGND VGND VPWR VPWR _1507_ sky130_fd_sc_hd__and2b_1
XFILLER_0_41_248 VGND VGND VPWR VPWR sky130_fd_sc_hd__decap_3
XFILLER_0_112_637 VGND VGND VPWR VPWR sky130_fd_sc_hd__decap_6
X_5390_ u_pe_array.u_fifo1.buffer\[0\]\[5\] _2275_ VGND VGND VPWR VPWR _2325_ sky130_fd_sc_hd__or2_1
XFILLER_0_78_46 VGND VGND VPWR VPWR sky130_fd_sc_hd__fill_2
XFILLER_0_10_624 VPWR VGND VPWR VGND sky130_ef_sc_hd__decap_12
X_4341_ _1420_ _1421_ _1432_ _1423_ VGND VGND VPWR VPWR _1445_ sky130_fd_sc_hd__o211a_1
XANTENNA__3912__B2 _0916_ VGND VGND VPWR VPWR sky130_fd_sc_hd__diode_2
XFILLER_0_10_657 VPWR VGND VPWR VGND sky130_ef_sc_hd__decap_12
X_4272_ net728 _1138_ _1258_ _1391_ VGND VGND VPWR VPWR _0124_ sky130_fd_sc_hd__a22o_1
X_7060_ clknet_leaf_85_clk _0135_ net74 VGND VGND VPWR VPWR u_pe_array.g_pe_row\[2\].g_pe_col\[2\].u_pe.move_reg\[12\]
+ sky130_fd_sc_hd__dfrtp_1
X_6011_ _2740_ _2842_ _2843_ _2571_ net718 VGND VGND VPWR VPWR _0411_ sky130_fd_sc_hd__a32o_1
XFILLER_0_94_78 VGND VGND VPWR VPWR sky130_fd_sc_hd__decap_3
XFILLER_0_94_67 VGND VGND VPWR VPWR sky130_fd_sc_hd__fill_2
XANTENNA__5417__A1 _2258_ VGND VGND VPWR VPWR sky130_fd_sc_hd__diode_2
XFILLER_0_89_440 VGND VGND VPWR VPWR sky130_fd_sc_hd__fill_2
X_6913_ _3440_ VGND VGND VPWR VPWR _0716_ sky130_fd_sc_hd__clkbuf_1
XFILLER_0_89_495 VGND VGND VPWR VPWR sky130_fd_sc_hd__decap_4
XFILLER_0_49_337 VGND VGND VPWR VPWR sky130_fd_sc_hd__fill_2
X_6844_ net255 _3122_ _3397_ VGND VGND VPWR VPWR _3404_ sky130_fd_sc_hd__mux2_1
XFILLER_0_9_412 VGND VGND VPWR VPWR sky130_fd_sc_hd__fill_2
XFILLER_0_92_649 VGND VGND VPWR VPWR sky130_fd_sc_hd__fill_2
XANTENNA__4928__B1 _0861_ VGND VGND VPWR VPWR sky130_fd_sc_hd__diode_2
X_6775_ net531 _3103_ _3366_ VGND VGND VPWR VPWR _3367_ sky130_fd_sc_hd__mux2_1
X_3987_ u_pe_array.g_pe_row\[3\].g_pe_col\[1\].u_pe.w_reg\[0\] u_pe_array.g_pe_row\[3\].g_pe_col\[1\].u_pe.act_val\[1\]
+ _1148_ _1149_ VGND VGND VPWR VPWR _1150_ sky130_fd_sc_hd__a22o_1
XFILLER_0_64_318 VGND VGND VPWR VPWR sky130_fd_sc_hd__decap_3
XFILLER_0_45_521 VGND VGND VPWR VPWR sky130_fd_sc_hd__fill_2
X_5726_ u_pe_array.g_pe_row\[0\].g_pe_col\[3\].u_pe.psum_out\[8\] u_pe_array.g_pe_row\[0\].g_pe_col\[3\].u_pe.move_reg\[8\]
+ _2469_ VGND VGND VPWR VPWR _2602_ sky130_fd_sc_hd__mux2_1
X_5657_ _2544_ _2548_ _2533_ VGND VGND VPWR VPWR _2549_ sky130_fd_sc_hd__mux2_1
XFILLER_0_5_673 VGND VGND VPWR VPWR sky130_fd_sc_hd__decap_4
XFILLER_0_102_103 VGND VGND VPWR VPWR sky130_fd_sc_hd__decap_6
XANTENNA__5353__B1 _0833_ VGND VGND VPWR VPWR sky130_fd_sc_hd__diode_2
X_5588_ u_pe_array.g_pe_row\[1\].g_pe_col\[0\].u_pe.act_val\[2\] u_pe_array.g_pe_row\[1\].g_pe_col\[0\].u_pe.w_reg\[0\]
+ VGND VGND VPWR VPWR _2485_ sky130_fd_sc_hd__nand2_1
X_4608_ u_pe_array.g_pe_row\[2\].g_pe_col\[1\].u_pe.psum_out\[10\] net193 _1661_ VGND
+ VGND VPWR VPWR _1663_ sky130_fd_sc_hd__mux2_1
XFILLER_0_102_158 VGND VGND VPWR VPWR sky130_fd_sc_hd__fill_2
Xhold341 u_pe_array.g_pe_row\[0\].g_pe_col\[0\].u_pe.move_reg\[10\] VGND VGND VPWR
+ VPWR net417 sky130_fd_sc_hd__dlygate4sd3_1
X_4539_ _1595_ _1602_ _1610_ VGND VGND VPWR VPWR _1611_ sky130_fd_sc_hd__a21oi_1
Xhold352 u_pe_array.u_fifo2.buffer\[0\]\[2\] VGND VGND VPWR VPWR net428 sky130_fd_sc_hd__dlygate4sd3_1
X_7327_ clknet_leaf_67_clk _0384_ net13 VGND VGND VPWR VPWR u_pe_array.g_pe_row\[0\].g_pe_col\[3\].u_pe.psum_out\[11\]
+ sky130_fd_sc_hd__dfrtp_1
Xhold330 u_pe_array.g_pe_row\[0\].g_pe_col\[3\].u_pe.psum_out\[12\] VGND VGND VPWR
+ VPWR net406 sky130_fd_sc_hd__dlygate4sd3_1
Xhold374 u_pe_array.u_fifo1.buffer\[6\]\[4\] VGND VGND VPWR VPWR net450 sky130_fd_sc_hd__dlygate4sd3_1
Xhold363 u_pe_array.u_fifo1.buffer\[7\]\[0\] VGND VGND VPWR VPWR net439 sky130_fd_sc_hd__dlygate4sd3_1
X_7258_ clknet_3_7__leaf_clk _0319_ net812 VGND VGND VPWR VPWR u_pe_array.g_pe_row\[1\].g_pe_col\[1\].u_pe.psum_out\[2\]
+ sky130_fd_sc_hd__dfrtp_1
Xhold385 u_pe_array.u_fifo1.rd_ptr\[2\] VGND VGND VPWR VPWR net461 sky130_fd_sc_hd__dlygate4sd3_1
Xhold396 u_pe_array.u_fifo2.buffer\[2\]\[0\] VGND VGND VPWR VPWR net472 sky130_fd_sc_hd__dlygate4sd3_1
X_6209_ _3002_ _3004_ VGND VGND VPWR VPWR _3005_ sky130_fd_sc_hd__xnor2_1
X_7189_ clknet_leaf_64_clk net148 net73 VGND VGND VPWR VPWR u_pe_array.g_pe_row\[1\].g_pe_col\[2\].u_pe.move_reg\[8\]
+ sky130_fd_sc_hd__dfrtp_1
XANTENNA__5721__S _2469_ VGND VGND VPWR VPWR sky130_fd_sc_hd__diode_2
XTAP_690 VGND VPWR sky130_fd_sc_hd__tapvpwrvgnd_1
XANTENNA__5959__A2 _2387_ VGND VGND VPWR VPWR sky130_fd_sc_hd__diode_2
Xclkbuf_3_6__f_clk clknet_0_clk VGND VGND VPWR VPWR clknet_3_6__leaf_clk sky130_fd_sc_hd__clkbuf_16
XFILLER_0_23_19 VGND VGND VPWR VPWR sky130_fd_sc_hd__fill_2
XANTENNA__6908__A1 _3130_ VGND VGND VPWR VPWR sky130_fd_sc_hd__diode_2
XANTENNA__5676__B _2478_ VGND VGND VPWR VPWR sky130_fd_sc_hd__diode_2
XFILLER_0_67_178 VGND VGND VPWR VPWR sky130_fd_sc_hd__fill_2
XANTENNA__5168__S _0828_ VGND VGND VPWR VPWR sky130_fd_sc_hd__diode_2
XFILLER_0_63_362 VGND VGND VPWR VPWR sky130_fd_sc_hd__fill_1
XFILLER_0_36_587 VGND VGND VPWR VPWR sky130_fd_sc_hd__fill_1
XFILLER_0_90_192 VGND VGND VPWR VPWR sky130_fd_sc_hd__fill_2
XANTENNA_clkbuf_leaf_5_clk_A clknet_3_0__leaf_clk VGND VGND VPWR VPWR sky130_fd_sc_hd__diode_2
XFILLER_0_2_109 VPWR VGND VPWR VGND sky130_ef_sc_hd__decap_12
XANTENNA__4800__S _0756_ VGND VGND VPWR VPWR sky130_fd_sc_hd__diode_2
XANTENNA__6300__B _2992_ VGND VGND VPWR VPWR sky130_fd_sc_hd__diode_2
XFILLER_0_64_15 VPWR VGND VPWR VGND sky130_ef_sc_hd__decap_12
XANTENNA__7241__RESET_B net813 VGND VGND VPWR VPWR sky130_fd_sc_hd__diode_2
XANTENNA_output49_A net49 VGND VGND VPWR VPWR sky130_fd_sc_hd__diode_2
X_4890_ _1894_ _1895_ VGND VGND VPWR VPWR _1896_ sky130_fd_sc_hd__and2b_1
XFILLER_0_74_605 VGND VGND VPWR VPWR sky130_fd_sc_hd__fill_2
X_3910_ _1084_ _1086_ _1087_ _1093_ VGND VGND VPWR VPWR _1094_ sky130_fd_sc_hd__a31oi_2
XANTENNA__5586__B u_pe_array.g_pe_row\[1\].g_pe_col\[0\].u_pe.w_reg\[0\] VGND VGND
+ VPWR VPWR sky130_fd_sc_hd__diode_2
X_3841_ u_pe_array.g_pe_row\[3\].g_pe_col\[2\].u_pe.act_val\[2\] VGND VGND VPWR VPWR
+ _1030_ sky130_fd_sc_hd__inv_2
X_6560_ _3247_ VGND VGND VPWR VPWR _0556_ sky130_fd_sc_hd__clkbuf_1
XFILLER_0_13_52 VGND VGND VPWR VPWR sky130_fd_sc_hd__fill_1
X_3772_ u_pe_array.g_pe_row\[3\].g_pe_col\[3\].u_pe.psum_out\[9\] u_pe_array.g_pe_row\[3\].g_pe_col\[3\].u_pe.psum_out\[10\]
+ _0869_ VGND VGND VPWR VPWR _0980_ sky130_fd_sc_hd__o21a_1
XFILLER_0_82_660 VGND VGND VPWR VPWR sky130_fd_sc_hd__fill_2
X_5511_ _2427_ _2429_ net830 _0875_ VGND VGND VPWR VPWR _0325_ sky130_fd_sc_hd__a2bb2o_1
X_6491_ _3210_ VGND VGND VPWR VPWR _0524_ sky130_fd_sc_hd__clkbuf_1
X_5442_ _2365_ VGND VGND VPWR VPWR _2366_ sky130_fd_sc_hd__inv_2
X_5373_ u_pe_array.u_fifo1.buffer\[4\]\[3\] _2279_ _2280_ u_pe_array.u_fifo1.buffer\[7\]\[3\]
+ VGND VGND VPWR VPWR _2310_ sky130_fd_sc_hd__a22o_1
XFILLER_0_1_131 VPWR VGND VPWR VGND sky130_ef_sc_hd__decap_12
XFILLER_0_2_643 VGND VGND VPWR VPWR sky130_fd_sc_hd__fill_1
XFILLER_0_112_489 VPWR VGND VPWR VGND sky130_ef_sc_hd__decap_12
X_7112_ clknet_leaf_37_clk _0183_ net76 VGND VGND VPWR VPWR u_pe_array.g_pe_row\[2\].g_pe_col\[0\].u_pe.act_val\[4\]
+ sky130_fd_sc_hd__dfrtp_2
X_4324_ u_pe_array.g_pe_row\[2\].g_pe_col\[3\].u_pe.psum_out\[3\] _1428_ VGND VGND
+ VPWR VPWR _1429_ sky130_fd_sc_hd__xnor2_1
X_7043_ clknet_leaf_33_clk _0118_ net817 VGND VGND VPWR VPWR u_pe_array.g_pe_row\[3\].g_pe_col\[0\].u_pe.psum_out\[10\]
+ sky130_fd_sc_hd__dfrtp_4
X_4255_ _1379_ _1369_ VGND VGND VPWR VPWR _1380_ sky130_fd_sc_hd__and2b_1
XANTENNA__6637__S _0747_ VGND VGND VPWR VPWR sky130_fd_sc_hd__diode_2
XANTENNA__7329__RESET_B net13 VGND VGND VPWR VPWR sky130_fd_sc_hd__diode_2
X_4186_ u_pe_array.g_pe_row\[3\].g_pe_col\[0\].u_pe.w_reg\[0\] u_pe_array.g_pe_row\[3\].g_pe_col\[0\].u_pe.act_val\[5\]
+ VGND VGND VPWR VPWR _1317_ sky130_fd_sc_hd__nand2_1
XFILLER_0_89_281 VGND VGND VPWR VPWR sky130_fd_sc_hd__fill_1
XFILLER_0_77_432 VGND VGND VPWR VPWR sky130_fd_sc_hd__fill_2
XTAP_1108 VGND VPWR sky130_fd_sc_hd__tapvpwrvgnd_1
XTAP_1119 VGND VPWR sky130_fd_sc_hd__tapvpwrvgnd_1
XANTENNA__6964__RESET_B net74 VGND VGND VPWR VPWR sky130_fd_sc_hd__diode_2
X_6827_ _3394_ VGND VGND VPWR VPWR _0676_ sky130_fd_sc_hd__clkbuf_1
XFILLER_0_107_217 VGND VGND VPWR VPWR sky130_fd_sc_hd__decap_4
XFILLER_0_92_457 VGND VGND VPWR VPWR sky130_fd_sc_hd__fill_2
X_6758_ net532 _3120_ net63 VGND VGND VPWR VPWR _3358_ sky130_fd_sc_hd__mux2_1
XFILLER_0_9_297 VGND VGND VPWR VPWR sky130_fd_sc_hd__fill_2
X_6689_ _3312_ _3319_ VGND VGND VPWR VPWR _3321_ sky130_fd_sc_hd__or2_1
XFILLER_0_18_598 VGND VGND VPWR VPWR sky130_fd_sc_hd__decap_3
X_5709_ u_pe_array.g_pe_row\[0\].g_pe_col\[3\].u_pe.act_val\[0\] u_pe_array.g_pe_row\[0\].g_pe_col\[3\].u_pe.psum_out\[0\]
+ _0770_ VGND VGND VPWR VPWR _2593_ sky130_fd_sc_hd__mux2_1
XFILLER_0_33_524 VGND VGND VPWR VPWR sky130_fd_sc_hd__decap_3
XANTENNA__5326__B1 _2174_ VGND VGND VPWR VPWR sky130_fd_sc_hd__diode_2
XANTENNA__4129__B2 _1004_ VGND VGND VPWR VPWR sky130_fd_sc_hd__diode_2
Xhold171 u_pe_array.u_fifo1.buffer\[2\]\[11\] VGND VGND VPWR VPWR net247 sky130_fd_sc_hd__dlygate4sd3_1
Xhold160 u_pe_array.g_pe_row\[0\].g_pe_col\[0\].u_pe.move_reg\[11\] VGND VGND VPWR
+ VPWR net236 sky130_fd_sc_hd__dlygate4sd3_1
XFILLER_0_13_281 VGND VGND VPWR VPWR sky130_fd_sc_hd__decap_3
XFILLER_0_13_292 VGND VGND VPWR VPWR sky130_fd_sc_hd__fill_1
Xhold182 u_pe_array.u_fifo1.buffer\[5\]\[12\] VGND VGND VPWR VPWR net258 sky130_fd_sc_hd__dlygate4sd3_1
Xhold193 u_pe_array.u_fifo2.buffer\[3\]\[6\] VGND VGND VPWR VPWR net269 sky130_fd_sc_hd__dlygate4sd3_1
XANTENNA__6547__S _3239_ VGND VGND VPWR VPWR sky130_fd_sc_hd__diode_2
XANTENNA__4604__A2 _1524_ VGND VGND VPWR VPWR sky130_fd_sc_hd__diode_2
XTAP_1631 VGND VPWR sky130_fd_sc_hd__tapvpwrvgnd_1
XTAP_1620 VGND VPWR sky130_fd_sc_hd__tapvpwrvgnd_1
XFILLER_0_68_465 VGND VGND VPWR VPWR sky130_fd_sc_hd__fill_2
XFILLER_0_56_649 VGND VGND VPWR VPWR sky130_fd_sc_hd__fill_1
XFILLER_0_50_39 VGND VGND VPWR VPWR sky130_fd_sc_hd__fill_2
XFILLER_0_63_181 VGND VGND VPWR VPWR sky130_fd_sc_hd__fill_2
XFILLER_0_59_15 VPWR VGND VPWR VGND sky130_ef_sc_hd__decap_12
XFILLER_0_24_557 VGND VGND VPWR VPWR sky130_fd_sc_hd__fill_2
XANTENNA__3670__A _0885_ VGND VGND VPWR VPWR sky130_fd_sc_hd__diode_2
XFILLER_0_75_69 VGND VGND VPWR VPWR sky130_fd_sc_hd__decap_8
X_4040_ net737 _1152_ _1197_ _1198_ VGND VGND VPWR VPWR _0085_ sky130_fd_sc_hd__a22o_1
XANTENNA__6045__B2 _0722_ VGND VGND VPWR VPWR sky130_fd_sc_hd__diode_2
XFILLER_0_78_229 VGND VGND VPWR VPWR sky130_fd_sc_hd__decap_4
X_5991_ _2810_ _2824_ _2825_ VGND VGND VPWR VPWR _2826_ sky130_fd_sc_hd__a21oi_1
X_4942_ _1931_ _1941_ _1942_ VGND VGND VPWR VPWR _1943_ sky130_fd_sc_hd__a21oi_1
X_7661_ clknet_leaf_26_clk _0710_ VGND VGND VPWR VPWR u_pe_array.u_fifo1.buffer\[7\]\[6\]
+ sky130_fd_sc_hd__dfxtp_1
XFILLER_0_86_284 VGND VGND VPWR VPWR sky130_fd_sc_hd__fill_1
XFILLER_0_47_627 VGND VGND VPWR VPWR sky130_fd_sc_hd__fill_2
X_4873_ _1878_ u_pe_array.g_pe_row\[2\].g_pe_col\[0\].u_pe.act_val\[4\] u_pe_array.g_pe_row\[2\].g_pe_col\[0\].u_pe.w_reg\[0\]
+ _1847_ VGND VGND VPWR VPWR _1880_ sky130_fd_sc_hd__nand4_2
X_6612_ _3275_ VGND VGND VPWR VPWR _0580_ sky130_fd_sc_hd__clkbuf_1
X_7592_ clknet_leaf_19_clk _0641_ VGND VGND VPWR VPWR u_pe_array.u_fifo1.buffer\[2\]\[2\]
+ sky130_fd_sc_hd__dfxtp_1
XANTENNA__5020__A2 _2009_ VGND VGND VPWR VPWR sky130_fd_sc_hd__diode_2
X_3824_ u_pe_array.g_pe_row\[3\].g_pe_col\[2\].u_pe.act_val\[1\] u_pe_array.g_pe_row\[3\].g_pe_col\[2\].u_pe.w_reg\[0\]
+ _1012_ _1013_ VGND VGND VPWR VPWR _1015_ sky130_fd_sc_hd__nand4_1
X_6543_ _1792_ _3140_ _3222_ VGND VGND VPWR VPWR _3238_ sky130_fd_sc_hd__and3_1
XFILLER_0_6_245 VGND VGND VPWR VPWR sky130_fd_sc_hd__decap_6
XFILLER_0_15_513 VGND VGND VPWR VPWR sky130_fd_sc_hd__decap_8
XFILLER_0_15_546 VGND VGND VPWR VPWR sky130_fd_sc_hd__decap_4
X_3755_ u_pe_array.g_pe_row\[3\].g_pe_col\[3\].u_pe.psum_out\[7\] u_pe_array.g_pe_row\[3\].g_pe_col\[3\].u_pe.psum_out\[8\]
+ _0869_ VGND VGND VPWR VPWR _0965_ sky130_fd_sc_hd__o21a_1
XFILLER_0_42_321 VGND VGND VPWR VPWR sky130_fd_sc_hd__decap_4
XFILLER_0_70_641 VGND VGND VPWR VPWR sky130_fd_sc_hd__decap_3
X_3686_ _0889_ _0899_ _0898_ VGND VGND VPWR VPWR _0902_ sky130_fd_sc_hd__a21oi_1
X_6474_ _3201_ VGND VGND VPWR VPWR _0516_ sky130_fd_sc_hd__clkbuf_1
XFILLER_0_40_83 VGND VGND VPWR VPWR sky130_fd_sc_hd__fill_1
X_5425_ _2258_ _2349_ _2350_ _2071_ net559 VGND VGND VPWR VPWR _0318_ sky130_fd_sc_hd__a32o_1
XFILLER_0_112_253 VPWR VGND VPWR VGND sky130_ef_sc_hd__decap_12
XFILLER_0_64_3 VPWR VGND VPWR VGND sky130_ef_sc_hd__decap_12
X_5356_ u_pe_array.u_fifo1.buffer\[5\]\[1\] _2284_ _2285_ u_pe_array.u_fifo1.buffer\[6\]\[1\]
+ _2286_ VGND VGND VPWR VPWR _2295_ sky130_fd_sc_hd__a221o_1
X_5287_ _2223_ _2226_ _2233_ VGND VGND VPWR VPWR _2234_ sky130_fd_sc_hd__a21oi_1
X_4307_ _1273_ _1412_ _1413_ _1144_ net543 VGND VGND VPWR VPWR _0137_ sky130_fd_sc_hd__a32o_1
XANTENNA__7163__RESET_B net814 VGND VGND VPWR VPWR sky130_fd_sc_hd__diode_2
X_4238_ _1273_ _1363_ _1364_ _1144_ net493 VGND VGND VPWR VPWR _0117_ sky130_fd_sc_hd__a32o_1
X_7026_ clknet_leaf_78_clk _0103_ net74 VGND VGND VPWR VPWR u_pe_array.g_pe_row\[2\].g_pe_col\[3\].u_pe.move_reg\[8\]
+ sky130_fd_sc_hd__dfrtp_1
XFILLER_0_4_83 VGND VGND VPWR VPWR sky130_fd_sc_hd__fill_1
XFILLER_0_97_505 VGND VGND VPWR VPWR sky130_fd_sc_hd__fill_2
X_4169_ _1298_ _1300_ VGND VGND VPWR VPWR _1302_ sky130_fd_sc_hd__nand2_1
XFILLER_0_69_207 VGND VGND VPWR VPWR sky130_fd_sc_hd__decap_3
XFILLER_0_77_251 VGND VGND VPWR VPWR sky130_fd_sc_hd__fill_2
XANTENNA__3739__B _0869_ VGND VGND VPWR VPWR sky130_fd_sc_hd__diode_2
XFILLER_0_65_457 VGND VGND VPWR VPWR sky130_fd_sc_hd__decap_6
XFILLER_0_65_468 VGND VGND VPWR VPWR sky130_fd_sc_hd__fill_2
XANTENNA__5011__A2 _2001_ VGND VGND VPWR VPWR sky130_fd_sc_hd__diode_2
XFILLER_0_18_351 VGND VGND VPWR VPWR sky130_fd_sc_hd__fill_1
XFILLER_0_18_362 VGND VGND VPWR VPWR sky130_fd_sc_hd__fill_2
XFILLER_0_61_630 VGND VGND VPWR VPWR sky130_fd_sc_hd__decap_4
XANTENNA__6131__A _2873_ VGND VGND VPWR VPWR sky130_fd_sc_hd__diode_2
XANTENNA__3474__B _0743_ VGND VGND VPWR VPWR sky130_fd_sc_hd__diode_2
XFILLER_0_21_527 VGND VGND VPWR VPWR sky130_fd_sc_hd__fill_2
XANTENNA__5181__S _0747_ VGND VGND VPWR VPWR sky130_fd_sc_hd__diode_2
XANTENNA__6275__A1 _2740_ VGND VGND VPWR VPWR sky130_fd_sc_hd__diode_2
Xclkbuf_leaf_85_clk clknet_3_1__leaf_clk VGND VGND VPWR VPWR clknet_leaf_85_clk sky130_fd_sc_hd__clkbuf_16
XTAP_1450 VGND VPWR sky130_fd_sc_hd__tapvpwrvgnd_1
XFILLER_0_96_560 VGND VGND VPWR VPWR sky130_fd_sc_hd__decap_4
XFILLER_0_68_262 VPWR VGND VPWR VGND sky130_ef_sc_hd__decap_12
XFILLER_0_61_27 VPWR VGND VPWR VGND sky130_ef_sc_hd__decap_12
XTAP_1483 VGND VPWR sky130_fd_sc_hd__tapvpwrvgnd_1
XTAP_1472 VGND VPWR sky130_fd_sc_hd__tapvpwrvgnd_1
XTAP_1461 VGND VPWR sky130_fd_sc_hd__tapvpwrvgnd_1
XTAP_1494 VGND VPWR sky130_fd_sc_hd__tapvpwrvgnd_1
XFILLER_0_83_276 VGND VGND VPWR VPWR sky130_fd_sc_hd__fill_2
XANTENNA__5002__A2 _1993_ VGND VGND VPWR VPWR sky130_fd_sc_hd__diode_2
XFILLER_0_71_449 VGND VGND VPWR VPWR sky130_fd_sc_hd__decap_4
X_3540_ _0717_ _0786_ VGND VGND VPWR VPWR _0787_ sky130_fd_sc_hd__and2_2
XFILLER_0_52_652 VGND VGND VPWR VPWR sky130_fd_sc_hd__decap_3
XFILLER_0_10_20 VGND VGND VPWR VPWR sky130_fd_sc_hd__fill_2
XFILLER_0_3_215 VGND VGND VPWR VPWR sky130_fd_sc_hd__decap_8
XFILLER_0_10_64 VGND VGND VPWR VPWR sky130_fd_sc_hd__fill_1
X_3471_ _0728_ _0741_ VGND VGND VPWR VPWR _0742_ sky130_fd_sc_hd__and2_1
X_5210_ _1725_ _2162_ _2163_ _2071_ net508 VGND VGND VPWR VPWR _0290_ sky130_fd_sc_hd__a32o_1
XFILLER_0_10_97 VGND VGND VPWR VPWR sky130_fd_sc_hd__decap_3
X_6190_ u_fsm.ch_cnt\[0\] u_fsm.ch_cnt\[1\] VGND VGND VPWR VPWR _2989_ sky130_fd_sc_hd__or2_1
XANTENNA__5710__B1 _2592_ VGND VGND VPWR VPWR sky130_fd_sc_hd__diode_2
X_5141_ u_pe_array.g_pe_row\[1\].g_pe_col\[3\].u_pe.psum_out\[8\] _2112_ _2114_ _2105_
+ VGND VGND VPWR VPWR _2115_ sky130_fd_sc_hd__a22o_1
X_5072_ _2049_ _2051_ VGND VGND VPWR VPWR _2052_ sky130_fd_sc_hd__xnor2_1
X_4023_ _1180_ _1182_ VGND VGND VPWR VPWR _1183_ sky130_fd_sc_hd__xnor2_1
XANTENNA__4277__B1 _1258_ VGND VGND VPWR VPWR sky130_fd_sc_hd__diode_2
XFILLER_0_36_7 VGND VGND VPWR VPWR sky130_fd_sc_hd__fill_2
Xclkbuf_leaf_76_clk clknet_3_4__leaf_clk VGND VGND VPWR VPWR clknet_leaf_76_clk sky130_fd_sc_hd__clkbuf_16
XANTENNA_clkbuf_leaf_92_clk_A clknet_3_0__leaf_clk VGND VGND VPWR VPWR sky130_fd_sc_hd__diode_2
XFILLER_0_79_549 VGND VGND VPWR VPWR sky130_fd_sc_hd__fill_2
X_5974_ u_pe_array.g_pe_row\[0\].g_pe_col\[2\].u_pe.psum_out\[7\] _2743_ VGND VGND
+ VPWR VPWR _2810_ sky130_fd_sc_hd__nand2_1
XANTENNA__4846__B1_N _1847_ VGND VGND VPWR VPWR sky130_fd_sc_hd__diode_2
X_4925_ _1919_ _1922_ _1927_ VGND VGND VPWR VPWR _1928_ sky130_fd_sc_hd__a21oi_2
X_4856_ _1854_ _1860_ _1863_ VGND VGND VPWR VPWR _1864_ sky130_fd_sc_hd__a21o_1
X_7644_ clknet_leaf_19_clk _0693_ VGND VGND VPWR VPWR u_pe_array.u_fifo1.buffer\[6\]\[2\]
+ sky130_fd_sc_hd__dfxtp_1
XANTENNA_clkbuf_leaf_30_clk_A clknet_3_3__leaf_clk VGND VGND VPWR VPWR sky130_fd_sc_hd__diode_2
X_7575_ clknet_leaf_27_clk _0624_ VGND VGND VPWR VPWR u_pe_array.u_fifo1.buffer\[0\]\[11\]
+ sky130_fd_sc_hd__dfxtp_1
XFILLER_0_51_82 VGND VGND VPWR VPWR sky130_fd_sc_hd__fill_1
X_3807_ net184 _0996_ _1002_ u_fsm.psum_shift_en VGND VGND VPWR VPWR _0048_ sky130_fd_sc_hd__a22o_1
XFILLER_0_34_129 VGND VGND VPWR VPWR sky130_fd_sc_hd__fill_2
XFILLER_0_105_529 VGND VGND VPWR VPWR sky130_fd_sc_hd__fill_1
XFILLER_0_15_332 VGND VGND VPWR VPWR sky130_fd_sc_hd__fill_2
X_6526_ _3229_ VGND VGND VPWR VPWR _0540_ sky130_fd_sc_hd__clkbuf_1
X_4787_ _1787_ _0854_ _1003_ _0747_ VGND VGND VPWR VPWR _1816_ sky130_fd_sc_hd__a22o_4
X_3738_ _0939_ _0942_ _0949_ VGND VGND VPWR VPWR _0950_ sky130_fd_sc_hd__a21oi_1
XFILLER_0_113_573 VPWR VGND VPWR VGND sky130_ef_sc_hd__decap_12
X_3669_ net733 _0875_ _0884_ _0886_ VGND VGND VPWR VPWR _0026_ sky130_fd_sc_hd__a22o_1
X_6457_ _3192_ VGND VGND VPWR VPWR _0508_ sky130_fd_sc_hd__clkbuf_1
XANTENNA__7344__RESET_B net13 VGND VGND VPWR VPWR sky130_fd_sc_hd__diode_2
XANTENNA_load_slew3_A net815 VGND VGND VPWR VPWR sky130_fd_sc_hd__diode_2
XFILLER_0_42_195 VGND VGND VPWR VPWR sky130_fd_sc_hd__fill_1
XFILLER_0_100_223 VGND VGND VPWR VPWR sky130_fd_sc_hd__fill_2
XANTENNA_clkbuf_leaf_45_clk_A clknet_3_7__leaf_clk VGND VGND VPWR VPWR sky130_fd_sc_hd__diode_2
X_5408_ u_pe_array.g_pe_row\[0\].g_pe_col\[0\].u_pe.psum_out\[10\] u_pe_array.g_pe_row\[0\].g_pe_col\[0\].u_pe.move_reg\[10\]
+ _1661_ VGND VGND VPWR VPWR _2338_ sky130_fd_sc_hd__mux2_1
X_6388_ _1791_ _3146_ VGND VGND VPWR VPWR _3152_ sky130_fd_sc_hd__nor2_1
X_5339_ u_pe_array.u_fifo1.rd_ptr\[1\] u_pe_array.u_fifo1.rd_ptr\[0\] _2271_ u_pe_array.u_fifo1.rd_ptr\[2\]
+ VGND VGND VPWR VPWR _2279_ sky130_fd_sc_hd__and4bb_2
XFILLER_0_97_302 VGND VGND VPWR VPWR sky130_fd_sc_hd__fill_1
X_7009_ clknet_leaf_11_clk _0086_ net818 VGND VGND VPWR VPWR u_pe_array.g_pe_row\[3\].g_pe_col\[1\].u_pe.psum_out\[6\]
+ sky130_fd_sc_hd__dfrtp_1
Xclkbuf_leaf_67_clk clknet_3_5__leaf_clk VGND VGND VPWR VPWR clknet_leaf_67_clk sky130_fd_sc_hd__clkbuf_16
XFILLER_0_65_210 VGND VGND VPWR VPWR sky130_fd_sc_hd__fill_2
XFILLER_0_38_424 VGND VGND VPWR VPWR sky130_fd_sc_hd__fill_2
XFILLER_0_53_438 VGND VGND VPWR VPWR sky130_fd_sc_hd__fill_2
XANTENNA__5176__S _0747_ VGND VGND VPWR VPWR sky130_fd_sc_hd__diode_2
XFILLER_0_104_573 VGND VGND VPWR VPWR sky130_fd_sc_hd__fill_2
XANTENNA__7085__RESET_B net818 VGND VGND VPWR VPWR sky130_fd_sc_hd__diode_2
XANTENNA__7014__RESET_B net818 VGND VGND VPWR VPWR sky130_fd_sc_hd__diode_2
XFILLER_0_21_379 VGND VGND VPWR VPWR sky130_fd_sc_hd__fill_2
XTAP_508 VGND VPWR sky130_fd_sc_hd__tapvpwrvgnd_1
XTAP_519 VGND VPWR sky130_fd_sc_hd__tapvpwrvgnd_1
XFILLER_0_56_27 VGND VGND VPWR VPWR sky130_fd_sc_hd__fill_1
XANTENNA__4259__B1 _1144_ VGND VGND VPWR VPWR sky130_fd_sc_hd__diode_2
Xclkbuf_leaf_58_clk clknet_3_6__leaf_clk VGND VGND VPWR VPWR clknet_leaf_58_clk sky130_fd_sc_hd__clkbuf_16
XFILLER_0_72_15 VPWR VGND VPWR VGND sky130_ef_sc_hd__decap_12
XFILLER_0_69_571 VGND VGND VPWR VPWR sky130_fd_sc_hd__fill_2
XANTENNA__5578__C u_pe_array.g_pe_row\[1\].g_pe_col\[0\].u_pe.w_reg\[0\] VGND VGND
+ VPWR VPWR sky130_fd_sc_hd__diode_2
XFILLER_0_84_530 VGND VGND VPWR VPWR sky130_fd_sc_hd__fill_2
XANTENNA__4431__B1 _1258_ VGND VGND VPWR VPWR sky130_fd_sc_hd__diode_2
XTAP_1291 VGND VPWR sky130_fd_sc_hd__tapvpwrvgnd_1
XTAP_1280 VGND VPWR sky130_fd_sc_hd__tapvpwrvgnd_1
X_5690_ _2573_ _2577_ VGND VGND VPWR VPWR _2579_ sky130_fd_sc_hd__nand2_1
X_4710_ _1752_ _1753_ VGND VGND VPWR VPWR _1754_ sky130_fd_sc_hd__or2_1
XANTENNA__6184__A0 net27 VGND VGND VPWR VPWR sky130_fd_sc_hd__diode_2
XFILLER_0_84_596 VGND VGND VPWR VPWR sky130_fd_sc_hd__fill_2
X_4641_ u_pe_array.g_pe_row\[2\].g_pe_col\[1\].u_pe.act_val\[2\] VGND VGND VPWR VPWR
+ _1690_ sky130_fd_sc_hd__inv_2
XFILLER_0_16_129 VGND VGND VPWR VPWR sky130_fd_sc_hd__fill_1
XFILLER_0_112_65 VPWR VGND VPWR VGND sky130_ef_sc_hd__decap_12
XFILLER_0_71_268 VGND VGND VPWR VPWR sky130_fd_sc_hd__fill_2
XANTENNA__4734__A1 _0914_ VGND VGND VPWR VPWR sky130_fd_sc_hd__diode_2
XFILLER_0_4_513 VPWR VGND VPWR VGND sky130_ef_sc_hd__decap_12
XFILLER_0_114_337 VGND VGND VPWR VPWR sky130_fd_sc_hd__fill_2
X_7360_ clknet_leaf_42_clk _0415_ net813 VGND VGND VPWR VPWR u_pe_array.g_pe_row\[0\].g_pe_col\[1\].u_pe.w_buffer\[1\]
+ sky130_fd_sc_hd__dfrtp_1
XFILLER_0_4_557 VPWR VGND VPWR VGND sky130_ef_sc_hd__decap_12
X_4572_ _1640_ _1630_ VGND VGND VPWR VPWR _1641_ sky130_fd_sc_hd__and2b_1
Xhold704 u_pe_array.g_pe_row\[0\].g_pe_col\[0\].u_pe.act_val\[2\] VGND VGND VPWR VPWR
+ net780 sky130_fd_sc_hd__dlygate4sd3_1
X_6311_ _3093_ _3097_ VGND VGND VPWR VPWR _3098_ sky130_fd_sc_hd__xor2_1
X_3523_ u_pe_array.g_pe_row\[1\].g_pe_col\[0\].u_pe.move_reg\[10\] _0770_ VGND VGND
+ VPWR VPWR _0775_ sky130_fd_sc_hd__or2_1
XANTENNA__4003__B _1145_ VGND VGND VPWR VPWR sky130_fd_sc_hd__diode_2
X_7291_ clknet_leaf_58_clk _0350_ net813 VGND VGND VPWR VPWR u_pe_array.g_pe_row\[1\].g_pe_col\[0\].u_pe.psum_out\[5\]
+ sky130_fd_sc_hd__dfrtp_1
Xhold715 u_pe_array.g_pe_row\[1\].g_pe_col\[2\].u_pe.psum_out\[10\] VGND VGND VPWR
+ VPWR net791 sky130_fd_sc_hd__dlygate4sd3_1
Xhold726 u_pe_array.g_pe_row\[1\].g_pe_col\[2\].u_pe.w_buffer\[1\] VGND VGND VPWR
+ VPWR net802 sky130_fd_sc_hd__dlygate4sd3_1
Xhold737 u_pe_array.g_pe_row\[3\].g_pe_col\[2\].u_pe.psum_out\[8\] VGND VGND VPWR
+ VPWR net821 sky130_fd_sc_hd__dlygate4sd3_1
XFILLER_0_24_195 VGND VGND VPWR VPWR sky130_fd_sc_hd__fill_1
XFILLER_0_40_622 VGND VGND VPWR VPWR sky130_fd_sc_hd__fill_2
X_6242_ _2740_ _3034_ _3035_ _0866_ net440 VGND VGND VPWR VPWR _0450_ sky130_fd_sc_hd__a32o_1
XFILLER_0_97_78 VGND VGND VPWR VPWR sky130_fd_sc_hd__fill_2
X_3454_ u_pe_array.g_pe_row\[0\].g_pe_col\[0\].u_pe.psum_shift_en_d VGND VGND VPWR
+ VPWR _0729_ sky130_fd_sc_hd__clkbuf_8
XANTENNA__4938__B _1847_ VGND VGND VPWR VPWR sky130_fd_sc_hd__diode_2
XFILLER_0_110_587 VGND VGND VPWR VPWR sky130_fd_sc_hd__fill_1
X_6173_ _2975_ _2976_ VGND VGND VPWR VPWR _2977_ sky130_fd_sc_hd__or2_1
X_5124_ _2076_ _2077_ _2090_ _2096_ VGND VGND VPWR VPWR _2099_ sky130_fd_sc_hd__or4b_1
Xclkbuf_leaf_49_clk clknet_3_7__leaf_clk VGND VGND VPWR VPWR clknet_leaf_49_clk sky130_fd_sc_hd__clkbuf_16
X_5055_ u_pe_array.g_pe_row\[1\].g_pe_col\[3\].u_pe.w_reg\[0\] u_pe_array.g_pe_row\[1\].g_pe_col\[3\].u_pe.act_val\[2\]
+ VGND VGND VPWR VPWR _2036_ sky130_fd_sc_hd__nand2_1
X_4006_ u_pe_array.g_pe_row\[3\].g_pe_col\[1\].u_pe.act_val\[2\] _1145_ VGND VGND
+ VPWR VPWR _1167_ sky130_fd_sc_hd__or2b_1
XFILLER_0_79_379 VGND VGND VPWR VPWR sky130_fd_sc_hd__fill_2
XFILLER_0_1_51 VGND VGND VPWR VPWR sky130_fd_sc_hd__decap_4
XFILLER_0_109_109 VGND VGND VPWR VPWR sky130_fd_sc_hd__decap_3
XFILLER_0_75_541 VGND VGND VPWR VPWR sky130_fd_sc_hd__fill_2
X_5957_ _2793_ _2794_ VGND VGND VPWR VPWR _2795_ sky130_fd_sc_hd__nand2_1
X_4908_ u_pe_array.g_pe_row\[2\].g_pe_col\[0\].u_pe.psum_out\[7\] _1847_ VGND VGND
+ VPWR VPWR _1912_ sky130_fd_sc_hd__nand2_1
XFILLER_0_90_500 VGND VGND VPWR VPWR sky130_fd_sc_hd__fill_2
XANTENNA__3776__A2 _0875_ VGND VGND VPWR VPWR sky130_fd_sc_hd__diode_2
XFILLER_0_90_522 VGND VGND VPWR VPWR sky130_fd_sc_hd__fill_2
X_5888_ u_pe_array.g_pe_row\[1\].g_pe_col\[1\].u_pe.psum_out\[9\] u_pe_array.g_pe_row\[1\].g_pe_col\[1\].u_pe.move_reg\[9\]
+ _2469_ VGND VGND VPWR VPWR _2735_ sky130_fd_sc_hd__mux2_1
X_7627_ clknet_leaf_18_clk _0676_ VGND VGND VPWR VPWR u_pe_array.u_fifo1.buffer\[4\]\[11\]
+ sky130_fd_sc_hd__dfxtp_1
XFILLER_0_47_276 VGND VGND VPWR VPWR sky130_fd_sc_hd__fill_2
X_4839_ _1846_ _1848_ VGND VGND VPWR VPWR _1849_ sky130_fd_sc_hd__xor2_1
XFILLER_0_90_544 VGND VGND VPWR VPWR sky130_fd_sc_hd__fill_2
XFILLER_0_62_246 VGND VGND VPWR VPWR sky130_fd_sc_hd__decap_4
XFILLER_0_16_641 VGND VGND VPWR VPWR sky130_fd_sc_hd__decap_3
XFILLER_0_35_449 VGND VGND VPWR VPWR sky130_fd_sc_hd__fill_2
XFILLER_0_105_337 VGND VGND VPWR VPWR sky130_fd_sc_hd__decap_3
XFILLER_0_90_599 VGND VGND VPWR VPWR sky130_fd_sc_hd__fill_2
XFILLER_0_90_577 VGND VGND VPWR VPWR sky130_fd_sc_hd__fill_2
XANTENNA__3528__A2 _0769_ VGND VGND VPWR VPWR sky130_fd_sc_hd__diode_2
X_7558_ clknet_leaf_18_clk _0607_ net816 VGND VGND VPWR VPWR u_pe_array.u_fifo1.rd_ptr\[2\]
+ sky130_fd_sc_hd__dfrtp_4
XFILLER_0_62_279 VGND VGND VPWR VPWR sky130_fd_sc_hd__fill_2
XFILLER_0_62_268 VGND VGND VPWR VPWR sky130_fd_sc_hd__fill_2
X_6509_ _3219_ VGND VGND VPWR VPWR _0533_ sky130_fd_sc_hd__clkbuf_1
X_7489_ clknet_leaf_3_clk _0538_ VGND VGND VPWR VPWR u_pe_array.u_fifo2.buffer\[4\]\[2\]
+ sky130_fd_sc_hd__dfxtp_1
XFILLER_0_31_633 VGND VGND VPWR VPWR sky130_fd_sc_hd__fill_1
XANTENNA__5724__S _2469_ VGND VGND VPWR VPWR sky130_fd_sc_hd__diode_2
XFILLER_0_30_132 VGND VGND VPWR VPWR sky130_fd_sc_hd__decap_8
XANTENNA__4489__B1 _0887_ VGND VGND VPWR VPWR sky130_fd_sc_hd__diode_2
XFILLER_0_30_187 VGND VGND VPWR VPWR sky130_fd_sc_hd__decap_3
Xhold31 u_pe_array.g_pe_row\[1\].g_pe_col\[1\].u_pe.w_buffer\[0\] VGND VGND VPWR VPWR
+ net107 sky130_fd_sc_hd__dlygate4sd3_1
Xhold20 u_pe_array.g_pe_row\[2\].g_pe_col\[2\].u_pe.w_buffer\[1\] VGND VGND VPWR VPWR
+ net96 sky130_fd_sc_hd__dlygate4sd3_1
Xhold42 u_pe_array.g_pe_row\[0\].g_pe_col\[1\].u_pe.move_reg\[7\] VGND VGND VPWR VPWR
+ net118 sky130_fd_sc_hd__dlygate4sd3_1
Xhold53 u_pe_array.g_pe_row\[2\].g_pe_col\[2\].u_pe.move_reg\[7\] VGND VGND VPWR VPWR
+ net129 sky130_fd_sc_hd__dlygate4sd3_1
Xhold64 _0339_ VGND VGND VPWR VPWR net140 sky130_fd_sc_hd__dlygate4sd3_1
XANTENNA__6555__S _3239_ VGND VGND VPWR VPWR sky130_fd_sc_hd__diode_2
XFILLER_0_97_110 VGND VGND VPWR VPWR sky130_fd_sc_hd__fill_2
Xhold86 u_pe_array.g_pe_row\[0\].g_pe_col\[1\].u_pe.move_reg\[12\] VGND VGND VPWR
+ VPWR net162 sky130_fd_sc_hd__dlygate4sd3_1
Xhold97 u_pe_array.g_pe_row\[3\].g_pe_col\[1\].u_pe.move_reg\[12\] VGND VGND VPWR
+ VPWR net173 sky130_fd_sc_hd__dlygate4sd3_1
Xhold75 _0129_ VGND VGND VPWR VPWR net151 sky130_fd_sc_hd__dlygate4sd3_1
XANTENNA__4803__S _0756_ VGND VGND VPWR VPWR sky130_fd_sc_hd__diode_2
XFILLER_0_109_665 VGND VGND VPWR VPWR sky130_fd_sc_hd__decap_6
XFILLER_0_26_438 VGND VGND VPWR VPWR sky130_fd_sc_hd__fill_2
XANTENNA__7266__RESET_B net812 VGND VGND VPWR VPWR sky130_fd_sc_hd__diode_2
XFILLER_0_41_408 VGND VGND VPWR VPWR sky130_fd_sc_hd__fill_2
XFILLER_0_61_290 VGND VGND VPWR VPWR sky130_fd_sc_hd__fill_2
XFILLER_0_1_505 VPWR VGND VPWR VGND sky130_ef_sc_hd__decap_12
XFILLER_0_111_329 VGND VGND VPWR VPWR sky130_fd_sc_hd__decap_6
XFILLER_0_6_29 VPWR VGND VPWR VGND sky130_ef_sc_hd__decap_12
XFILLER_0_22_655 VGND VGND VPWR VPWR sky130_fd_sc_hd__fill_2
XFILLER_0_67_15 VPWR VGND VPWR VGND sky130_ef_sc_hd__decap_12
XANTENNA__3662__B _0869_ VGND VGND VPWR VPWR sky130_fd_sc_hd__diode_2
XTAP_305 VGND VPWR sky130_fd_sc_hd__tapvpwrvgnd_1
XTAP_349 VGND VPWR sky130_fd_sc_hd__tapvpwrvgnd_1
XTAP_338 VGND VPWR sky130_fd_sc_hd__tapvpwrvgnd_1
XTAP_316 VGND VPWR sky130_fd_sc_hd__tapvpwrvgnd_1
XTAP_327 VGND VPWR sky130_fd_sc_hd__tapvpwrvgnd_1
XANTENNA__4493__B _1536_ VGND VGND VPWR VPWR sky130_fd_sc_hd__diode_2
XFILLER_0_13_9 VGND VGND VPWR VPWR sky130_fd_sc_hd__decap_8
X_6860_ net462 _3103_ _3412_ VGND VGND VPWR VPWR _3413_ sky130_fd_sc_hd__mux2_1
XFILLER_0_16_85 VGND VGND VPWR VPWR sky130_fd_sc_hd__decap_3
X_6791_ net329 _3126_ _3366_ VGND VGND VPWR VPWR _3375_ sky130_fd_sc_hd__mux2_1
XFILLER_0_57_530 VGND VGND VPWR VPWR sky130_fd_sc_hd__fill_1
X_5811_ _2675_ VGND VGND VPWR VPWR _2676_ sky130_fd_sc_hd__inv_2
X_5742_ u_pe_array.g_pe_row\[0\].g_pe_col\[3\].u_pe.act_val\[0\] _2611_ VGND VGND
+ VPWR VPWR _2612_ sky130_fd_sc_hd__nand2_1
XFILLER_0_57_585 VGND VGND VPWR VPWR sky130_fd_sc_hd__fill_2
XFILLER_0_44_202 VGND VGND VPWR VPWR sky130_fd_sc_hd__decap_3
XANTENNA__6157__B1 _2571_ VGND VGND VPWR VPWR sky130_fd_sc_hd__diode_2
X_5673_ _2553_ _2555_ _2556_ _2562_ net71 VGND VGND VPWR VPWR _2564_ sky130_fd_sc_hd__a41o_1
X_4624_ _1670_ _1674_ VGND VGND VPWR VPWR _1675_ sky130_fd_sc_hd__xnor2_1
X_7412_ clknet_leaf_16_clk _0461_ VGND VGND VPWR VPWR u_pe_array.u_fifo1.buffer\[8\]\[2\]
+ sky130_fd_sc_hd__dfxtp_1
XFILLER_0_13_611 VGND VGND VPWR VPWR sky130_fd_sc_hd__decap_3
XFILLER_0_114_167 VGND VGND VPWR VPWR sky130_fd_sc_hd__fill_1
XANTENNA__5380__A1 _0836_ VGND VGND VPWR VPWR sky130_fd_sc_hd__diode_2
X_7343_ clknet_leaf_53_clk net163 net812 VGND VGND VPWR VPWR u_pe_array.g_pe_row\[0\].g_pe_col\[1\].u_pe.move_reg\[12\]
+ sky130_fd_sc_hd__dfrtp_1
XFILLER_0_4_365 VGND VGND VPWR VPWR sky130_fd_sc_hd__fill_2
Xhold501 u_pe_array.u_fifo2.buffer\[6\]\[1\] VGND VGND VPWR VPWR net577 sky130_fd_sc_hd__dlygate4sd3_1
X_4555_ _1273_ _1624_ _1625_ _1534_ net681 VGND VGND VPWR VPWR _0173_ sky130_fd_sc_hd__a32o_1
Xhold512 u_pe_array.g_pe_row\[0\].g_pe_col\[0\].u_pe.act_val\[5\] VGND VGND VPWR VPWR
+ net588 sky130_fd_sc_hd__dlygate4sd3_1
XANTENNA__6989__RESET_B net76 VGND VGND VPWR VPWR sky130_fd_sc_hd__diode_2
X_3506_ _0764_ VGND VGND VPWR VPWR net42 sky130_fd_sc_hd__clkbuf_1
Xhold523 u_pe_array.g_pe_row\[1\].g_pe_col\[1\].u_pe.act_val\[5\] VGND VGND VPWR VPWR
+ net599 sky130_fd_sc_hd__dlygate4sd3_1
Xhold545 u_pe_array.g_pe_row\[2\].g_pe_col\[0\].u_pe.move_reg\[7\] VGND VGND VPWR
+ VPWR net621 sky130_fd_sc_hd__dlygate4sd3_1
Xhold534 u_pe_array.g_pe_row\[2\].g_pe_col\[3\].u_pe.psum_out\[5\] VGND VGND VPWR
+ VPWR net610 sky130_fd_sc_hd__dlygate4sd3_1
XFILLER_0_40_463 VGND VGND VPWR VPWR sky130_fd_sc_hd__fill_1
Xhold556 u_pe_array.g_pe_row\[1\].g_pe_col\[1\].u_pe.psum_out\[5\] VGND VGND VPWR
+ VPWR net632 sky130_fd_sc_hd__dlygate4sd3_1
XANTENNA__4668__B _1672_ VGND VGND VPWR VPWR sky130_fd_sc_hd__diode_2
Xhold567 u_pe_array.g_pe_row\[3\].g_pe_col\[1\].u_pe.psum_out\[2\] VGND VGND VPWR
+ VPWR net643 sky130_fd_sc_hd__dlygate4sd3_1
XANTENNA__6918__RESET_B net73 VGND VGND VPWR VPWR sky130_fd_sc_hd__diode_2
X_4486_ _1559_ _1561_ VGND VGND VPWR VPWR _1563_ sky130_fd_sc_hd__nand2_1
Xhold578 u_pe_array.g_pe_row\[1\].g_pe_col\[3\].u_pe.move_reg\[12\] VGND VGND VPWR
+ VPWR net654 sky130_fd_sc_hd__dlygate4sd3_1
X_7274_ clknet_leaf_69_clk _0335_ net814 VGND VGND VPWR VPWR u_pe_array.g_pe_row\[0\].g_pe_col\[3\].u_pe.act_val\[3\]
+ sky130_fd_sc_hd__dfrtp_2
X_6225_ _3019_ VGND VGND VPWR VPWR _3020_ sky130_fd_sc_hd__inv_2
Xhold589 u_pe_array.g_pe_row\[0\].g_pe_col\[0\].u_pe.psum_out\[2\] VGND VGND VPWR
+ VPWR net665 sky130_fd_sc_hd__dlygate4sd3_1
XANTENNA__5132__A1 _2029_ VGND VGND VPWR VPWR sky130_fd_sc_hd__diode_2
XANTENNA__6880__A1 _3130_ VGND VGND VPWR VPWR sky130_fd_sc_hd__diode_2
X_6156_ _2952_ _2955_ _2960_ VGND VGND VPWR VPWR _2962_ sky130_fd_sc_hd__or3_1
XTAP_861 VGND VPWR sky130_fd_sc_hd__tapvpwrvgnd_1
XTAP_850 VGND VPWR sky130_fd_sc_hd__tapvpwrvgnd_1
XTAP_894 VGND VPWR sky130_fd_sc_hd__tapvpwrvgnd_1
XTAP_872 VGND VPWR sky130_fd_sc_hd__tapvpwrvgnd_1
XTAP_883 VGND VPWR sky130_fd_sc_hd__tapvpwrvgnd_1
X_5107_ u_pe_array.g_pe_row\[1\].g_pe_col\[3\].u_pe.act_val\[5\] VGND VGND VPWR VPWR
+ _2084_ sky130_fd_sc_hd__inv_2
X_6087_ _2896_ _2898_ VGND VGND VPWR VPWR _2899_ sky130_fd_sc_hd__nor2_1
XANTENNA__6632__A1 u_pe_array.g_pe_row\[3\].g_pe_col\[3\].u_pe.act_val\[2\] VGND VGND
+ VPWR VPWR sky130_fd_sc_hd__diode_2
XFILLER_0_79_110 VGND VGND VPWR VPWR sky130_fd_sc_hd__fill_2
X_5038_ u_pe_array.g_pe_row\[0\].g_pe_col\[2\].u_pe.psum_out\[10\] u_pe_array.g_pe_row\[0\].g_pe_col\[2\].u_pe.move_reg\[10\]
+ _1661_ VGND VGND VPWR VPWR _2024_ sky130_fd_sc_hd__mux2_1
XANTENNA__5840__C1 _2611_ VGND VGND VPWR VPWR sky130_fd_sc_hd__diode_2
XFILLER_0_94_113 VGND VGND VPWR VPWR sky130_fd_sc_hd__fill_2
XFILLER_0_79_198 VGND VGND VPWR VPWR sky130_fd_sc_hd__decap_3
X_6989_ clknet_leaf_35_clk _0068_ net76 VGND VGND VPWR VPWR u_pe_array.g_pe_row\[3\].g_pe_col\[0\].u_pe.act_val\[1\]
+ sky130_fd_sc_hd__dfrtp_1
XFILLER_0_48_563 VGND VGND VPWR VPWR sky130_fd_sc_hd__decap_8
XANTENNA__5719__S _0770_ VGND VGND VPWR VPWR sky130_fd_sc_hd__diode_2
XFILLER_0_75_371 VGND VGND VPWR VPWR sky130_fd_sc_hd__fill_1
XFILLER_0_63_500 VGND VGND VPWR VPWR sky130_fd_sc_hd__fill_2
XFILLER_0_106_613 VPWR VGND VPWR VGND sky130_ef_sc_hd__decap_12
XFILLER_0_106_657 VPWR VGND VPWR VGND sky130_ef_sc_hd__decap_12
XFILLER_0_63_577 VGND VGND VPWR VPWR sky130_fd_sc_hd__decap_3
XANTENNA__5371__A1 _0836_ VGND VGND VPWR VPWR sky130_fd_sc_hd__diode_2
XFILLER_0_16_471 VGND VGND VPWR VPWR sky130_fd_sc_hd__decap_4
XANTENNA__3482__B _0730_ VGND VGND VPWR VPWR sky130_fd_sc_hd__diode_2
Xoutput43 net43 VGND VGND VPWR VPWR psum_out0[4] sky130_fd_sc_hd__clkbuf_4
XFILLER_0_101_351 VGND VGND VPWR VPWR sky130_fd_sc_hd__fill_1
Xoutput54 net54 VGND VGND VPWR VPWR psum_out1[2] sky130_fd_sc_hd__clkbuf_4
XANTENNA__5123__A1 _1725_ VGND VGND VPWR VPWR sky130_fd_sc_hd__diode_2
XANTENNA_input30_A w_in_flat[3] VGND VGND VPWR VPWR sky130_fd_sc_hd__diode_2
XANTENNA__6623__A1 _1818_ VGND VGND VPWR VPWR sky130_fd_sc_hd__diode_2
XFILLER_0_58_305 VGND VGND VPWR VPWR sky130_fd_sc_hd__fill_1
XFILLER_0_85_124 VGND VGND VPWR VPWR sky130_fd_sc_hd__fill_2
XFILLER_0_73_308 VGND VGND VPWR VPWR sky130_fd_sc_hd__decap_8
XFILLER_0_85_179 VGND VGND VPWR VPWR sky130_fd_sc_hd__decap_8
XPHY_160 VGND VGND VPWR VPWR sky130_fd_sc_hd__decap_3
XPHY_193 VGND VGND VPWR VPWR sky130_fd_sc_hd__decap_3
XPHY_182 VGND VGND VPWR VPWR sky130_fd_sc_hd__decap_3
XPHY_171 VGND VGND VPWR VPWR sky130_fd_sc_hd__decap_3
XFILLER_0_54_555 VGND VGND VPWR VPWR sky130_fd_sc_hd__decap_6
XFILLER_0_54_533 VGND VGND VPWR VPWR sky130_fd_sc_hd__decap_6
XANTENNA__5362__A1 _0836_ VGND VGND VPWR VPWR sky130_fd_sc_hd__diode_2
XANTENNA__3673__A u_pe_array.g_pe_row\[3\].g_pe_col\[3\].u_pe.act_val\[2\] VGND VGND
+ VPWR VPWR sky130_fd_sc_hd__diode_2
XFILLER_0_1_302 VGND VGND VPWR VPWR sky130_fd_sc_hd__fill_2
XFILLER_0_1_313 VGND VGND VPWR VPWR sky130_fd_sc_hd__decap_8
XFILLER_0_22_441 VGND VGND VPWR VPWR sky130_fd_sc_hd__fill_2
XFILLER_0_10_636 VGND VGND VPWR VPWR sky130_fd_sc_hd__decap_8
X_4340_ _1441_ _1443_ VGND VGND VPWR VPWR _1444_ sky130_fd_sc_hd__xnor2_1
XFILLER_0_22_485 VGND VGND VPWR VPWR sky130_fd_sc_hd__fill_1
XFILLER_0_10_669 VGND VGND VPWR VPWR sky130_fd_sc_hd__decap_8
X_4271_ u_pe_array.g_pe_row\[2\].g_pe_col\[3\].u_pe.act_val\[1\] u_pe_array.g_pe_row\[2\].g_pe_col\[3\].u_pe.psum_out\[1\]
+ _0770_ VGND VGND VPWR VPWR _1391_ sky130_fd_sc_hd__mux2_1
X_6010_ _2837_ _2841_ VGND VGND VPWR VPWR _2843_ sky130_fd_sc_hd__nand2_1
XANTENNA__3612__S _0819_ VGND VGND VPWR VPWR sky130_fd_sc_hd__diode_2
X_6912_ net232 _3134_ _3427_ VGND VGND VPWR VPWR _3440_ sky130_fd_sc_hd__mux2_1
XFILLER_0_89_463 VGND VGND VPWR VPWR sky130_fd_sc_hd__decap_3
XFILLER_0_49_305 VGND VGND VPWR VPWR sky130_fd_sc_hd__fill_1
X_6843_ _3403_ VGND VGND VPWR VPWR _0683_ sky130_fd_sc_hd__clkbuf_1
XFILLER_0_49_316 VGND VGND VPWR VPWR sky130_fd_sc_hd__fill_2
XANTENNA__7188__RESET_B net73 VGND VGND VPWR VPWR sky130_fd_sc_hd__diode_2
XANTENNA__6378__B1 _1787_ VGND VGND VPWR VPWR sky130_fd_sc_hd__diode_2
XANTENNA__4443__S _0855_ VGND VGND VPWR VPWR sky130_fd_sc_hd__diode_2
XANTENNA__4928__A1 _0914_ VGND VGND VPWR VPWR sky130_fd_sc_hd__diode_2
X_6774_ _3301_ _3323_ VGND VGND VPWR VPWR _3366_ sky130_fd_sc_hd__nor2_8
X_3986_ _1146_ _1147_ _1143_ VGND VGND VPWR VPWR _1149_ sky130_fd_sc_hd__o21ai_1
XANTENNA__7117__RESET_B net816 VGND VGND VPWR VPWR sky130_fd_sc_hd__diode_2
XFILLER_0_9_446 VGND VGND VPWR VPWR sky130_fd_sc_hd__fill_2
XFILLER_0_72_341 VGND VGND VPWR VPWR sky130_fd_sc_hd__fill_1
XFILLER_0_57_393 VGND VGND VPWR VPWR sky130_fd_sc_hd__fill_2
X_5725_ net246 _2600_ _2601_ _2336_ VGND VGND VPWR VPWR _0367_ sky130_fd_sc_hd__a22o_1
XFILLER_0_94_3 VPWR VGND VPWR VGND sky130_ef_sc_hd__decap_12
X_5656_ _2547_ VGND VGND VPWR VPWR _2548_ sky130_fd_sc_hd__inv_2
XFILLER_0_5_641 VPWR VGND VPWR VGND sky130_ef_sc_hd__decap_12
XFILLER_0_17_279 VGND VGND VPWR VPWR sky130_fd_sc_hd__fill_1
XANTENNA__5353__A1 _0836_ VGND VGND VPWR VPWR sky130_fd_sc_hd__diode_2
XFILLER_0_72_396 VGND VGND VPWR VPWR sky130_fd_sc_hd__fill_2
X_4607_ net477 _1524_ _1662_ _1399_ VGND VGND VPWR VPWR _0188_ sky130_fd_sc_hd__a22o_1
X_5587_ _2258_ _2483_ _2484_ _2071_ net572 VGND VGND VPWR VPWR _0346_ sky130_fd_sc_hd__a32o_1
Xhold320 u_fsm.ch_cnt\[1\] VGND VGND VPWR VPWR net396 sky130_fd_sc_hd__dlygate4sd3_1
XFILLER_0_32_249 VGND VGND VPWR VPWR sky130_fd_sc_hd__decap_3
Xhold342 u_pe_array.g_pe_row\[1\].g_pe_col\[1\].u_pe.psum_out\[2\] VGND VGND VPWR
+ VPWR net418 sky130_fd_sc_hd__dlygate4sd3_1
Xhold353 u_pe_array.g_pe_row\[3\].g_pe_col\[2\].u_pe.psum_out\[12\] VGND VGND VPWR
+ VPWR net429 sky130_fd_sc_hd__dlygate4sd3_1
XFILLER_0_7_61 VGND VGND VPWR VPWR sky130_fd_sc_hd__fill_2
XFILLER_0_4_195 VGND VGND VPWR VPWR sky130_fd_sc_hd__fill_1
X_4538_ _1596_ _1597_ _1603_ _1591_ _1609_ VGND VGND VPWR VPWR _1610_ sky130_fd_sc_hd__a32o_1
X_7326_ clknet_leaf_67_clk _0383_ net13 VGND VGND VPWR VPWR u_pe_array.g_pe_row\[0\].g_pe_col\[3\].u_pe.psum_out\[10\]
+ sky130_fd_sc_hd__dfrtp_2
Xhold331 u_pe_array.u_fifo2.buffer\[0\]\[0\] VGND VGND VPWR VPWR net407 sky130_fd_sc_hd__dlygate4sd3_1
Xhold364 u_pe_array.g_pe_row\[0\].g_pe_col\[0\].u_pe.psum_out\[4\] VGND VGND VPWR
+ VPWR net440 sky130_fd_sc_hd__dlygate4sd3_1
Xhold375 u_pe_array.u_fifo1.buffer\[0\]\[4\] VGND VGND VPWR VPWR net451 sky130_fd_sc_hd__dlygate4sd3_1
Xhold386 u_pe_array.u_fifo1.buffer\[6\]\[0\] VGND VGND VPWR VPWR net462 sky130_fd_sc_hd__dlygate4sd3_1
X_7257_ clknet_leaf_54_clk _0318_ net812 VGND VGND VPWR VPWR u_pe_array.g_pe_row\[1\].g_pe_col\[1\].u_pe.psum_out\[1\]
+ sky130_fd_sc_hd__dfrtp_1
X_4469_ _1545_ _1546_ VGND VGND VPWR VPWR _1547_ sky130_fd_sc_hd__xnor2_1
XFILLER_0_40_282 VGND VGND VPWR VPWR sky130_fd_sc_hd__decap_3
XFILLER_0_110_170 VGND VGND VPWR VPWR sky130_fd_sc_hd__fill_1
X_6208_ _3003_ u_pe_array.g_pe_row\[0\].g_pe_col\[0\].u_pe.psum_out\[1\] _2992_ VGND
+ VGND VPWR VPWR _3004_ sky130_fd_sc_hd__o21a_1
Xhold397 u_pe_array.u_fifo1.buffer\[2\]\[0\] VGND VGND VPWR VPWR net473 sky130_fd_sc_hd__dlygate4sd3_1
X_7188_ clknet_leaf_64_clk net208 net73 VGND VGND VPWR VPWR u_pe_array.g_pe_row\[1\].g_pe_col\[2\].u_pe.move_reg\[7\]
+ sky130_fd_sc_hd__dfrtp_1
X_6139_ u_pe_array.g_pe_row\[0\].g_pe_col\[1\].u_pe.psum_out\[7\] VGND VGND VPWR VPWR
+ _2946_ sky130_fd_sc_hd__inv_2
XTAP_680 VGND VPWR sky130_fd_sc_hd__tapvpwrvgnd_1
XTAP_691 VGND VPWR sky130_fd_sc_hd__tapvpwrvgnd_1
XFILLER_0_67_113 VGND VGND VPWR VPWR sky130_fd_sc_hd__fill_1
XFILLER_0_83_617 VGND VGND VPWR VPWR sky130_fd_sc_hd__fill_2
XANTENNA__7540__RESET_B net815 VGND VGND VPWR VPWR sky130_fd_sc_hd__diode_2
XFILLER_0_83_628 VGND VGND VPWR VPWR sky130_fd_sc_hd__fill_1
XFILLER_0_82_105 VGND VGND VPWR VPWR sky130_fd_sc_hd__fill_1
XANTENNA__3477__B _0730_ VGND VGND VPWR VPWR sky130_fd_sc_hd__diode_2
XFILLER_0_36_533 VGND VGND VPWR VPWR sky130_fd_sc_hd__fill_2
XFILLER_0_63_352 VGND VGND VPWR VPWR sky130_fd_sc_hd__fill_2
XFILLER_0_36_577 VGND VGND VPWR VPWR sky130_fd_sc_hd__fill_2
XFILLER_0_23_216 VGND VGND VPWR VPWR sky130_fd_sc_hd__decap_6
XFILLER_0_106_487 VGND VGND VPWR VPWR sky130_fd_sc_hd__fill_1
XANTENNA__3493__A _0730_ VGND VGND VPWR VPWR sky130_fd_sc_hd__diode_2
XFILLER_0_64_27 VGND VGND VPWR VPWR sky130_fd_sc_hd__fill_1
XFILLER_0_98_271 VGND VGND VPWR VPWR sky130_fd_sc_hd__fill_1
XFILLER_0_86_433 VGND VGND VPWR VPWR sky130_fd_sc_hd__fill_2
XFILLER_0_80_15 VGND VGND VPWR VPWR sky130_fd_sc_hd__decap_8
XFILLER_0_58_146 VGND VGND VPWR VPWR sky130_fd_sc_hd__fill_2
XANTENNA__7281__RESET_B net814 VGND VGND VPWR VPWR sky130_fd_sc_hd__diode_2
XFILLER_0_74_639 VGND VGND VPWR VPWR sky130_fd_sc_hd__fill_2
XANTENNA__7210__RESET_B net73 VGND VGND VPWR VPWR sky130_fd_sc_hd__diode_2
X_3840_ u_pe_array.g_pe_row\[3\].g_pe_col\[2\].u_pe.act_val\[3\] u_pe_array.g_pe_row\[3\].g_pe_col\[2\].u_pe.w_reg\[0\]
+ VGND VGND VPWR VPWR _1029_ sky130_fd_sc_hd__nand2_1
XFILLER_0_104_77 VGND VGND VPWR VPWR sky130_fd_sc_hd__decap_4
X_3771_ _0864_ _0978_ _0979_ _0867_ net424 VGND VGND VPWR VPWR _0035_ sky130_fd_sc_hd__a32o_1
XFILLER_0_39_393 VGND VGND VPWR VPWR sky130_fd_sc_hd__fill_2
XFILLER_0_109_281 VPWR VGND VPWR VGND sky130_ef_sc_hd__decap_12
XFILLER_0_104_99 VGND VGND VPWR VPWR sky130_fd_sc_hd__decap_3
X_5510_ net71 _2428_ VGND VGND VPWR VPWR _2429_ sky130_fd_sc_hd__or2_1
XFILLER_0_89_57 VPWR VGND VPWR VGND sky130_ef_sc_hd__decap_12
XFILLER_0_89_35 VGND VGND VPWR VPWR sky130_fd_sc_hd__fill_2
XFILLER_0_14_238 VGND VGND VPWR VPWR sky130_fd_sc_hd__fill_1
X_6490_ net561 _1798_ _3208_ VGND VGND VPWR VPWR _3210_ sky130_fd_sc_hd__mux2_1
X_5441_ u_pe_array.g_pe_row\[1\].g_pe_col\[1\].u_pe.act_val\[2\] u_pe_array.g_pe_row\[1\].g_pe_col\[1\].u_pe.act_val\[3\]
+ u_pe_array.g_pe_row\[1\].g_pe_col\[1\].u_pe.w_reg\[0\] _2345_ VGND VGND VPWR VPWR
+ _2365_ sky130_fd_sc_hd__and4b_1
X_5372_ u_pe_array.u_fifo1.buffer\[0\]\[3\] _2275_ VGND VGND VPWR VPWR _2309_ sky130_fd_sc_hd__or2_1
XFILLER_0_1_143 VPWR VGND VPWR VGND sky130_ef_sc_hd__decap_12
XFILLER_0_1_121 VGND VGND VPWR VPWR sky130_fd_sc_hd__decap_3
X_7111_ clknet_leaf_36_clk _0182_ net76 VGND VGND VPWR VPWR u_pe_array.g_pe_row\[2\].g_pe_col\[0\].u_pe.act_val\[3\]
+ sky130_fd_sc_hd__dfrtp_2
X_4323_ u_pe_array.g_pe_row\[2\].g_pe_col\[3\].u_pe.act_val\[2\] _1407_ VGND VGND
+ VPWR VPWR _1428_ sky130_fd_sc_hd__or2b_1
X_7042_ clknet_leaf_34_clk _0117_ net76 VGND VGND VPWR VPWR u_pe_array.g_pe_row\[3\].g_pe_col\[0\].u_pe.psum_out\[9\]
+ sky130_fd_sc_hd__dfrtp_2
XANTENNA__5638__A2 _2387_ VGND VGND VPWR VPWR sky130_fd_sc_hd__diode_2
XFILLER_0_10_477 VPWR VGND VPWR VGND sky130_ef_sc_hd__decap_12
X_4254_ _1377_ _1378_ VGND VGND VPWR VPWR _1379_ sky130_fd_sc_hd__or2_1
XANTENNA__4946__B _1847_ VGND VGND VPWR VPWR sky130_fd_sc_hd__diode_2
X_4185_ _1315_ _1316_ net743 _0916_ VGND VGND VPWR VPWR _0112_ sky130_fd_sc_hd__a2bb2o_1
XANTENNA__7369__RESET_B net812 VGND VGND VPWR VPWR sky130_fd_sc_hd__diode_2
XTAP_1109 VGND VPWR sky130_fd_sc_hd__tapvpwrvgnd_1
XANTENNA__5777__B _2611_ VGND VGND VPWR VPWR sky130_fd_sc_hd__diode_2
XFILLER_0_77_455 VGND VGND VPWR VPWR sky130_fd_sc_hd__fill_1
XFILLER_0_92_425 VGND VGND VPWR VPWR sky130_fd_sc_hd__fill_2
X_6826_ net231 _3132_ _3382_ VGND VGND VPWR VPWR _3394_ sky130_fd_sc_hd__mux2_1
XFILLER_0_9_232 VGND VGND VPWR VPWR sky130_fd_sc_hd__fill_2
XFILLER_0_92_447 VGND VGND VPWR VPWR sky130_fd_sc_hd__fill_2
X_6757_ _3357_ VGND VGND VPWR VPWR _0643_ sky130_fd_sc_hd__clkbuf_1
X_3969_ u_pe_array.g_pe_row\[2\].g_pe_col\[0\].u_pe.move_reg\[9\] u_pe_array.g_pe_row\[2\].g_pe_col\[0\].u_pe.psum_out\[9\]
+ _0755_ VGND VGND VPWR VPWR _1137_ sky130_fd_sc_hd__mux2_1
XFILLER_0_73_650 VGND VGND VPWR VPWR sky130_fd_sc_hd__fill_2
XFILLER_0_70_81 VGND VGND VPWR VPWR sky130_fd_sc_hd__decap_3
X_5708_ _0835_ VGND VGND VPWR VPWR _2592_ sky130_fd_sc_hd__buf_8
XANTENNA__5574__B2 _2336_ VGND VGND VPWR VPWR sky130_fd_sc_hd__diode_2
X_6688_ _3315_ _3319_ _3320_ _3312_ net581 VGND VGND VPWR VPWR _0611_ sky130_fd_sc_hd__a32o_1
XANTENNA__6933__RESET_B net819 VGND VGND VPWR VPWR sky130_fd_sc_hd__diode_2
X_5639_ u_pe_array.g_pe_row\[1\].g_pe_col\[0\].u_pe.act_val\[5\] VGND VGND VPWR VPWR
+ _2532_ sky130_fd_sc_hd__inv_2
XFILLER_0_5_482 VPWR VGND VPWR VGND sky130_ef_sc_hd__decap_12
XANTENNA__4129__A2 _1138_ VGND VGND VPWR VPWR sky130_fd_sc_hd__diode_2
XFILLER_0_103_435 VGND VGND VPWR VPWR sky130_fd_sc_hd__fill_2
XANTENNA__5877__A2 _2600_ VGND VGND VPWR VPWR sky130_fd_sc_hd__diode_2
XFILLER_0_60_388 VGND VGND VPWR VPWR sky130_fd_sc_hd__decap_3
XANTENNA__6828__S _3382_ VGND VGND VPWR VPWR sky130_fd_sc_hd__diode_2
Xhold161 u_pe_array.g_pe_row\[0\].g_pe_col\[0\].u_pe.move_reg\[8\] VGND VGND VPWR
+ VPWR net237 sky130_fd_sc_hd__dlygate4sd3_1
X_7309_ clknet_leaf_66_clk _0368_ net814 VGND VGND VPWR VPWR u_pe_array.g_pe_row\[0\].g_pe_col\[2\].u_pe.move_reg\[8\]
+ sky130_fd_sc_hd__dfrtp_1
Xhold150 u_pe_array.u_fifo2.buffer\[1\]\[10\] VGND VGND VPWR VPWR net226 sky130_fd_sc_hd__dlygate4sd3_1
Xhold183 u_pe_array.u_fifo1.buffer\[4\]\[8\] VGND VGND VPWR VPWR net259 sky130_fd_sc_hd__dlygate4sd3_1
Xhold194 u_pe_array.u_fifo1.buffer\[6\]\[12\] VGND VGND VPWR VPWR net270 sky130_fd_sc_hd__dlygate4sd3_1
XANTENNA__6826__A1 _3132_ VGND VGND VPWR VPWR sky130_fd_sc_hd__diode_2
Xhold172 u_pe_array.u_fifo2.buffer\[0\]\[9\] VGND VGND VPWR VPWR net248 sky130_fd_sc_hd__dlygate4sd3_1
XANTENNA__5732__S _2469_ VGND VGND VPWR VPWR sky130_fd_sc_hd__diode_2
XANTENNA__4301__A2 _1407_ VGND VGND VPWR VPWR sky130_fd_sc_hd__diode_2
XANTENNA__6563__S _3239_ VGND VGND VPWR VPWR sky130_fd_sc_hd__diode_2
XANTENNA__7039__RESET_B net817 VGND VGND VPWR VPWR sky130_fd_sc_hd__diode_2
XTAP_1632 VGND VPWR sky130_fd_sc_hd__tapvpwrvgnd_1
XTAP_1621 VGND VPWR sky130_fd_sc_hd__tapvpwrvgnd_1
XTAP_1610 VGND VPWR sky130_fd_sc_hd__tapvpwrvgnd_1
XFILLER_0_95_230 VGND VGND VPWR VPWR sky130_fd_sc_hd__decap_4
XANTENNA__3812__B2 _1004_ VGND VGND VPWR VPWR sky130_fd_sc_hd__diode_2
XFILLER_0_68_477 VGND VGND VPWR VPWR sky130_fd_sc_hd__fill_2
XFILLER_0_95_296 VGND VGND VPWR VPWR sky130_fd_sc_hd__fill_2
XFILLER_0_50_29 VGND VGND VPWR VPWR sky130_fd_sc_hd__fill_2
XFILLER_0_70_119 VGND VGND VPWR VPWR sky130_fd_sc_hd__decap_4
XFILLER_0_59_27 VPWR VGND VPWR VGND sky130_ef_sc_hd__decap_12
XANTENNA_output61_A net61 VGND VGND VPWR VPWR sky130_fd_sc_hd__diode_2
XANTENNA__6045__A2 _2738_ VGND VGND VPWR VPWR sky130_fd_sc_hd__diode_2
XFILLER_0_78_208 VGND VGND VPWR VPWR sky130_fd_sc_hd__decap_3
X_5990_ u_pe_array.g_pe_row\[0\].g_pe_col\[2\].u_pe.psum_out\[8\] _2810_ VGND VGND
+ VPWR VPWR _2825_ sky130_fd_sc_hd__nor2_1
X_4941_ u_pe_array.g_pe_row\[2\].g_pe_col\[0\].u_pe.psum_out\[10\] _1931_ VGND VGND
+ VPWR VPWR _1942_ sky130_fd_sc_hd__nor2_1
XFILLER_0_59_455 VGND VGND VPWR VPWR sky130_fd_sc_hd__fill_1
XFILLER_0_59_433 VGND VGND VPWR VPWR sky130_fd_sc_hd__decap_3
XFILLER_0_47_606 VGND VGND VPWR VPWR sky130_fd_sc_hd__decap_3
XANTENNA__3803__B2 u_fsm.psum_shift_en VGND VGND VPWR VPWR sky130_fd_sc_hd__diode_2
X_4872_ u_pe_array.g_pe_row\[2\].g_pe_col\[0\].u_pe.act_val\[4\] u_pe_array.g_pe_row\[2\].g_pe_col\[0\].u_pe.w_reg\[0\]
+ _1847_ _1878_ VGND VGND VPWR VPWR _1879_ sky130_fd_sc_hd__a22o_1
X_7660_ clknet_leaf_22_clk _0709_ VGND VGND VPWR VPWR u_pe_array.u_fifo1.buffer\[7\]\[5\]
+ sky130_fd_sc_hd__dfxtp_1
XFILLER_0_86_263 VGND VGND VPWR VPWR sky130_fd_sc_hd__fill_1
XFILLER_0_59_477 VGND VGND VPWR VPWR sky130_fd_sc_hd__fill_2
XFILLER_0_59_466 VGND VGND VPWR VPWR sky130_fd_sc_hd__fill_1
XFILLER_0_47_639 VGND VGND VPWR VPWR sky130_fd_sc_hd__decap_4
XFILLER_0_24_85 VGND VGND VPWR VPWR sky130_fd_sc_hd__fill_2
X_3823_ u_pe_array.g_pe_row\[3\].g_pe_col\[2\].u_pe.act_val\[1\] u_pe_array.g_pe_row\[3\].g_pe_col\[2\].u_pe.w_reg\[0\]
+ _1012_ _1013_ VGND VGND VPWR VPWR _1014_ sky130_fd_sc_hd__a22o_1
X_6611_ net564 _1806_ _3269_ VGND VGND VPWR VPWR _3275_ sky130_fd_sc_hd__mux2_1
X_7591_ clknet_leaf_23_clk _0640_ VGND VGND VPWR VPWR u_pe_array.u_fifo1.buffer\[2\]\[1\]
+ sky130_fd_sc_hd__dfxtp_1
XFILLER_0_55_661 VGND VGND VPWR VPWR sky130_fd_sc_hd__decap_3
XFILLER_0_15_503 VGND VGND VPWR VPWR sky130_fd_sc_hd__fill_1
XFILLER_0_27_330 VGND VGND VPWR VPWR sky130_fd_sc_hd__fill_2
XFILLER_0_54_182 VGND VGND VPWR VPWR sky130_fd_sc_hd__fill_2
X_6542_ _3237_ VGND VGND VPWR VPWR _0548_ sky130_fd_sc_hd__clkbuf_1
X_3754_ net674 _0875_ _0963_ _0964_ VGND VGND VPWR VPWR _0033_ sky130_fd_sc_hd__a22o_1
X_3685_ net667 _0875_ _0887_ _0901_ VGND VGND VPWR VPWR _0027_ sky130_fd_sc_hd__a22o_1
XFILLER_0_15_558 VGND VGND VPWR VPWR sky130_fd_sc_hd__fill_2
X_6473_ net316 _1808_ net67 VGND VGND VPWR VPWR _3201_ sky130_fd_sc_hd__mux2_1
XANTENNA__5763__D _2611_ VGND VGND VPWR VPWR sky130_fd_sc_hd__diode_2
XFILLER_0_40_73 VGND VGND VPWR VPWR sky130_fd_sc_hd__fill_2
X_5424_ u_pe_array.g_pe_row\[1\].g_pe_col\[1\].u_pe.psum_out\[1\] _2348_ VGND VGND
+ VPWR VPWR _2350_ sky130_fd_sc_hd__nand2_1
XFILLER_0_112_265 VPWR VGND VPWR VGND sky130_ef_sc_hd__decap_12
X_5355_ u_pe_array.u_fifo1.buffer\[4\]\[1\] _2279_ _2280_ u_pe_array.u_fifo1.buffer\[7\]\[1\]
+ VGND VGND VPWR VPWR _2294_ sky130_fd_sc_hd__a22o_1
XFILLER_0_57_3 VPWR VGND VPWR VGND sky130_ef_sc_hd__decap_12
XFILLER_0_10_230 VGND VGND VPWR VPWR sky130_fd_sc_hd__fill_2
X_5286_ _2232_ _2212_ _2218_ _2230_ VGND VGND VPWR VPWR _2233_ sky130_fd_sc_hd__a22o_1
X_4306_ u_pe_array.g_pe_row\[2\].g_pe_col\[3\].u_pe.w_reg\[0\] u_pe_array.g_pe_row\[2\].g_pe_col\[3\].u_pe.act_val\[1\]
+ _1410_ _1411_ VGND VGND VPWR VPWR _1413_ sky130_fd_sc_hd__nand4_1
X_4237_ _1354_ _1357_ _1362_ VGND VGND VPWR VPWR _1364_ sky130_fd_sc_hd__or3_1
X_7025_ clknet_leaf_78_clk _0102_ net74 VGND VGND VPWR VPWR u_pe_array.g_pe_row\[2\].g_pe_col\[3\].u_pe.move_reg\[7\]
+ sky130_fd_sc_hd__dfrtp_1
X_4168_ _1298_ _1300_ VGND VGND VPWR VPWR _1301_ sky130_fd_sc_hd__nor2_1
XANTENNA_clkbuf_leaf_4_clk_A clknet_3_0__leaf_clk VGND VGND VPWR VPWR sky130_fd_sc_hd__diode_2
XANTENNA__7132__RESET_B net816 VGND VGND VPWR VPWR sky130_fd_sc_hd__diode_2
X_4099_ _1241_ _1247_ _1250_ _1245_ VGND VGND VPWR VPWR _1251_ sky130_fd_sc_hd__a22oi_2
XANTENNA__3800__S _0745_ VGND VGND VPWR VPWR sky130_fd_sc_hd__diode_2
XANTENNA__4598__A2 _1524_ VGND VGND VPWR VPWR sky130_fd_sc_hd__diode_2
XFILLER_0_37_105 VGND VGND VPWR VPWR sky130_fd_sc_hd__decap_4
XFILLER_0_108_505 VPWR VGND VPWR VGND sky130_ef_sc_hd__decap_12
X_6809_ _3385_ VGND VGND VPWR VPWR _0667_ sky130_fd_sc_hd__clkbuf_1
XFILLER_0_92_288 VGND VGND VPWR VPWR sky130_fd_sc_hd__fill_2
XFILLER_0_60_141 VGND VGND VPWR VPWR sky130_fd_sc_hd__fill_1
XANTENNA__5028__A _1787_ VGND VGND VPWR VPWR sky130_fd_sc_hd__diode_2
XFILLER_0_33_366 VGND VGND VPWR VPWR sky130_fd_sc_hd__decap_3
XFILLER_0_21_539 VGND VGND VPWR VPWR sky130_fd_sc_hd__fill_2
XANTENNA__3490__B _0730_ VGND VGND VPWR VPWR sky130_fd_sc_hd__diode_2
XANTENNA__4286__B2 _1399_ VGND VGND VPWR VPWR sky130_fd_sc_hd__diode_2
XFILLER_0_88_517 VGND VGND VPWR VPWR sky130_fd_sc_hd__fill_2
XANTENNA__4806__S _0756_ VGND VGND VPWR VPWR sky130_fd_sc_hd__diode_2
XANTENNA__4589__A2 _1524_ VGND VGND VPWR VPWR sky130_fd_sc_hd__diode_2
XFILLER_0_68_230 VGND VGND VPWR VPWR sky130_fd_sc_hd__fill_2
XANTENNA__5786__B2 _0875_ VGND VGND VPWR VPWR sky130_fd_sc_hd__diode_2
XTAP_1440 VGND VPWR sky130_fd_sc_hd__tapvpwrvgnd_1
XTAP_1451 VGND VPWR sky130_fd_sc_hd__tapvpwrvgnd_1
XFILLER_0_96_583 VGND VGND VPWR VPWR sky130_fd_sc_hd__decap_4
XFILLER_0_68_274 VPWR VGND VPWR VGND sky130_ef_sc_hd__decap_12
XFILLER_0_61_39 VPWR VGND VPWR VGND sky130_ef_sc_hd__decap_12
XFILLER_0_29_617 VGND VGND VPWR VPWR sky130_fd_sc_hd__decap_3
XTAP_1484 VGND VPWR sky130_fd_sc_hd__tapvpwrvgnd_1
XTAP_1473 VGND VPWR sky130_fd_sc_hd__tapvpwrvgnd_1
XTAP_1462 VGND VPWR sky130_fd_sc_hd__tapvpwrvgnd_1
XTAP_1495 VGND VPWR sky130_fd_sc_hd__tapvpwrvgnd_1
XFILLER_0_44_609 VGND VGND VPWR VPWR sky130_fd_sc_hd__fill_2
XFILLER_0_43_108 VGND VGND VPWR VPWR sky130_fd_sc_hd__fill_2
XFILLER_0_64_491 VGND VGND VPWR VPWR sky130_fd_sc_hd__fill_2
XFILLER_0_36_182 VGND VGND VPWR VPWR sky130_fd_sc_hd__fill_2
X_3470_ u_pe_array.g_pe_row\[3\].g_pe_col\[0\].u_pe.act_val\[4\] u_pe_array.g_pe_row\[3\].g_pe_col\[0\].u_pe.psum_out\[4\]
+ _0730_ VGND VGND VPWR VPWR _0741_ sky130_fd_sc_hd__mux2_1
XANTENNA__4513__A2 _1152_ VGND VGND VPWR VPWR sky130_fd_sc_hd__diode_2
XFILLER_0_20_561 VGND VGND VPWR VPWR sky130_fd_sc_hd__decap_4
X_5140_ _2112_ _2113_ VGND VGND VPWR VPWR _2114_ sky130_fd_sc_hd__nor2_1
XFILLER_0_20_572 VGND VGND VPWR VPWR sky130_fd_sc_hd__fill_2
X_5071_ u_pe_array.g_pe_row\[1\].g_pe_col\[3\].u_pe.psum_out\[3\] _2050_ VGND VGND
+ VPWR VPWR _2051_ sky130_fd_sc_hd__xnor2_1
X_4022_ u_pe_array.g_pe_row\[3\].g_pe_col\[1\].u_pe.w_reg\[0\] u_pe_array.g_pe_row\[3\].g_pe_col\[1\].u_pe.act_val\[3\]
+ _1168_ _1181_ VGND VGND VPWR VPWR _1182_ sky130_fd_sc_hd__a31o_1
XANTENNA__3485__C1 _0728_ VGND VGND VPWR VPWR sky130_fd_sc_hd__diode_2
XANTENNA__6018__A2 _2387_ VGND VGND VPWR VPWR sky130_fd_sc_hd__diode_2
XANTENNA__5226__B1 _2158_ VGND VGND VPWR VPWR sky130_fd_sc_hd__diode_2
XANTENNA__3620__S _0755_ VGND VGND VPWR VPWR sky130_fd_sc_hd__diode_2
XFILLER_0_94_509 VGND VGND VPWR VPWR sky130_fd_sc_hd__decap_3
X_5973_ u_pe_array.g_pe_row\[0\].g_pe_col\[2\].u_pe.psum_out\[7\] VGND VGND VPWR VPWR
+ _2809_ sky130_fd_sc_hd__inv_2
X_4924_ _1912_ _1925_ _1926_ VGND VGND VPWR VPWR _1927_ sky130_fd_sc_hd__a21o_1
XANTENNA__4017__A _1145_ VGND VGND VPWR VPWR sky130_fd_sc_hd__diode_2
XANTENNA__5547__S _0828_ VGND VGND VPWR VPWR sky130_fd_sc_hd__diode_2
X_4855_ _1855_ _1859_ VGND VGND VPWR VPWR _1863_ sky130_fd_sc_hd__nor2_1
X_7643_ clknet_leaf_23_clk _0692_ VGND VGND VPWR VPWR u_pe_array.u_fifo1.buffer\[6\]\[1\]
+ sky130_fd_sc_hd__dfxtp_1
XFILLER_0_47_469 VGND VGND VPWR VPWR sky130_fd_sc_hd__fill_1
XFILLER_0_35_609 VGND VGND VPWR VPWR sky130_fd_sc_hd__fill_1
X_7574_ clknet_leaf_26_clk _0623_ VGND VGND VPWR VPWR u_pe_array.u_fifo1.buffer\[0\]\[10\]
+ sky130_fd_sc_hd__dfxtp_1
XANTENNA__4201__A1 _1275_ VGND VGND VPWR VPWR sky130_fd_sc_hd__diode_2
XFILLER_0_74_299 VGND VGND VPWR VPWR sky130_fd_sc_hd__decap_6
X_4786_ _1815_ VGND VGND VPWR VPWR _0214_ sky130_fd_sc_hd__clkbuf_1
X_3806_ u_pe_array.g_pe_row\[3\].g_pe_col\[2\].u_pe.psum_out\[9\] u_pe_array.g_pe_row\[3\].g_pe_col\[2\].u_pe.move_reg\[9\]
+ _0734_ VGND VGND VPWR VPWR _1002_ sky130_fd_sc_hd__mux2_1
X_3737_ _0948_ _0928_ _0934_ _0946_ VGND VGND VPWR VPWR _0949_ sky130_fd_sc_hd__a22o_1
X_6525_ net593 _1804_ _3224_ VGND VGND VPWR VPWR _3229_ sky130_fd_sc_hd__mux2_1
XFILLER_0_27_193 VGND VGND VPWR VPWR sky130_fd_sc_hd__decap_6
XFILLER_0_113_541 VPWR VGND VPWR VGND sky130_ef_sc_hd__decap_12
XFILLER_0_30_314 VGND VGND VPWR VPWR sky130_fd_sc_hd__fill_1
X_3668_ _0877_ _0883_ _0885_ VGND VGND VPWR VPWR _0886_ sky130_fd_sc_hd__o21a_1
X_6456_ net359 _1818_ net68 VGND VGND VPWR VPWR _3192_ sky130_fd_sc_hd__mux2_1
XFILLER_0_113_585 VPWR VGND VPWR VGND sky130_ef_sc_hd__decap_12
X_5407_ net112 _2144_ _2337_ _2336_ VGND VGND VPWR VPWR _0313_ sky130_fd_sc_hd__a22o_1
X_3599_ _0831_ VGND VGND VPWR VPWR _0832_ sky130_fd_sc_hd__clkbuf_8
X_6387_ net211 _3150_ _3151_ VGND VGND VPWR VPWR _0479_ sky130_fd_sc_hd__a21oi_1
X_5338_ u_pe_array.u_fifo1.rd_ptr\[1\] u_pe_array.u_fifo1.rd_ptr\[0\] _2277_ VGND
+ VGND VPWR VPWR _2278_ sky130_fd_sc_hd__and3b_2
XANTENNA__7384__RESET_B net13 VGND VGND VPWR VPWR sky130_fd_sc_hd__diode_2
X_5269_ _2196_ _2206_ _2207_ VGND VGND VPWR VPWR _2218_ sky130_fd_sc_hd__o21a_1
XANTENNA__7313__RESET_B net73 VGND VGND VPWR VPWR sky130_fd_sc_hd__diode_2
X_7008_ clknet_leaf_11_clk _0085_ net74 VGND VGND VPWR VPWR u_pe_array.g_pe_row\[3\].g_pe_col\[1\].u_pe.psum_out\[5\]
+ sky130_fd_sc_hd__dfrtp_2
XFILLER_0_85_509 VGND VGND VPWR VPWR sky130_fd_sc_hd__fill_2
XANTENNA__3491__A2 _0745_ VGND VGND VPWR VPWR sky130_fd_sc_hd__diode_2
XFILLER_0_78_561 VGND VGND VPWR VPWR sky130_fd_sc_hd__decap_4
XFILLER_0_93_531 VGND VGND VPWR VPWR sky130_fd_sc_hd__fill_2
XANTENNA__4440__B2 _1399_ VGND VGND VPWR VPWR sky130_fd_sc_hd__diode_2
XFILLER_0_38_436 VGND VGND VPWR VPWR sky130_fd_sc_hd__fill_1
XFILLER_0_93_553 VGND VGND VPWR VPWR sky130_fd_sc_hd__decap_6
XFILLER_0_19_661 VGND VGND VPWR VPWR sky130_fd_sc_hd__decap_8
XFILLER_0_108_346 VGND VGND VPWR VPWR sky130_fd_sc_hd__decap_3
XFILLER_0_108_335 VGND VGND VPWR VPWR sky130_fd_sc_hd__fill_2
XANTENNA__6142__A _2873_ VGND VGND VPWR VPWR sky130_fd_sc_hd__diode_2
XFILLER_0_65_288 VGND VGND VPWR VPWR sky130_fd_sc_hd__decap_6
XFILLER_0_104_530 VGND VGND VPWR VPWR sky130_fd_sc_hd__fill_2
XFILLER_0_34_664 VGND VGND VPWR VPWR sky130_fd_sc_hd__fill_1
XTAP_509 VGND VPWR sky130_fd_sc_hd__tapvpwrvgnd_1
XANTENNA__5205__B _2158_ VGND VGND VPWR VPWR sky130_fd_sc_hd__diode_2
XANTENNA__4259__A1 _1273_ VGND VGND VPWR VPWR sky130_fd_sc_hd__diode_2
XANTENNA__7054__RESET_B net819 VGND VGND VPWR VPWR sky130_fd_sc_hd__diode_2
XFILLER_0_72_27 VGND VGND VPWR VPWR sky130_fd_sc_hd__fill_1
XFILLER_0_69_561 VGND VGND VPWR VPWR sky130_fd_sc_hd__decap_4
XFILLER_0_96_380 VGND VGND VPWR VPWR sky130_fd_sc_hd__fill_1
XTAP_1292 VGND VPWR sky130_fd_sc_hd__tapvpwrvgnd_1
XTAP_1270 VGND VPWR sky130_fd_sc_hd__tapvpwrvgnd_1
XTAP_1281 VGND VPWR sky130_fd_sc_hd__tapvpwrvgnd_1
X_4640_ _1679_ _1685_ _1688_ VGND VGND VPWR VPWR _1689_ sky130_fd_sc_hd__a21o_1
XFILLER_0_71_225 VGND VGND VPWR VPWR sky130_fd_sc_hd__decap_6
XANTENNA__4271__S _0770_ VGND VGND VPWR VPWR sky130_fd_sc_hd__diode_2
XFILLER_0_25_620 VGND VGND VPWR VPWR sky130_fd_sc_hd__fill_2
XFILLER_0_112_77 VGND VGND VPWR VPWR sky130_fd_sc_hd__decap_6
XANTENNA__4195__B1 _0885_ VGND VGND VPWR VPWR sky130_fd_sc_hd__diode_2
XFILLER_0_4_525 VGND VGND VPWR VPWR sky130_fd_sc_hd__decap_6
XFILLER_0_21_53 VGND VGND VPWR VPWR sky130_fd_sc_hd__decap_3
XFILLER_0_25_642 VGND VGND VPWR VPWR sky130_fd_sc_hd__fill_2
XFILLER_0_37_480 VGND VGND VPWR VPWR sky130_fd_sc_hd__fill_2
X_6310_ u_pe_array.g_pe_row\[0\].g_pe_col\[0\].u_pe.psum_out\[11\] _3096_ _3087_ VGND
+ VGND VPWR VPWR _3097_ sky130_fd_sc_hd__mux2_1
X_4571_ _1638_ _1639_ VGND VGND VPWR VPWR _1640_ sky130_fd_sc_hd__or2_1
XFILLER_0_40_601 VGND VGND VPWR VPWR sky130_fd_sc_hd__fill_1
X_3522_ u_pe_array.g_pe_row\[1\].g_pe_col\[0\].u_pe.psum_out\[9\] _0769_ _0774_ _0754_
+ VGND VGND VPWR VPWR net48 sky130_fd_sc_hd__o211a_1
Xhold705 u_pe_array.g_pe_row\[1\].g_pe_col\[1\].u_pe.act_val\[3\] VGND VGND VPWR VPWR
+ net781 sky130_fd_sc_hd__dlygate4sd3_1
X_7290_ clknet_leaf_58_clk _0349_ net813 VGND VGND VPWR VPWR u_pe_array.g_pe_row\[1\].g_pe_col\[0\].u_pe.psum_out\[4\]
+ sky130_fd_sc_hd__dfrtp_1
XFILLER_0_52_494 VGND VGND VPWR VPWR sky130_fd_sc_hd__fill_2
Xhold727 _2139_ VGND VGND VPWR VPWR net803 sky130_fd_sc_hd__dlygate4sd3_1
XFILLER_0_12_325 VPWR VGND VPWR VGND sky130_ef_sc_hd__decap_12
XFILLER_0_4_569 VPWR VGND VPWR VGND sky130_ef_sc_hd__decap_12
Xhold716 u_pe_array.g_pe_row\[2\].g_pe_col\[3\].u_pe.psum_out\[10\] VGND VGND VPWR
+ VPWR net792 sky130_fd_sc_hd__dlygate4sd3_1
XFILLER_0_40_645 VGND VGND VPWR VPWR sky130_fd_sc_hd__fill_2
XFILLER_0_110_533 VPWR VGND VPWR VGND sky130_ef_sc_hd__decap_12
X_6241_ _3032_ _3033_ VGND VGND VPWR VPWR _3035_ sky130_fd_sc_hd__or2_1
X_3453_ _0727_ VGND VGND VPWR VPWR _0728_ sky130_fd_sc_hd__buf_4
Xhold738 u_pe_array.g_pe_row\[0\].g_pe_col\[3\].u_pe.act_val\[3\] VGND VGND VPWR VPWR
+ net822 sky130_fd_sc_hd__dlygate4sd3_1
X_6172_ _2873_ u_pe_array.g_pe_row\[0\].g_pe_col\[1\].u_pe.psum_out\[11\] VGND VGND
+ VPWR VPWR _2976_ sky130_fd_sc_hd__and2b_1
XANTENNA__3615__S _0819_ VGND VGND VPWR VPWR sky130_fd_sc_hd__diode_2
X_5123_ _1725_ _2097_ _2098_ _2071_ u_pe_array.g_pe_row\[1\].g_pe_col\[3\].u_pe.psum_out\[7\]
+ VGND VGND VPWR VPWR _0268_ sky130_fd_sc_hd__a32o_1
XFILLER_0_46_61 VGND VGND VPWR VPWR sky130_fd_sc_hd__fill_2
X_5054_ _1725_ _2034_ _2035_ _1534_ net589 VGND VGND VPWR VPWR _0262_ sky130_fd_sc_hd__a32o_1
X_4005_ u_pe_array.g_pe_row\[3\].g_pe_col\[1\].u_pe.w_reg\[0\] u_pe_array.g_pe_row\[3\].g_pe_col\[1\].u_pe.act_val\[3\]
+ VGND VGND VPWR VPWR _1166_ sky130_fd_sc_hd__nand2_1
XFILLER_0_46_72 VGND VGND VPWR VPWR sky130_fd_sc_hd__fill_1
XANTENNA__5131__A _2029_ VGND VGND VPWR VPWR sky130_fd_sc_hd__diode_2
XFILLER_0_87_380 VGND VGND VPWR VPWR sky130_fd_sc_hd__fill_1
X_5956_ _2783_ _2784_ _2781_ VGND VGND VPWR VPWR _2794_ sky130_fd_sc_hd__o21ai_1
X_4907_ _1902_ _1904_ VGND VGND VPWR VPWR _1911_ sky130_fd_sc_hd__and2b_1
X_5887_ net145 _2600_ _2734_ _0722_ VGND VGND VPWR VPWR _0396_ sky130_fd_sc_hd__a22o_1
XFILLER_0_47_244 VGND VGND VPWR VPWR sky130_fd_sc_hd__fill_2
X_7626_ clknet_leaf_30_clk _0675_ VGND VGND VPWR VPWR u_pe_array.u_fifo1.buffer\[4\]\[10\]
+ sky130_fd_sc_hd__dfxtp_1
X_4838_ u_pe_array.g_pe_row\[2\].g_pe_col\[0\].u_pe.act_val\[0\] _1847_ VGND VGND
+ VPWR VPWR _1848_ sky130_fd_sc_hd__nand2_1
XFILLER_0_16_653 VPWR VGND VPWR VGND sky130_ef_sc_hd__decap_12
XFILLER_0_90_589 VGND VGND VPWR VPWR sky130_fd_sc_hd__fill_2
X_7557_ clknet_leaf_18_clk _0606_ net816 VGND VGND VPWR VPWR u_pe_array.u_fifo1.rd_ptr\[1\]
+ sky130_fd_sc_hd__dfrtp_4
XFILLER_0_15_152 VPWR VGND VPWR VGND sky130_ef_sc_hd__decap_12
X_4769_ _1787_ _0846_ _0994_ _0747_ VGND VGND VPWR VPWR _1804_ sky130_fd_sc_hd__a22o_2
XFILLER_0_31_601 VGND VGND VPWR VPWR sky130_fd_sc_hd__fill_2
XFILLER_0_70_280 VGND VGND VPWR VPWR sky130_fd_sc_hd__decap_8
X_6508_ net344 _1816_ _3208_ VGND VGND VPWR VPWR _3219_ sky130_fd_sc_hd__mux2_1
X_7488_ clknet_leaf_2_clk _0537_ VGND VGND VPWR VPWR u_pe_array.u_fifo2.buffer\[4\]\[1\]
+ sky130_fd_sc_hd__dfxtp_1
X_6439_ _3183_ VGND VGND VPWR VPWR _0499_ sky130_fd_sc_hd__clkbuf_1
XFILLER_0_113_393 VPWR VGND VPWR VGND sky130_ef_sc_hd__decap_12
XFILLER_0_11_391 VGND VGND VPWR VPWR sky130_fd_sc_hd__fill_1
Xhold32 u_pe_array.g_pe_row\[0\].g_pe_col\[1\].u_pe.w_buffer\[0\] VGND VGND VPWR VPWR
+ net108 sky130_fd_sc_hd__dlygate4sd3_1
Xhold21 u_pe_array.g_pe_row\[0\].g_pe_col\[0\].u_pe.w_buffer\[0\] VGND VGND VPWR VPWR
+ net97 sky130_fd_sc_hd__dlygate4sd3_1
XANTENNA__6836__S _3397_ VGND VGND VPWR VPWR sky130_fd_sc_hd__diode_2
Xhold10 u_pe_array.g_pe_row\[0\].g_pe_col\[2\].u_pe.w_buffer\[1\] VGND VGND VPWR VPWR
+ net86 sky130_fd_sc_hd__dlygate4sd3_1
Xhold43 u_pe_array.g_pe_row\[3\].g_pe_col\[0\].u_pe.move_reg\[6\] VGND VGND VPWR VPWR
+ net119 sky130_fd_sc_hd__dlygate4sd3_1
Xhold54 u_pe_array.g_pe_row\[2\].g_pe_col\[2\].u_pe.move_reg\[10\] VGND VGND VPWR
+ VPWR net130 sky130_fd_sc_hd__dlygate4sd3_1
Xhold65 u_pe_array.g_pe_row\[3\].g_pe_col\[2\].u_pe.move_reg\[11\] VGND VGND VPWR
+ VPWR net141 sky130_fd_sc_hd__dlygate4sd3_1
Xhold87 _0400_ VGND VGND VPWR VPWR net163 sky130_fd_sc_hd__dlygate4sd3_1
Xhold76 u_pe_array.g_pe_row\[0\].g_pe_col\[2\].u_pe.move_reg\[12\] VGND VGND VPWR
+ VPWR net152 sky130_fd_sc_hd__dlygate4sd3_1
Xhold98 u_pe_array.g_pe_row\[0\].g_pe_col\[2\].u_pe.move_reg\[10\] VGND VGND VPWR
+ VPWR net174 sky130_fd_sc_hd__dlygate4sd3_1
XANTENNA__4110__B1 _0837_ VGND VGND VPWR VPWR sky130_fd_sc_hd__diode_2
XFILLER_0_38_200 VGND VGND VPWR VPWR sky130_fd_sc_hd__fill_2
XFILLER_0_66_553 VGND VGND VPWR VPWR sky130_fd_sc_hd__fill_2
XFILLER_0_93_372 VGND VGND VPWR VPWR sky130_fd_sc_hd__fill_1
XANTENNA__5187__S _1661_ VGND VGND VPWR VPWR sky130_fd_sc_hd__diode_2
XANTENNA__3496__A _0754_ VGND VGND VPWR VPWR sky130_fd_sc_hd__diode_2
XFILLER_0_53_203 VGND VGND VPWR VPWR sky130_fd_sc_hd__fill_1
XFILLER_0_81_545 VGND VGND VPWR VPWR sky130_fd_sc_hd__fill_1
XANTENNA_clkbuf_leaf_91_clk_A clknet_3_1__leaf_clk VGND VGND VPWR VPWR sky130_fd_sc_hd__diode_2
XFILLER_0_1_517 VGND VGND VPWR VPWR sky130_fd_sc_hd__fill_2
XFILLER_0_22_645 VGND VGND VPWR VPWR sky130_fd_sc_hd__fill_2
XFILLER_0_104_360 VGND VGND VPWR VPWR sky130_fd_sc_hd__fill_2
XFILLER_0_22_667 VGND VGND VPWR VPWR sky130_fd_sc_hd__fill_2
XFILLER_0_67_27 VPWR VGND VPWR VGND sky130_ef_sc_hd__decap_12
XANTENNA__7235__RESET_B net812 VGND VGND VPWR VPWR sky130_fd_sc_hd__diode_2
XTAP_306 VGND VPWR sky130_fd_sc_hd__tapvpwrvgnd_1
XTAP_339 VGND VPWR sky130_fd_sc_hd__tapvpwrvgnd_1
XTAP_317 VGND VPWR sky130_fd_sc_hd__tapvpwrvgnd_1
XTAP_328 VGND VPWR sky130_fd_sc_hd__tapvpwrvgnd_1
XFILLER_0_83_15 VPWR VGND VPWR VGND sky130_ef_sc_hd__decap_12
XFILLER_0_107_55 VGND VGND VPWR VPWR sky130_fd_sc_hd__fill_1
XFILLER_0_88_166 VGND VGND VPWR VPWR sky130_fd_sc_hd__fill_2
XFILLER_0_76_317 VGND VGND VPWR VPWR sky130_fd_sc_hd__fill_2
XFILLER_0_16_64 VGND VGND VPWR VPWR sky130_fd_sc_hd__fill_1
X_6790_ _3374_ VGND VGND VPWR VPWR _0659_ sky130_fd_sc_hd__clkbuf_1
XANTENNA_clkbuf_leaf_44_clk_A clknet_3_6__leaf_clk VGND VGND VPWR VPWR sky130_fd_sc_hd__diode_2
XFILLER_0_9_617 VPWR VGND VPWR VGND sky130_ef_sc_hd__decap_12
XFILLER_0_16_97 VGND VGND VPWR VPWR sky130_fd_sc_hd__decap_4
X_5810_ _2672_ _2673_ _2671_ VGND VGND VPWR VPWR _2675_ sky130_fd_sc_hd__o21a_1
XFILLER_0_91_309 VGND VGND VPWR VPWR sky130_fd_sc_hd__decap_8
XFILLER_0_57_542 VGND VGND VPWR VPWR sky130_fd_sc_hd__decap_8
XFILLER_0_29_244 VGND VGND VPWR VPWR sky130_fd_sc_hd__fill_2
X_5741_ u_pe_array.g_pe_row\[0\].g_pe_col\[3\].u_pe.w_reg\[1\] VGND VGND VPWR VPWR
+ _2611_ sky130_fd_sc_hd__clkbuf_8
XFILLER_0_84_350 VGND VGND VPWR VPWR sky130_fd_sc_hd__fill_2
XFILLER_0_29_266 VGND VGND VPWR VPWR sky130_fd_sc_hd__fill_2
XANTENNA__6157__A1 _2740_ VGND VGND VPWR VPWR sky130_fd_sc_hd__diode_2
X_7411_ clknet_leaf_27_clk _0460_ VGND VGND VPWR VPWR u_pe_array.u_fifo1.buffer\[8\]\[1\]
+ sky130_fd_sc_hd__dfxtp_1
X_5672_ _2553_ _2555_ _2556_ _2562_ VGND VGND VPWR VPWR _2563_ sky130_fd_sc_hd__a31oi_2
XFILLER_0_44_225 VGND VGND VPWR VPWR sky130_fd_sc_hd__fill_2
XFILLER_0_17_439 VGND VGND VPWR VPWR sky130_fd_sc_hd__fill_1
XFILLER_0_114_113 VGND VGND VPWR VPWR sky130_fd_sc_hd__decap_3
X_4623_ _1671_ _1673_ VGND VGND VPWR VPWR _1674_ sky130_fd_sc_hd__xor2_1
XANTENNA_clkbuf_leaf_59_clk_A clknet_3_6__leaf_clk VGND VGND VPWR VPWR sky130_fd_sc_hd__diode_2
XFILLER_0_44_258 VGND VGND VPWR VPWR sky130_fd_sc_hd__decap_3
XFILLER_0_4_333 VGND VGND VPWR VPWR sky130_fd_sc_hd__decap_3
Xhold502 u_pe_array.g_pe_row\[1\].g_pe_col\[0\].u_pe.psum_out\[10\] VGND VGND VPWR
+ VPWR net578 sky130_fd_sc_hd__dlygate4sd3_1
XANTENNA__5380__A2 _2314_ VGND VGND VPWR VPWR sky130_fd_sc_hd__diode_2
X_7342_ clknet_leaf_51_clk net169 net812 VGND VGND VPWR VPWR u_pe_array.g_pe_row\[0\].g_pe_col\[1\].u_pe.move_reg\[11\]
+ sky130_fd_sc_hd__dfrtp_1
X_4554_ _1615_ _1618_ _1623_ VGND VGND VPWR VPWR _1625_ sky130_fd_sc_hd__or3_1
X_3505_ _0754_ _0763_ VGND VGND VPWR VPWR _0764_ sky130_fd_sc_hd__and2_2
Xhold535 u_pe_array.g_pe_row\[2\].g_pe_col\[3\].u_pe.act_val\[2\] VGND VGND VPWR VPWR
+ net611 sky130_fd_sc_hd__dlygate4sd3_1
Xhold513 u_pe_array.g_pe_row\[1\].g_pe_col\[3\].u_pe.psum_out\[1\] VGND VGND VPWR
+ VPWR net589 sky130_fd_sc_hd__dlygate4sd3_1
Xhold524 u_pe_array.u_fifo2.buffer\[4\]\[1\] VGND VGND VPWR VPWR net600 sky130_fd_sc_hd__dlygate4sd3_1
X_7273_ clknet_leaf_74_clk _0334_ net814 VGND VGND VPWR VPWR u_pe_array.g_pe_row\[0\].g_pe_col\[3\].u_pe.act_val\[2\]
+ sky130_fd_sc_hd__dfrtp_2
XFILLER_0_40_453 VGND VGND VPWR VPWR sky130_fd_sc_hd__fill_2
X_6224_ _3010_ _3011_ _3017_ VGND VGND VPWR VPWR _3019_ sky130_fd_sc_hd__o21ai_1
Xhold557 u_pe_array.g_pe_row\[1\].g_pe_col\[1\].u_pe.psum_out\[3\] VGND VGND VPWR
+ VPWR net633 sky130_fd_sc_hd__dlygate4sd3_1
Xhold546 u_pe_array.g_pe_row\[2\].g_pe_col\[1\].u_pe.act_val\[1\] VGND VGND VPWR VPWR
+ net622 sky130_fd_sc_hd__dlygate4sd3_1
Xhold568 u_pe_array.g_pe_row\[1\].g_pe_col\[2\].u_pe.psum_out\[2\] VGND VGND VPWR
+ VPWR net644 sky130_fd_sc_hd__dlygate4sd3_1
X_4485_ _1559_ _1561_ VGND VGND VPWR VPWR _1562_ sky130_fd_sc_hd__nor2_1
Xhold579 u_pe_array.g_pe_row\[0\].g_pe_col\[3\].u_pe.psum_out\[9\] VGND VGND VPWR
+ VPWR net655 sky130_fd_sc_hd__dlygate4sd3_1
XFILLER_0_40_475 VGND VGND VPWR VPWR sky130_fd_sc_hd__fill_1
XFILLER_0_40_497 VGND VGND VPWR VPWR sky130_fd_sc_hd__fill_2
XFILLER_0_0_561 VGND VGND VPWR VPWR sky130_fd_sc_hd__decap_8
X_6155_ _2952_ _2955_ _2960_ VGND VGND VPWR VPWR _2961_ sky130_fd_sc_hd__o21ai_1
XTAP_862 VGND VPWR sky130_fd_sc_hd__tapvpwrvgnd_1
XTAP_851 VGND VPWR sky130_fd_sc_hd__tapvpwrvgnd_1
XTAP_840 VGND VPWR sky130_fd_sc_hd__tapvpwrvgnd_1
XANTENNA__5560__S _0745_ VGND VGND VPWR VPWR sky130_fd_sc_hd__diode_2
X_6086_ u_pe_array.g_pe_row\[0\].g_pe_col\[1\].u_pe.psum_out\[2\] _2884_ _2897_ VGND
+ VGND VPWR VPWR _2898_ sky130_fd_sc_hd__a21oi_1
XANTENNA__6958__RESET_B net816 VGND VGND VPWR VPWR sky130_fd_sc_hd__diode_2
XTAP_895 VGND VPWR sky130_fd_sc_hd__tapvpwrvgnd_1
XTAP_873 VGND VPWR sky130_fd_sc_hd__tapvpwrvgnd_1
XTAP_884 VGND VPWR sky130_fd_sc_hd__tapvpwrvgnd_1
X_5106_ _2076_ _2080_ VGND VGND VPWR VPWR _2083_ sky130_fd_sc_hd__nor2_1
X_5037_ net265 _1666_ _2023_ _1665_ VGND VGND VPWR VPWR _0257_ sky130_fd_sc_hd__a22o_1
XANTENNA__6632__A2 _2738_ VGND VGND VPWR VPWR sky130_fd_sc_hd__diode_2
XFILLER_0_79_155 VGND VGND VPWR VPWR sky130_fd_sc_hd__fill_2
XFILLER_0_67_317 VGND VGND VPWR VPWR sky130_fd_sc_hd__decap_3
X_6988_ clknet_leaf_28_clk _0067_ net817 VGND VGND VPWR VPWR u_pe_array.g_pe_row\[3\].g_pe_col\[0\].u_pe.act_val\[0\]
+ sky130_fd_sc_hd__dfrtp_2
X_5939_ u_pe_array.g_pe_row\[0\].g_pe_col\[2\].u_pe.act_val\[4\] u_pe_array.g_pe_row\[0\].g_pe_col\[2\].u_pe.w_reg\[0\]
+ _2775_ _2776_ VGND VGND VPWR VPWR _2778_ sky130_fd_sc_hd__o2bb2a_1
XFILLER_0_90_331 VGND VGND VPWR VPWR sky130_fd_sc_hd__fill_1
XFILLER_0_106_625 VPWR VGND VPWR VGND sky130_ef_sc_hd__decap_12
X_7609_ clknet_leaf_27_clk _0658_ VGND VGND VPWR VPWR u_pe_array.u_fifo1.buffer\[3\]\[6\]
+ sky130_fd_sc_hd__dfxtp_1
XFILLER_0_90_353 VGND VGND VPWR VPWR sky130_fd_sc_hd__decap_8
XFILLER_0_7_182 VGND VGND VPWR VPWR sky130_fd_sc_hd__decap_4
XFILLER_0_16_461 VGND VGND VPWR VPWR sky130_fd_sc_hd__fill_2
XFILLER_0_106_669 VGND VGND VPWR VPWR sky130_fd_sc_hd__decap_8
XANTENNA__5371__A2 _2306_ VGND VGND VPWR VPWR sky130_fd_sc_hd__diode_2
XFILLER_0_101_330 VGND VGND VPWR VPWR sky130_fd_sc_hd__decap_6
XFILLER_0_31_497 VGND VGND VPWR VPWR sky130_fd_sc_hd__decap_6
Xoutput55 net55 VGND VGND VPWR VPWR psum_out1[3] sky130_fd_sc_hd__clkbuf_4
XFILLER_0_9_3 VGND VGND VPWR VPWR sky130_fd_sc_hd__fill_2
Xoutput44 net44 VGND VGND VPWR VPWR psum_out0[5] sky130_fd_sc_hd__clkbuf_4
XANTENNA__4331__B1 _1144_ VGND VGND VPWR VPWR sky130_fd_sc_hd__diode_2
XANTENNA__4882__B2 _0916_ VGND VGND VPWR VPWR sky130_fd_sc_hd__diode_2
XANTENNA__3685__A2 _0875_ VGND VGND VPWR VPWR sky130_fd_sc_hd__diode_2
XANTENNA_input23_A v_in1[2] VGND VGND VPWR VPWR sky130_fd_sc_hd__diode_2
XFILLER_0_98_431 VGND VGND VPWR VPWR sky130_fd_sc_hd__fill_2
XANTENNA_clkbuf_3_1__f_clk_A clknet_0_clk VGND VGND VPWR VPWR sky130_fd_sc_hd__diode_2
XFILLER_0_58_339 VGND VGND VPWR VPWR sky130_fd_sc_hd__decap_3
XFILLER_0_85_136 VGND VGND VPWR VPWR sky130_fd_sc_hd__decap_3
XFILLER_0_39_531 VGND VGND VPWR VPWR sky130_fd_sc_hd__decap_3
XFILLER_0_85_169 VGND VGND VPWR VPWR sky130_fd_sc_hd__fill_2
XPHY_161 VGND VGND VPWR VPWR sky130_fd_sc_hd__decap_3
XPHY_150 VGND VGND VPWR VPWR sky130_fd_sc_hd__decap_3
XFILLER_0_54_512 VPWR VGND VPWR VGND sky130_ef_sc_hd__decap_12
XPHY_194 VGND VGND VPWR VPWR sky130_fd_sc_hd__decap_3
XPHY_183 VGND VGND VPWR VPWR sky130_fd_sc_hd__decap_3
XPHY_172 VGND VGND VPWR VPWR sky130_fd_sc_hd__decap_3
XFILLER_0_26_236 VGND VGND VPWR VPWR sky130_fd_sc_hd__fill_1
XFILLER_0_54_578 VGND VGND VPWR VPWR sky130_fd_sc_hd__decap_3
XFILLER_0_54_567 VGND VGND VPWR VPWR sky130_fd_sc_hd__fill_2
XFILLER_0_81_397 VGND VGND VPWR VPWR sky130_fd_sc_hd__decap_4
XFILLER_0_78_15 VPWR VGND VPWR VGND sky130_ef_sc_hd__decap_12
XFILLER_0_111_105 VGND VGND VPWR VPWR sky130_fd_sc_hd__fill_2
XANTENNA__5362__A2 _2298_ VGND VGND VPWR VPWR sky130_fd_sc_hd__diode_2
XFILLER_0_78_37 VGND VGND VPWR VPWR sky130_fd_sc_hd__fill_1
XFILLER_0_1_325 VGND VGND VPWR VPWR sky130_fd_sc_hd__decap_8
XFILLER_0_22_475 VGND VGND VPWR VPWR sky130_fd_sc_hd__fill_1
X_4270_ net641 _1138_ _1258_ _1390_ VGND VGND VPWR VPWR _0123_ sky130_fd_sc_hd__a22o_1
XFILLER_0_22_497 VGND VGND VPWR VPWR sky130_fd_sc_hd__fill_2
XANTENNA__6075__B1 _0885_ VGND VGND VPWR VPWR sky130_fd_sc_hd__diode_2
XFILLER_0_89_475 VGND VGND VPWR VPWR sky130_fd_sc_hd__fill_2
XFILLER_0_89_453 VGND VGND VPWR VPWR sky130_fd_sc_hd__decap_3
XFILLER_0_77_615 VGND VGND VPWR VPWR sky130_fd_sc_hd__fill_1
X_6911_ _3439_ VGND VGND VPWR VPWR _0715_ sky130_fd_sc_hd__clkbuf_1
X_6842_ net453 _3120_ _3397_ VGND VGND VPWR VPWR _3403_ sky130_fd_sc_hd__mux2_1
XFILLER_0_77_626 VGND VGND VPWR VPWR sky130_fd_sc_hd__decap_3
X_6773_ _3365_ VGND VGND VPWR VPWR _0651_ sky130_fd_sc_hd__clkbuf_1
XFILLER_0_76_169 VGND VGND VPWR VPWR sky130_fd_sc_hd__decap_4
X_3985_ _1143_ _1146_ _1147_ VGND VGND VPWR VPWR _1148_ sky130_fd_sc_hd__or3_1
XFILLER_0_64_309 VGND VGND VPWR VPWR sky130_fd_sc_hd__fill_2
XFILLER_0_9_436 VGND VGND VPWR VPWR sky130_fd_sc_hd__fill_1
XFILLER_0_17_203 VGND VGND VPWR VPWR sky130_fd_sc_hd__decap_3
XFILLER_0_17_214 VGND VGND VPWR VPWR sky130_fd_sc_hd__decap_8
XFILLER_0_17_225 VGND VGND VPWR VPWR sky130_fd_sc_hd__fill_2
X_5724_ u_pe_array.g_pe_row\[0\].g_pe_col\[3\].u_pe.psum_out\[7\] u_pe_array.g_pe_row\[0\].g_pe_col\[3\].u_pe.move_reg\[7\]
+ _2469_ VGND VGND VPWR VPWR _2601_ sky130_fd_sc_hd__mux2_1
X_5655_ _2545_ _2546_ VGND VGND VPWR VPWR _2547_ sky130_fd_sc_hd__and2_1
XFILLER_0_87_3 VPWR VGND VPWR VGND sky130_ef_sc_hd__decap_12
XFILLER_0_60_548 VGND VGND VPWR VPWR sky130_fd_sc_hd__fill_2
XFILLER_0_60_526 VGND VGND VPWR VPWR sky130_fd_sc_hd__fill_2
X_4606_ u_pe_array.g_pe_row\[2\].g_pe_col\[1\].u_pe.psum_out\[9\] net209 _1661_ VGND
+ VGND VPWR VPWR _1662_ sky130_fd_sc_hd__mux2_1
XFILLER_0_5_653 VPWR VGND VPWR VGND sky130_ef_sc_hd__decap_12
XFILLER_0_4_141 VPWR VGND VPWR VGND sky130_ef_sc_hd__decap_12
XANTENNA__7157__RESET_B net814 VGND VGND VPWR VPWR sky130_fd_sc_hd__diode_2
XFILLER_0_103_617 VPWR VGND VPWR VGND sky130_ef_sc_hd__decap_12
XANTENNA__5353__A2 _2290_ VGND VGND VPWR VPWR sky130_fd_sc_hd__diode_2
X_5586_ u_pe_array.g_pe_row\[1\].g_pe_col\[0\].u_pe.act_val\[1\] u_pe_array.g_pe_row\[1\].g_pe_col\[0\].u_pe.w_reg\[0\]
+ _2481_ _2482_ VGND VGND VPWR VPWR _2484_ sky130_fd_sc_hd__nand4_1
Xhold310 u_pe_array.g_pe_row\[2\].g_pe_col\[1\].u_pe.psum_out\[6\] VGND VGND VPWR
+ VPWR net386 sky130_fd_sc_hd__dlygate4sd3_1
XFILLER_0_13_453 VGND VGND VPWR VPWR sky130_fd_sc_hd__decap_3
X_7325_ clknet_leaf_67_clk _0382_ net13 VGND VGND VPWR VPWR u_pe_array.g_pe_row\[0\].g_pe_col\[3\].u_pe.psum_out\[9\]
+ sky130_fd_sc_hd__dfrtp_1
Xhold343 _0390_ VGND VGND VPWR VPWR net419 sky130_fd_sc_hd__dlygate4sd3_1
Xhold321 u_pe_array.g_pe_row\[3\].g_pe_col\[1\].u_pe.psum_out\[4\] VGND VGND VPWR
+ VPWR net397 sky130_fd_sc_hd__dlygate4sd3_1
XFILLER_0_7_51 VGND VGND VPWR VPWR sky130_fd_sc_hd__decap_3
X_4537_ u_pe_array.g_pe_row\[2\].g_pe_col\[2\].u_pe.psum_out\[7\] VGND VGND VPWR VPWR
+ _1609_ sky130_fd_sc_hd__inv_2
Xhold332 u_pe_array.g_pe_row\[1\].g_pe_col\[3\].u_pe.psum_out\[0\] VGND VGND VPWR
+ VPWR net408 sky130_fd_sc_hd__dlygate4sd3_1
XFILLER_0_40_272 VGND VGND VPWR VPWR sky130_fd_sc_hd__fill_2
Xhold387 u_pe_array.u_fifo1.buffer\[6\]\[5\] VGND VGND VPWR VPWR net463 sky130_fd_sc_hd__dlygate4sd3_1
XFILLER_0_68_81 VGND VGND VPWR VPWR sky130_fd_sc_hd__decap_3
X_7256_ clknet_leaf_54_clk _0317_ net75 VGND VGND VPWR VPWR u_pe_array.g_pe_row\[1\].g_pe_col\[1\].u_pe.psum_out\[0\]
+ sky130_fd_sc_hd__dfrtp_1
X_4468_ u_pe_array.g_pe_row\[2\].g_pe_col\[2\].u_pe.w_reg\[0\] u_pe_array.g_pe_row\[2\].g_pe_col\[2\].u_pe.act_val\[2\]
+ VGND VGND VPWR VPWR _1546_ sky130_fd_sc_hd__nand2_1
XANTENNA__5105__A2 _1714_ VGND VGND VPWR VPWR sky130_fd_sc_hd__diode_2
Xhold376 u_pe_array.u_fifo2.buffer\[1\]\[4\] VGND VGND VPWR VPWR net452 sky130_fd_sc_hd__dlygate4sd3_1
Xhold365 u_pe_array.u_fifo2.buffer\[2\]\[2\] VGND VGND VPWR VPWR net441 sky130_fd_sc_hd__dlygate4sd3_1
Xhold354 u_pe_array.g_pe_row\[2\].g_pe_col\[3\].u_pe.psum_out\[12\] VGND VGND VPWR
+ VPWR net430 sky130_fd_sc_hd__dlygate4sd3_1
X_6207_ u_pe_array.g_pe_row\[0\].g_pe_col\[0\].u_pe.act_val\[0\] VGND VGND VPWR VPWR
+ _3003_ sky130_fd_sc_hd__inv_2
XANTENNA__4695__A _1672_ VGND VGND VPWR VPWR sky130_fd_sc_hd__diode_2
X_7187_ clknet_leaf_64_clk net202 net73 VGND VGND VPWR VPWR u_pe_array.g_pe_row\[1\].g_pe_col\[2\].u_pe.move_reg\[6\]
+ sky130_fd_sc_hd__dfrtp_1
XANTENNA__4313__B1 _1407_ VGND VGND VPWR VPWR sky130_fd_sc_hd__diode_2
Xhold398 u_pe_array.g_pe_row\[3\].g_pe_col\[3\].u_pe.psum_out\[12\] VGND VGND VPWR
+ VPWR net474 sky130_fd_sc_hd__dlygate4sd3_1
XFILLER_0_110_193 VGND VGND VPWR VPWR sky130_fd_sc_hd__decap_3
X_6138_ _2903_ _2912_ _2943_ _2944_ VGND VGND VPWR VPWR _2945_ sky130_fd_sc_hd__or4_1
X_4399_ _1407_ u_pe_array.g_pe_row\[2\].g_pe_col\[3\].u_pe.psum_out\[10\] VGND VGND
+ VPWR VPWR _1497_ sky130_fd_sc_hd__nand2_1
XTAP_670 VGND VPWR sky130_fd_sc_hd__tapvpwrvgnd_1
XTAP_681 VGND VPWR sky130_fd_sc_hd__tapvpwrvgnd_1
XTAP_692 VGND VPWR sky130_fd_sc_hd__tapvpwrvgnd_1
X_6069_ u_pe_array.g_pe_row\[0\].g_pe_col\[1\].u_pe.act_val\[1\] _2873_ VGND VGND
+ VPWR VPWR _2882_ sky130_fd_sc_hd__and2b_1
XFILLER_0_95_445 VGND VGND VPWR VPWR sky130_fd_sc_hd__decap_3
XANTENNA__3758__B _0869_ VGND VGND VPWR VPWR sky130_fd_sc_hd__diode_2
XFILLER_0_95_478 VGND VGND VPWR VPWR sky130_fd_sc_hd__decap_3
XANTENNA__5041__B2 _1665_ VGND VGND VPWR VPWR sky130_fd_sc_hd__diode_2
XFILLER_0_82_139 VGND VGND VPWR VPWR sky130_fd_sc_hd__fill_1
XFILLER_0_91_673 VGND VGND VPWR VPWR sky130_fd_sc_hd__decap_4
XFILLER_0_90_150 VGND VGND VPWR VPWR sky130_fd_sc_hd__decap_3
XFILLER_0_51_526 VPWR VGND VPWR VGND sky130_ef_sc_hd__decap_12
XFILLER_0_106_477 VGND VGND VPWR VPWR sky130_fd_sc_hd__decap_3
XANTENNA__6541__A1 _1820_ VGND VGND VPWR VPWR sky130_fd_sc_hd__diode_2
XFILLER_0_48_29 VGND VGND VPWR VPWR sky130_fd_sc_hd__decap_3
XANTENNA__4809__S _0756_ VGND VGND VPWR VPWR sky130_fd_sc_hd__diode_2
XANTENNA__6057__B1 _2571_ VGND VGND VPWR VPWR sky130_fd_sc_hd__diode_2
XANTENNA__4607__B2 _1399_ VGND VGND VPWR VPWR sky130_fd_sc_hd__diode_2
XFILLER_0_58_114 VGND VGND VPWR VPWR sky130_fd_sc_hd__fill_1
XFILLER_0_58_103 VGND VGND VPWR VPWR sky130_fd_sc_hd__fill_2
XFILLER_0_46_309 VGND VGND VPWR VPWR sky130_fd_sc_hd__decap_4
X_3770_ _0970_ _0972_ _0977_ VGND VGND VPWR VPWR _0979_ sky130_fd_sc_hd__or3_1
XFILLER_0_109_271 VGND VGND VPWR VPWR sky130_fd_sc_hd__decap_8
XFILLER_0_82_673 VGND VGND VPWR VPWR sky130_fd_sc_hd__fill_2
XANTENNA__4791__A0 _1818_ VGND VGND VPWR VPWR sky130_fd_sc_hd__diode_2
XFILLER_0_109_293 VPWR VGND VPWR VGND sky130_ef_sc_hd__decap_12
XANTENNA__7250__RESET_B net75 VGND VGND VPWR VPWR sky130_fd_sc_hd__diode_2
X_5440_ _2345_ _2363_ u_pe_array.g_pe_row\[1\].g_pe_col\[1\].u_pe.act_val\[3\] u_pe_array.g_pe_row\[1\].g_pe_col\[1\].u_pe.w_reg\[0\]
+ VGND VGND VPWR VPWR _2364_ sky130_fd_sc_hd__a22o_1
XFILLER_0_14_206 VGND VGND VPWR VPWR sky130_fd_sc_hd__decap_4
XFILLER_0_89_69 VPWR VGND VPWR VGND sky130_ef_sc_hd__decap_12
XFILLER_0_2_601 VPWR VGND VPWR VGND sky130_ef_sc_hd__decap_12
X_5371_ _0836_ _2306_ _2308_ _0833_ net640 VGND VGND VPWR VPWR _0306_ sky130_fd_sc_hd__a32o_1
XFILLER_0_1_111 VGND VGND VPWR VPWR sky130_fd_sc_hd__fill_1
XFILLER_0_2_645 VPWR VGND VPWR VGND sky130_ef_sc_hd__decap_12
XFILLER_0_22_250 VGND VGND VPWR VPWR sky130_fd_sc_hd__fill_2
XFILLER_0_100_609 VGND VGND VPWR VPWR sky130_fd_sc_hd__decap_4
X_7110_ clknet_leaf_36_clk _0181_ net76 VGND VGND VPWR VPWR u_pe_array.g_pe_row\[2\].g_pe_col\[0\].u_pe.act_val\[2\]
+ sky130_fd_sc_hd__dfrtp_2
XFILLER_0_1_155 VPWR VGND VPWR VGND sky130_ef_sc_hd__decap_12
X_4322_ u_pe_array.g_pe_row\[2\].g_pe_col\[3\].u_pe.w_reg\[0\] u_pe_array.g_pe_row\[2\].g_pe_col\[3\].u_pe.act_val\[3\]
+ VGND VGND VPWR VPWR _1427_ sky130_fd_sc_hd__nand2_1
X_7041_ clknet_leaf_34_clk _0116_ net817 VGND VGND VPWR VPWR u_pe_array.g_pe_row\[3\].g_pe_col\[0\].u_pe.psum_out\[8\]
+ sky130_fd_sc_hd__dfrtp_2
XANTENNA__6296__B1 _0866_ VGND VGND VPWR VPWR sky130_fd_sc_hd__diode_2
XANTENNA_hold31_A u_pe_array.g_pe_row\[1\].g_pe_col\[1\].u_pe.w_buffer\[0\] VGND VGND
+ VPWR VPWR sky130_fd_sc_hd__diode_2
X_4253_ _1275_ u_pe_array.g_pe_row\[3\].g_pe_col\[0\].u_pe.psum_out\[11\] VGND VGND
+ VPWR VPWR _1378_ sky130_fd_sc_hd__and2b_1
XFILLER_0_10_489 VPWR VGND VPWR VGND sky130_ef_sc_hd__decap_12
XANTENNA__3623__S _0755_ VGND VGND VPWR VPWR sky130_fd_sc_hd__diode_2
X_4184_ _1305_ _1314_ _0914_ VGND VGND VPWR VPWR _1316_ sky130_fd_sc_hd__a21o_1
XFILLER_0_38_73 VGND VGND VPWR VPWR sky130_fd_sc_hd__decap_8
XFILLER_0_89_250 VGND VGND VPWR VPWR sky130_fd_sc_hd__fill_2
XFILLER_0_54_94 VPWR VGND VPWR VGND sky130_ef_sc_hd__decap_12
X_6825_ _3393_ VGND VGND VPWR VPWR _0675_ sky130_fd_sc_hd__clkbuf_1
XFILLER_0_92_415 VGND VGND VPWR VPWR sky130_fd_sc_hd__fill_2
XANTENNA__7338__RESET_B net812 VGND VGND VPWR VPWR sky130_fd_sc_hd__diode_2
XFILLER_0_77_478 VGND VGND VPWR VPWR sky130_fd_sc_hd__fill_2
XFILLER_0_64_117 VGND VGND VPWR VPWR sky130_fd_sc_hd__decap_6
XFILLER_0_49_169 VGND VGND VPWR VPWR sky130_fd_sc_hd__decap_3
XFILLER_0_9_222 VGND VGND VPWR VPWR sky130_fd_sc_hd__fill_2
X_3968_ net117 _0996_ _1136_ _1004_ VGND VGND VPWR VPWR _0075_ sky130_fd_sc_hd__a22o_1
X_6756_ net458 _3118_ net63 VGND VGND VPWR VPWR _3357_ sky130_fd_sc_hd__mux2_1
XANTENNA__5574__A2 _2463_ VGND VGND VPWR VPWR sky130_fd_sc_hd__diode_2
XFILLER_0_73_673 VGND VGND VPWR VPWR sky130_fd_sc_hd__fill_2
XFILLER_0_70_93 VGND VGND VPWR VPWR sky130_fd_sc_hd__decap_3
XFILLER_0_45_353 VGND VGND VPWR VPWR sky130_fd_sc_hd__decap_3
XANTENNA__4782__A0 _1812_ VGND VGND VPWR VPWR sky130_fd_sc_hd__diode_2
X_5707_ _2591_ VGND VGND VPWR VPWR _0359_ sky130_fd_sc_hd__clkbuf_1
X_6687_ u_pe_array.u_fifo1.count\[0\] _3318_ u_pe_array.u_fifo1.count\[2\] VGND VGND
+ VPWR VPWR _3320_ sky130_fd_sc_hd__a21o_1
X_3899_ _1057_ _1058_ _1070_ _1080_ VGND VGND VPWR VPWR _1083_ sky130_fd_sc_hd__or4_1
XFILLER_0_18_589 VGND VGND VPWR VPWR sky130_fd_sc_hd__decap_6
X_5638_ net661 _2387_ _2530_ _2531_ VGND VGND VPWR VPWR _0350_ sky130_fd_sc_hd__a22o_1
XANTENNA__5326__A2 _1714_ VGND VGND VPWR VPWR sky130_fd_sc_hd__diode_2
XFILLER_0_33_559 VGND VGND VPWR VPWR sky130_fd_sc_hd__fill_1
XFILLER_0_103_447 VGND VGND VPWR VPWR sky130_fd_sc_hd__fill_1
XFILLER_0_5_494 VGND VGND VPWR VPWR sky130_fd_sc_hd__decap_8
X_5569_ u_pe_array.g_pe_row\[1\].g_pe_col\[3\].u_pe.psum_out\[9\] u_pe_array.g_pe_row\[1\].g_pe_col\[3\].u_pe.move_reg\[9\]
+ _2469_ VGND VGND VPWR VPWR _2472_ sky130_fd_sc_hd__mux2_1
Xhold162 _0424_ VGND VGND VPWR VPWR net238 sky130_fd_sc_hd__dlygate4sd3_1
Xhold140 u_fsm.h_cnt\[0\] VGND VGND VPWR VPWR net216 sky130_fd_sc_hd__dlygate4sd3_1
XANTENNA__6973__RESET_B net819 VGND VGND VPWR VPWR sky130_fd_sc_hd__diode_2
Xhold151 u_pe_array.g_pe_row\[2\].g_pe_col\[3\].u_pe.move_reg\[9\] VGND VGND VPWR
+ VPWR net227 sky130_fd_sc_hd__dlygate4sd3_1
X_7308_ clknet_leaf_66_clk _0367_ net814 VGND VGND VPWR VPWR u_pe_array.g_pe_row\[0\].g_pe_col\[2\].u_pe.move_reg\[7\]
+ sky130_fd_sc_hd__dfrtp_1
Xhold195 u_pe_array.u_fifo2.buffer\[4\]\[12\] VGND VGND VPWR VPWR net271 sky130_fd_sc_hd__dlygate4sd3_1
XFILLER_0_0_7 VGND VGND VPWR VPWR sky130_fd_sc_hd__fill_2
Xhold184 u_pe_array.g_pe_row\[2\].g_pe_col\[3\].u_pe.move_reg\[7\] VGND VGND VPWR
+ VPWR net260 sky130_fd_sc_hd__dlygate4sd3_1
Xhold173 u_pe_array.u_fifo2.buffer\[0\]\[10\] VGND VGND VPWR VPWR net249 sky130_fd_sc_hd__dlygate4sd3_1
X_7239_ clknet_leaf_42_clk _0302_ net813 VGND VGND VPWR VPWR u_pe_array.g_pe_row\[1\].g_pe_col\[1\].u_pe.w_buffer\[0\]
+ sky130_fd_sc_hd__dfrtp_1
XANTENNA__6039__B1 _2592_ VGND VGND VPWR VPWR sky130_fd_sc_hd__diode_2
XFILLER_0_95_90 VGND VGND VPWR VPWR sky130_fd_sc_hd__fill_1
XANTENNA_fanout73_A net818 VGND VGND VPWR VPWR sky130_fd_sc_hd__diode_2
XANTENNA__6844__S _3397_ VGND VGND VPWR VPWR sky130_fd_sc_hd__diode_2
XTAP_1600 VGND VPWR sky130_fd_sc_hd__tapvpwrvgnd_1
XTAP_1633 VGND VPWR sky130_fd_sc_hd__tapvpwrvgnd_1
XTAP_1622 VGND VPWR sky130_fd_sc_hd__tapvpwrvgnd_1
XTAP_1611 VGND VPWR sky130_fd_sc_hd__tapvpwrvgnd_1
XANTENNA__3812__A2 _0996_ VGND VGND VPWR VPWR sky130_fd_sc_hd__diode_2
XANTENNA__3488__B _0730_ VGND VGND VPWR VPWR sky130_fd_sc_hd__diode_2
XANTENNA__7079__RESET_B net816 VGND VGND VPWR VPWR sky130_fd_sc_hd__diode_2
XFILLER_0_49_670 VGND VGND VPWR VPWR sky130_fd_sc_hd__fill_2
XFILLER_0_28_309 VGND VGND VPWR VPWR sky130_fd_sc_hd__fill_2
XFILLER_0_83_437 VGND VGND VPWR VPWR sky130_fd_sc_hd__fill_2
XANTENNA__7008__RESET_B net74 VGND VGND VPWR VPWR sky130_fd_sc_hd__diode_2
XANTENNA__4773__A0 _1806_ VGND VGND VPWR VPWR sky130_fd_sc_hd__diode_2
XANTENNA__5195__S _1661_ VGND VGND VPWR VPWR sky130_fd_sc_hd__diode_2
XFILLER_0_51_323 VGND VGND VPWR VPWR sky130_fd_sc_hd__decap_4
XFILLER_0_51_345 VGND VGND VPWR VPWR sky130_fd_sc_hd__fill_1
XFILLER_0_59_39 VPWR VGND VPWR VGND sky130_ef_sc_hd__decap_12
XFILLER_0_32_581 VGND VGND VPWR VPWR sky130_fd_sc_hd__fill_1
XANTENNA__3879__A2 _1009_ VGND VGND VPWR VPWR sky130_fd_sc_hd__diode_2
XFILLER_0_102_491 VGND VGND VPWR VPWR sky130_fd_sc_hd__decap_3
XANTENNA_output54_A net54 VGND VGND VPWR VPWR sky130_fd_sc_hd__diode_2
XANTENNA__3679__A u_pe_array.g_pe_row\[3\].g_pe_col\[3\].u_pe.act_val\[2\] VGND VGND
+ VPWR VPWR sky130_fd_sc_hd__diode_2
XFILLER_0_99_592 VGND VGND VPWR VPWR sky130_fd_sc_hd__fill_1
X_4940_ _1939_ _1940_ VGND VGND VPWR VPWR _1941_ sky130_fd_sc_hd__nand2_1
XANTENNA__3803__A2 _0996_ VGND VGND VPWR VPWR sky130_fd_sc_hd__diode_2
XANTENNA__4274__S _0769_ VGND VGND VPWR VPWR sky130_fd_sc_hd__diode_2
X_4871_ u_pe_array.g_pe_row\[2\].g_pe_col\[0\].u_pe.act_val\[3\] VGND VGND VPWR VPWR
+ _1878_ sky130_fd_sc_hd__inv_2
XFILLER_0_86_253 VGND VGND VPWR VPWR sky130_fd_sc_hd__fill_2
XFILLER_0_74_415 VGND VGND VPWR VPWR sky130_fd_sc_hd__decap_3
XFILLER_0_19_309 VGND VGND VPWR VPWR sky130_fd_sc_hd__fill_1
XANTENNA__6202__B1 _0866_ VGND VGND VPWR VPWR sky130_fd_sc_hd__diode_2
X_7590_ clknet_leaf_20_clk _0639_ VGND VGND VPWR VPWR u_pe_array.u_fifo1.buffer\[2\]\[0\]
+ sky130_fd_sc_hd__dfxtp_1
XFILLER_0_74_448 VGND VGND VPWR VPWR sky130_fd_sc_hd__fill_2
XANTENNA__7431__RESET_B net74 VGND VGND VPWR VPWR sky130_fd_sc_hd__diode_2
XANTENNA__5894__A _0832_ VGND VGND VPWR VPWR sky130_fd_sc_hd__diode_2
X_6610_ _3274_ VGND VGND VPWR VPWR _0579_ sky130_fd_sc_hd__clkbuf_1
X_3822_ _1010_ _1011_ _1008_ VGND VGND VPWR VPWR _1013_ sky130_fd_sc_hd__o21ai_1
X_6541_ net271 _1820_ _3224_ VGND VGND VPWR VPWR _3237_ sky130_fd_sc_hd__mux2_1
XFILLER_0_6_203 VPWR VGND VPWR VGND sky130_ef_sc_hd__decap_12
XFILLER_0_82_481 VGND VGND VPWR VPWR sky130_fd_sc_hd__fill_1
XFILLER_0_55_673 VGND VGND VPWR VPWR sky130_fd_sc_hd__fill_1
XANTENNA__3618__S _0819_ VGND VGND VPWR VPWR sky130_fd_sc_hd__diode_2
XFILLER_0_27_375 VGND VGND VPWR VPWR sky130_fd_sc_hd__fill_2
X_3753_ _0954_ _0956_ _0962_ _0885_ VGND VGND VPWR VPWR _0964_ sky130_fd_sc_hd__o31a_1
XFILLER_0_42_301 VGND VGND VPWR VPWR sky130_fd_sc_hd__decap_4
X_3684_ _0889_ _0900_ VGND VGND VPWR VPWR _0901_ sky130_fd_sc_hd__xnor2_1
X_6472_ _3200_ VGND VGND VPWR VPWR _0515_ sky130_fd_sc_hd__clkbuf_1
XFILLER_0_40_85 VGND VGND VPWR VPWR sky130_fd_sc_hd__decap_8
XFILLER_0_42_356 VGND VGND VPWR VPWR sky130_fd_sc_hd__decap_6
XFILLER_0_112_222 VPWR VGND VPWR VGND sky130_ef_sc_hd__decap_12
XFILLER_0_70_676 VGND VGND VPWR VPWR sky130_fd_sc_hd__fill_1
X_5423_ u_pe_array.g_pe_row\[1\].g_pe_col\[1\].u_pe.psum_out\[1\] _2348_ VGND VGND
+ VPWR VPWR _2349_ sky130_fd_sc_hd__or2_1
XFILLER_0_30_529 VGND VGND VPWR VPWR sky130_fd_sc_hd__decap_3
X_5354_ u_pe_array.u_fifo1.buffer\[0\]\[1\] _2275_ VGND VGND VPWR VPWR _2293_ sky130_fd_sc_hd__or2_1
XFILLER_0_2_475 VGND VGND VPWR VPWR sky130_fd_sc_hd__fill_1
XFILLER_0_112_277 VPWR VGND VPWR VGND sky130_ef_sc_hd__decap_12
XFILLER_0_10_253 VGND VGND VPWR VPWR sky130_fd_sc_hd__fill_2
XFILLER_0_10_242 VGND VGND VPWR VPWR sky130_fd_sc_hd__decap_8
X_4305_ u_pe_array.g_pe_row\[2\].g_pe_col\[3\].u_pe.w_reg\[0\] u_pe_array.g_pe_row\[2\].g_pe_col\[3\].u_pe.act_val\[1\]
+ _1410_ _1411_ VGND VGND VPWR VPWR _1412_ sky130_fd_sc_hd__a22o_1
X_5285_ u_pe_array.g_pe_row\[1\].g_pe_col\[2\].u_pe.psum_out\[7\] VGND VGND VPWR VPWR
+ _2232_ sky130_fd_sc_hd__inv_2
XANTENNA__4449__S _0855_ VGND VGND VPWR VPWR sky130_fd_sc_hd__diode_2
X_4236_ _1354_ _1357_ _1362_ VGND VGND VPWR VPWR _1363_ sky130_fd_sc_hd__o21ai_1
XFILLER_0_4_41 VPWR VGND VPWR VGND sky130_ef_sc_hd__decap_12
X_7024_ clknet_leaf_78_clk _0101_ net74 VGND VGND VPWR VPWR u_pe_array.g_pe_row\[2\].g_pe_col\[3\].u_pe.move_reg\[6\]
+ sky130_fd_sc_hd__dfrtp_1
X_4167_ u_pe_array.g_pe_row\[3\].g_pe_col\[0\].u_pe.psum_out\[2\] _1286_ _1299_ VGND
+ VGND VPWR VPWR _1300_ sky130_fd_sc_hd__a21oi_1
XFILLER_0_4_85 VPWR VGND VPWR VGND sky130_ef_sc_hd__decap_12
XFILLER_0_65_93 VGND VGND VPWR VPWR sky130_fd_sc_hd__fill_2
X_4098_ u_pe_array.g_pe_row\[3\].g_pe_col\[1\].u_pe.psum_out\[9\] u_pe_array.g_pe_row\[3\].g_pe_col\[1\].u_pe.psum_out\[10\]
+ _1145_ VGND VGND VPWR VPWR _1250_ sky130_fd_sc_hd__o21a_1
XFILLER_0_108_517 VPWR VGND VPWR VGND sky130_ef_sc_hd__decap_12
XANTENNA__7172__RESET_B net817 VGND VGND VPWR VPWR sky130_fd_sc_hd__diode_2
X_6808_ net460 _3114_ _3382_ VGND VGND VPWR VPWR _3385_ sky130_fd_sc_hd__mux2_1
XANTENNA__7101__RESET_B net819 VGND VGND VPWR VPWR sky130_fd_sc_hd__diode_2
X_6739_ net274 _3128_ net64 VGND VGND VPWR VPWR _3348_ sky130_fd_sc_hd__mux2_1
XFILLER_0_80_418 VGND VGND VPWR VPWR sky130_fd_sc_hd__fill_2
XFILLER_0_61_621 VGND VGND VPWR VPWR sky130_fd_sc_hd__decap_3
XFILLER_0_61_610 VGND VGND VPWR VPWR sky130_fd_sc_hd__fill_2
XFILLER_0_45_161 VGND VGND VPWR VPWR sky130_fd_sc_hd__decap_4
XFILLER_0_33_334 VGND VGND VPWR VPWR sky130_fd_sc_hd__fill_2
XFILLER_0_33_345 VGND VGND VPWR VPWR sky130_fd_sc_hd__fill_2
XFILLER_0_61_676 VGND VGND VPWR VPWR sky130_fd_sc_hd__fill_1
XFILLER_0_103_255 VGND VGND VPWR VPWR sky130_fd_sc_hd__fill_2
XFILLER_0_60_197 VGND VGND VPWR VPWR sky130_fd_sc_hd__decap_8
XFILLER_0_103_277 VGND VGND VPWR VPWR sky130_fd_sc_hd__decap_3
XFILLER_0_45_19 VGND VGND VPWR VPWR sky130_fd_sc_hd__decap_3
XANTENNA__4286__A2 _1392_ VGND VGND VPWR VPWR sky130_fd_sc_hd__diode_2
XANTENNA__3499__A _0754_ VGND VGND VPWR VPWR sky130_fd_sc_hd__diode_2
XTAP_1441 VGND VPWR sky130_fd_sc_hd__tapvpwrvgnd_1
XTAP_1430 VGND VPWR sky130_fd_sc_hd__tapvpwrvgnd_1
XFILLER_0_29_607 VGND VGND VPWR VPWR sky130_fd_sc_hd__fill_2
XTAP_1474 VGND VPWR sky130_fd_sc_hd__tapvpwrvgnd_1
XTAP_1463 VGND VPWR sky130_fd_sc_hd__tapvpwrvgnd_1
XTAP_1452 VGND VPWR sky130_fd_sc_hd__tapvpwrvgnd_1
XFILLER_0_83_223 VGND VGND VPWR VPWR sky130_fd_sc_hd__fill_1
XFILLER_0_68_286 VGND VGND VPWR VPWR sky130_fd_sc_hd__fill_2
XTAP_1496 VGND VPWR sky130_fd_sc_hd__tapvpwrvgnd_1
XTAP_1485 VGND VPWR sky130_fd_sc_hd__tapvpwrvgnd_1
XFILLER_0_83_289 VGND VGND VPWR VPWR sky130_fd_sc_hd__decap_3
XFILLER_0_52_610 VGND VGND VPWR VPWR sky130_fd_sc_hd__fill_2
XFILLER_0_37_673 VGND VGND VPWR VPWR sky130_fd_sc_hd__fill_2
XFILLER_0_107_561 VPWR VGND VPWR VGND sky130_ef_sc_hd__decap_12
XFILLER_0_52_643 VGND VGND VPWR VPWR sky130_fd_sc_hd__fill_1
XFILLER_0_24_345 VGND VGND VPWR VPWR sky130_fd_sc_hd__decap_3
XFILLER_0_36_194 VGND VGND VPWR VPWR sky130_fd_sc_hd__fill_2
XFILLER_0_101_57 VGND VGND VPWR VPWR sky130_fd_sc_hd__decap_3
XFILLER_0_86_37 VGND VGND VPWR VPWR sky130_fd_sc_hd__fill_2
XFILLER_0_86_15 VGND VGND VPWR VPWR sky130_fd_sc_hd__decap_8
XFILLER_0_20_551 VGND VGND VPWR VPWR sky130_fd_sc_hd__fill_1
XANTENNA__5710__A2 _2463_ VGND VGND VPWR VPWR sky130_fd_sc_hd__diode_2
XANTENNA__4269__S _0770_ VGND VGND VPWR VPWR sky130_fd_sc_hd__diode_2
XFILLER_0_19_20 VGND VGND VPWR VPWR sky130_fd_sc_hd__fill_2
X_5070_ u_pe_array.g_pe_row\[1\].g_pe_col\[3\].u_pe.act_val\[2\] _2029_ VGND VGND
+ VPWR VPWR _2050_ sky130_fd_sc_hd__or2b_1
X_4021_ u_pe_array.g_pe_row\[3\].g_pe_col\[1\].u_pe.act_val\[2\] u_pe_array.g_pe_row\[3\].g_pe_col\[1\].u_pe.psum_out\[3\]
+ _1145_ VGND VGND VPWR VPWR _1181_ sky130_fd_sc_hd__and3b_1
XANTENNA__4277__A2 _1392_ VGND VGND VPWR VPWR sky130_fd_sc_hd__diode_2
XFILLER_0_19_97 VGND VGND VPWR VPWR sky130_fd_sc_hd__fill_1
X_5972_ _2807_ _2805_ _2802_ VGND VGND VPWR VPWR _2808_ sky130_fd_sc_hd__a21oi_1
X_4923_ u_pe_array.g_pe_row\[2\].g_pe_col\[0\].u_pe.psum_out\[8\] _1912_ VGND VGND
+ VPWR VPWR _1926_ sky130_fd_sc_hd__nor2_1
XANTENNA__3788__A1 _0990_ VGND VGND VPWR VPWR sky130_fd_sc_hd__diode_2
XFILLER_0_59_253 VGND VGND VPWR VPWR sky130_fd_sc_hd__fill_2
X_4854_ net717 _1714_ _1861_ _1862_ VGND VGND VPWR VPWR _0235_ sky130_fd_sc_hd__a22o_1
X_7642_ clknet_leaf_20_clk _0691_ VGND VGND VPWR VPWR u_pe_array.u_fifo1.buffer\[6\]\[0\]
+ sky130_fd_sc_hd__dfxtp_1
XFILLER_0_7_501 VGND VGND VPWR VPWR sky130_fd_sc_hd__decap_3
XFILLER_0_28_640 VGND VGND VPWR VPWR sky130_fd_sc_hd__fill_2
X_7573_ clknet_leaf_29_clk _0622_ VGND VGND VPWR VPWR u_pe_array.u_fifo1.buffer\[0\]\[9\]
+ sky130_fd_sc_hd__dfxtp_1
X_3805_ net138 _0996_ _1001_ u_fsm.psum_shift_en VGND VGND VPWR VPWR _0047_ sky130_fd_sc_hd__a22o_1
X_4785_ _1814_ net364 _1796_ VGND VGND VPWR VPWR _1815_ sky130_fd_sc_hd__mux2_1
X_6524_ _3228_ VGND VGND VPWR VPWR _0539_ sky130_fd_sc_hd__clkbuf_1
XFILLER_0_15_345 VGND VGND VPWR VPWR sky130_fd_sc_hd__fill_2
X_3736_ u_pe_array.g_pe_row\[3\].g_pe_col\[3\].u_pe.psum_out\[7\] VGND VGND VPWR VPWR
+ _0948_ sky130_fd_sc_hd__inv_2
XFILLER_0_113_553 VGND VGND VPWR VPWR sky130_fd_sc_hd__decap_6
X_3667_ _0863_ VGND VGND VPWR VPWR _0885_ sky130_fd_sc_hd__buf_12
X_6455_ _3191_ VGND VGND VPWR VPWR _0507_ sky130_fd_sc_hd__clkbuf_1
XFILLER_0_42_197 VGND VGND VPWR VPWR sky130_fd_sc_hd__fill_2
XFILLER_0_113_597 VPWR VGND VPWR VGND sky130_ef_sc_hd__decap_12
X_5406_ u_pe_array.g_pe_row\[0\].g_pe_col\[0\].u_pe.psum_out\[9\] u_pe_array.g_pe_row\[0\].g_pe_col\[0\].u_pe.move_reg\[9\]
+ _1661_ VGND VGND VPWR VPWR _2337_ sky130_fd_sc_hd__mux2_1
X_3598_ _0717_ _0729_ _0786_ VGND VGND VPWR VPWR _0831_ sky130_fd_sc_hd__nor3_1
X_6386_ u_pe_array.u_fifo2.rd_ptr\[3\] _3150_ _3146_ _1960_ VGND VGND VPWR VPWR _3151_
+ sky130_fd_sc_hd__a2bb2o_1
XANTENNA__5162__B1 _2071_ VGND VGND VPWR VPWR sky130_fd_sc_hd__diode_2
XFILLER_0_100_247 VGND VGND VPWR VPWR sky130_fd_sc_hd__decap_3
X_5337_ u_pe_array.u_fifo1.rd_ptr\[3\] u_pe_array.u_fifo1.rd_ptr\[2\] VGND VGND VPWR
+ VPWR _2277_ sky130_fd_sc_hd__nor2_1
X_5268_ _2214_ _2216_ VGND VGND VPWR VPWR _2217_ sky130_fd_sc_hd__xnor2_1
X_4219_ _1305_ _1314_ _1345_ _1346_ VGND VGND VPWR VPWR _1347_ sky130_fd_sc_hd__or4_2
X_7007_ clknet_leaf_14_clk _0084_ net816 VGND VGND VPWR VPWR u_pe_array.g_pe_row\[3\].g_pe_col\[1\].u_pe.psum_out\[4\]
+ sky130_fd_sc_hd__dfrtp_1
X_5199_ u_pe_array.g_pe_row\[1\].g_pe_col\[2\].u_pe.act_val\[0\] u_pe_array.g_pe_row\[1\].g_pe_col\[2\].u_pe.w_reg\[0\]
+ u_pe_array.g_pe_row\[1\].g_pe_col\[2\].u_pe.psum_out\[0\] VGND VGND VPWR VPWR _2154_
+ sky130_fd_sc_hd__a21o_1
XANTENNA__3811__S _0734_ VGND VGND VPWR VPWR sky130_fd_sc_hd__diode_2
XANTENNA__7353__RESET_B net818 VGND VGND VPWR VPWR sky130_fd_sc_hd__diode_2
XFILLER_0_93_521 VGND VGND VPWR VPWR sky130_fd_sc_hd__fill_2
XANTENNA__4440__A2 _1524_ VGND VGND VPWR VPWR sky130_fd_sc_hd__diode_2
XFILLER_0_108_303 VGND VGND VPWR VPWR sky130_fd_sc_hd__decap_4
XFILLER_0_93_565 VGND VGND VPWR VPWR sky130_fd_sc_hd__decap_8
XFILLER_0_93_543 VGND VGND VPWR VPWR sky130_fd_sc_hd__decap_4
XFILLER_0_65_234 VGND VGND VPWR VPWR sky130_fd_sc_hd__fill_1
XFILLER_0_108_358 VGND VGND VPWR VPWR sky130_fd_sc_hd__decap_6
XFILLER_0_93_576 VGND VGND VPWR VPWR sky130_fd_sc_hd__decap_3
XFILLER_0_65_267 VGND VGND VPWR VPWR sky130_fd_sc_hd__fill_1
XFILLER_0_53_418 VGND VGND VPWR VPWR sky130_fd_sc_hd__fill_2
XFILLER_0_18_161 VGND VGND VPWR VPWR sky130_fd_sc_hd__fill_2
XFILLER_0_19_673 VGND VGND VPWR VPWR sky130_fd_sc_hd__decap_4
XFILLER_0_80_259 VGND VGND VPWR VPWR sky130_fd_sc_hd__decap_4
XFILLER_0_46_492 VGND VGND VPWR VPWR sky130_fd_sc_hd__fill_2
XFILLER_0_18_194 VGND VGND VPWR VPWR sky130_fd_sc_hd__fill_2
XFILLER_0_34_654 VGND VGND VPWR VPWR sky130_fd_sc_hd__decap_4
XFILLER_0_34_676 VGND VGND VPWR VPWR sky130_fd_sc_hd__fill_1
XANTENNA__6569__S _3239_ VGND VGND VPWR VPWR sky130_fd_sc_hd__diode_2
XFILLER_0_0_209 VGND VGND VPWR VPWR sky130_fd_sc_hd__fill_2
XFILLER_0_21_337 VGND VGND VPWR VPWR sky130_fd_sc_hd__fill_2
XFILLER_0_104_586 VGND VGND VPWR VPWR sky130_fd_sc_hd__fill_2
XANTENNA__5153__B1 _0913_ VGND VGND VPWR VPWR sky130_fd_sc_hd__diode_2
XFILLER_0_56_29 VPWR VGND VPWR VGND sky130_ef_sc_hd__decap_12
XFILLER_0_88_326 VGND VGND VPWR VPWR sky130_fd_sc_hd__fill_1
XFILLER_0_88_315 VGND VGND VPWR VPWR sky130_fd_sc_hd__fill_2
XANTENNA__7094__RESET_B net819 VGND VGND VPWR VPWR sky130_fd_sc_hd__diode_2
XANTENNA__7023__RESET_B net74 VGND VGND VPWR VPWR sky130_fd_sc_hd__diode_2
XANTENNA__4431__A2 _1392_ VGND VGND VPWR VPWR sky130_fd_sc_hd__diode_2
XFILLER_0_56_212 VGND VGND VPWR VPWR sky130_fd_sc_hd__fill_2
XTAP_1293 VGND VPWR sky130_fd_sc_hd__tapvpwrvgnd_1
XTAP_1271 VGND VPWR sky130_fd_sc_hd__tapvpwrvgnd_1
XTAP_1282 VGND VPWR sky130_fd_sc_hd__tapvpwrvgnd_1
XTAP_1260 VGND VPWR sky130_fd_sc_hd__tapvpwrvgnd_1
XFILLER_0_84_587 VGND VGND VPWR VPWR sky130_fd_sc_hd__fill_1
X_4570_ _1536_ u_pe_array.g_pe_row\[2\].g_pe_col\[2\].u_pe.psum_out\[11\] VGND VGND
+ VPWR VPWR _1639_ sky130_fd_sc_hd__and2b_1
XFILLER_0_108_3 VGND VGND VPWR VPWR sky130_fd_sc_hd__fill_2
X_3521_ u_pe_array.g_pe_row\[1\].g_pe_col\[0\].u_pe.move_reg\[9\] _0770_ VGND VGND
+ VPWR VPWR _0774_ sky130_fd_sc_hd__or2_1
Xhold728 u_pe_array.g_pe_row\[2\].g_pe_col\[0\].u_pe.w_buffer\[0\] VGND VGND VPWR
+ VPWR net804 sky130_fd_sc_hd__dlygate4sd3_1
Xhold717 u_pe_array.g_pe_row\[0\].g_pe_col\[0\].u_pe.psum_out\[7\] VGND VGND VPWR
+ VPWR net793 sky130_fd_sc_hd__dlygate4sd3_1
Xhold706 u_pe_array.g_pe_row\[0\].g_pe_col\[0\].u_pe.act_val\[1\] VGND VGND VPWR VPWR
+ net782 sky130_fd_sc_hd__dlygate4sd3_1
XFILLER_0_52_473 VGND VGND VPWR VPWR sky130_fd_sc_hd__decap_3
XFILLER_0_12_337 VGND VGND VPWR VPWR sky130_fd_sc_hd__decap_6
XFILLER_0_24_186 VGND VGND VPWR VPWR sky130_fd_sc_hd__decap_3
XFILLER_0_24_197 VGND VGND VPWR VPWR sky130_fd_sc_hd__fill_2
XANTENNA_clkbuf_leaf_3_clk_A clknet_3_0__leaf_clk VGND VGND VPWR VPWR sky130_fd_sc_hd__diode_2
X_6240_ _3032_ _3033_ VGND VGND VPWR VPWR _3034_ sky130_fd_sc_hd__nand2_1
X_3452_ _0724_ _0726_ VGND VGND VPWR VPWR _0727_ sky130_fd_sc_hd__or2_1
XANTENNA__5144__B1 _2071_ VGND VGND VPWR VPWR sky130_fd_sc_hd__diode_2
Xhold739 u_pe_array.g_pe_row\[3\].g_pe_col\[3\].u_pe.act_val\[4\] VGND VGND VPWR VPWR
+ net823 sky130_fd_sc_hd__dlygate4sd3_1
XFILLER_0_110_545 VPWR VGND VPWR VGND sky130_ef_sc_hd__decap_12
X_6171_ u_pe_array.g_pe_row\[0\].g_pe_col\[1\].u_pe.psum_out\[11\] _2873_ VGND VGND
+ VPWR VPWR _2975_ sky130_fd_sc_hd__and2b_1
XFILLER_0_110_589 VPWR VGND VPWR VGND sky130_ef_sc_hd__decap_12
X_5122_ _2094_ _2092_ _2096_ VGND VGND VPWR VPWR _2098_ sky130_fd_sc_hd__o21ai_1
XANTENNA__7314__D net105 VGND VGND VPWR VPWR sky130_fd_sc_hd__diode_2
X_5053_ u_pe_array.g_pe_row\[1\].g_pe_col\[3\].u_pe.w_reg\[0\] u_pe_array.g_pe_row\[1\].g_pe_col\[3\].u_pe.act_val\[1\]
+ _2032_ _2033_ VGND VGND VPWR VPWR _2035_ sky130_fd_sc_hd__nand4_1
XANTENNA__3631__S _0734_ VGND VGND VPWR VPWR sky130_fd_sc_hd__diode_2
X_4004_ u_pe_array.g_pe_row\[3\].g_pe_col\[1\].u_pe.w_reg\[0\] u_pe_array.g_pe_row\[3\].g_pe_col\[1\].u_pe.act_val\[2\]
+ _1155_ VGND VGND VPWR VPWR _1165_ sky130_fd_sc_hd__and3_1
XFILLER_0_79_337 VGND VGND VPWR VPWR sky130_fd_sc_hd__fill_2
XFILLER_0_94_307 VGND VGND VPWR VPWR sky130_fd_sc_hd__fill_1
XANTENNA__4958__A0 u_pe_array.g_pe_row\[0\].g_pe_col\[3\].u_pe.w_buffer\[0\] VGND
+ VGND VPWR VPWR sky130_fd_sc_hd__diode_2
X_5955_ _2791_ _2792_ VGND VGND VPWR VPWR _2793_ sky130_fd_sc_hd__nor2_1
XFILLER_0_47_212 VGND VGND VPWR VPWR sky130_fd_sc_hd__fill_1
XANTENNA__5558__S _0745_ VGND VGND VPWR VPWR sky130_fd_sc_hd__diode_2
X_4906_ _1725_ _1908_ _1910_ _1534_ net584 VGND VGND VPWR VPWR _0239_ sky130_fd_sc_hd__a32o_1
X_5886_ u_pe_array.g_pe_row\[1\].g_pe_col\[1\].u_pe.psum_out\[8\] net810 _2469_ VGND
+ VGND VPWR VPWR _2734_ sky130_fd_sc_hd__mux2_1
XFILLER_0_62_83 VGND VGND VPWR VPWR sky130_fd_sc_hd__fill_1
XFILLER_0_47_234 VGND VGND VPWR VPWR sky130_fd_sc_hd__decap_3
X_4837_ u_pe_array.g_pe_row\[2\].g_pe_col\[0\].u_pe.w_reg\[1\] VGND VGND VPWR VPWR
+ _1847_ sky130_fd_sc_hd__clkbuf_8
X_7625_ clknet_leaf_29_clk _0674_ VGND VGND VPWR VPWR u_pe_array.u_fifo1.buffer\[4\]\[9\]
+ sky130_fd_sc_hd__dfxtp_1
X_7556_ clknet_leaf_18_clk _0605_ net816 VGND VGND VPWR VPWR u_pe_array.u_fifo1.rd_ptr\[0\]
+ sky130_fd_sc_hd__dfrtp_4
X_4768_ _1803_ VGND VGND VPWR VPWR _0208_ sky130_fd_sc_hd__clkbuf_1
XFILLER_0_15_131 VGND VGND VPWR VPWR sky130_fd_sc_hd__fill_1
XFILLER_0_16_665 VPWR VGND VPWR VGND sky130_ef_sc_hd__decap_12
X_4699_ _1725_ _1742_ _1743_ _1534_ u_pe_array.g_pe_row\[2\].g_pe_col\[1\].u_pe.psum_out\[7\]
+ VGND VGND VPWR VPWR _0199_ sky130_fd_sc_hd__a32o_1
XFILLER_0_43_495 VGND VGND VPWR VPWR sky130_fd_sc_hd__fill_2
XFILLER_0_15_164 VGND VGND VPWR VPWR sky130_fd_sc_hd__decap_4
X_3719_ _0930_ _0932_ VGND VGND VPWR VPWR _0933_ sky130_fd_sc_hd__xnor2_1
X_6507_ _3218_ VGND VGND VPWR VPWR _0532_ sky130_fd_sc_hd__clkbuf_1
XFILLER_0_30_112 VGND VGND VPWR VPWR sky130_fd_sc_hd__fill_2
XFILLER_0_31_613 VGND VGND VPWR VPWR sky130_fd_sc_hd__fill_1
XFILLER_0_31_646 VGND VGND VPWR VPWR sky130_fd_sc_hd__fill_2
XANTENNA__3806__S _0734_ VGND VGND VPWR VPWR sky130_fd_sc_hd__diode_2
X_7487_ clknet_leaf_3_clk _0536_ VGND VGND VPWR VPWR u_pe_array.u_fifo2.buffer\[4\]\[0\]
+ sky130_fd_sc_hd__dfxtp_1
XFILLER_0_113_361 VPWR VGND VPWR VGND sky130_ef_sc_hd__decap_12
XFILLER_0_70_292 VGND VGND VPWR VPWR sky130_fd_sc_hd__fill_2
X_6438_ net521 _1800_ net69 VGND VGND VPWR VPWR _3183_ sky130_fd_sc_hd__mux2_1
XANTENNA__5306__B _2158_ VGND VGND VPWR VPWR sky130_fd_sc_hd__diode_2
XANTENNA__4489__A2 _1152_ VGND VGND VPWR VPWR sky130_fd_sc_hd__diode_2
XFILLER_0_30_167 VGND VGND VPWR VPWR sky130_fd_sc_hd__fill_2
XANTENNA__3697__B1 _0861_ VGND VGND VPWR VPWR sky130_fd_sc_hd__diode_2
X_6369_ u_pe_array.u_fifo2.wr_ptr\[1\] VGND VGND VPWR VPWR _3140_ sky130_fd_sc_hd__inv_2
Xhold22 u_pe_array.g_pe_row\[1\].g_pe_col\[0\].u_pe.w_buffer\[0\] VGND VGND VPWR VPWR
+ net98 sky130_fd_sc_hd__dlygate4sd3_1
Xhold11 u_pe_array.g_pe_row\[2\].g_pe_col\[3\].u_pe.w_buffer\[0\] VGND VGND VPWR VPWR
+ net87 sky130_fd_sc_hd__dlygate4sd3_1
Xhold33 u_pe_array.g_pe_row\[3\].g_pe_col\[0\].u_pe.move_reg\[9\] VGND VGND VPWR VPWR
+ net109 sky130_fd_sc_hd__dlygate4sd3_1
Xhold44 u_pe_array.g_pe_row\[3\].g_pe_col\[0\].u_pe.move_reg\[10\] VGND VGND VPWR
+ VPWR net120 sky130_fd_sc_hd__dlygate4sd3_1
Xhold55 _0133_ VGND VGND VPWR VPWR net131 sky130_fd_sc_hd__dlygate4sd3_1
Xhold88 u_pe_array.g_pe_row\[1\].g_pe_col\[1\].u_pe.move_reg\[11\] VGND VGND VPWR
+ VPWR net164 sky130_fd_sc_hd__dlygate4sd3_1
Xhold99 u_pe_array.g_pe_row\[2\].g_pe_col\[1\].u_pe.move_reg\[6\] VGND VGND VPWR VPWR
+ net175 sky130_fd_sc_hd__dlygate4sd3_1
Xhold77 u_pe_array.g_pe_row\[2\].g_pe_col\[1\].u_pe.move_reg\[7\] VGND VGND VPWR VPWR
+ net153 sky130_fd_sc_hd__dlygate4sd3_1
Xhold66 u_pe_array.g_pe_row\[2\].g_pe_col\[3\].u_pe.move_reg\[12\] VGND VGND VPWR
+ VPWR net142 sky130_fd_sc_hd__dlygate4sd3_1
XANTENNA__6852__S _3397_ VGND VGND VPWR VPWR sky130_fd_sc_hd__diode_2
XFILLER_0_66_565 VGND VGND VPWR VPWR sky130_fd_sc_hd__fill_2
XANTENNA__3621__A0 net26 VGND VGND VPWR VPWR sky130_fd_sc_hd__diode_2
XFILLER_0_108_144 VGND VGND VPWR VPWR sky130_fd_sc_hd__decap_3
XFILLER_0_81_557 VGND VGND VPWR VPWR sky130_fd_sc_hd__decap_3
XFILLER_0_34_440 VGND VGND VPWR VPWR sky130_fd_sc_hd__fill_2
XFILLER_0_61_281 VGND VGND VPWR VPWR sky130_fd_sc_hd__fill_2
XFILLER_0_67_39 VPWR VGND VPWR VGND sky130_ef_sc_hd__decap_12
XFILLER_0_21_189 VGND VGND VPWR VPWR sky130_fd_sc_hd__decap_3
XANTENNA__3688__B1 _0869_ VGND VGND VPWR VPWR sky130_fd_sc_hd__diode_2
XTAP_318 VGND VPWR sky130_fd_sc_hd__tapvpwrvgnd_1
XTAP_329 VGND VPWR sky130_fd_sc_hd__tapvpwrvgnd_1
XTAP_307 VGND VPWR sky130_fd_sc_hd__tapvpwrvgnd_1
XANTENNA__7275__RESET_B net814 VGND VGND VPWR VPWR sky130_fd_sc_hd__diode_2
XANTENNA__7204__RESET_B net815 VGND VGND VPWR VPWR sky130_fd_sc_hd__diode_2
XFILLER_0_83_27 VGND VGND VPWR VPWR sky130_fd_sc_hd__decap_4
XANTENNA__5378__S _0755_ VGND VGND VPWR VPWR sky130_fd_sc_hd__diode_2
XFILLER_0_76_329 VGND VGND VPWR VPWR sky130_fd_sc_hd__decap_3
XFILLER_0_29_201 VGND VGND VPWR VPWR sky130_fd_sc_hd__decap_3
XFILLER_0_9_629 VPWR VGND VPWR VGND sky130_ef_sc_hd__decap_12
XANTENNA__3687__A u_pe_array.g_pe_row\[3\].g_pe_col\[3\].u_pe.act_val\[3\] VGND VGND
+ VPWR VPWR sky130_fd_sc_hd__diode_2
XFILLER_0_8_117 VGND VGND VPWR VPWR sky130_fd_sc_hd__fill_2
XFILLER_0_8_106 VGND VGND VPWR VPWR sky130_fd_sc_hd__decap_4
XANTENNA__4282__S _0855_ VGND VGND VPWR VPWR sky130_fd_sc_hd__diode_2
X_5740_ u_pe_array.g_pe_row\[0\].g_pe_col\[3\].u_pe.w_reg\[0\] u_pe_array.g_pe_row\[0\].g_pe_col\[3\].u_pe.act_val\[1\]
+ VGND VGND VPWR VPWR _2610_ sky130_fd_sc_hd__nand2_1
XTAP_1090 VGND VPWR sky130_fd_sc_hd__tapvpwrvgnd_1
XFILLER_0_57_565 VGND VGND VPWR VPWR sky130_fd_sc_hd__decap_6
XFILLER_0_17_418 VGND VGND VPWR VPWR sky130_fd_sc_hd__fill_2
XFILLER_0_29_256 VGND VGND VPWR VPWR sky130_fd_sc_hd__decap_8
XFILLER_0_84_384 VGND VGND VPWR VPWR sky130_fd_sc_hd__decap_3
X_7410_ clknet_leaf_16_clk _0459_ VGND VGND VPWR VPWR u_pe_array.u_fifo1.buffer\[8\]\[0\]
+ sky130_fd_sc_hd__dfxtp_1
X_5671_ _2561_ VGND VGND VPWR VPWR _2562_ sky130_fd_sc_hd__inv_2
XFILLER_0_44_215 VGND VGND VPWR VPWR sky130_fd_sc_hd__decap_3
X_4622_ u_pe_array.g_pe_row\[2\].g_pe_col\[1\].u_pe.act_val\[0\] _1672_ VGND VGND
+ VPWR VPWR _1673_ sky130_fd_sc_hd__nand2_1
XFILLER_0_114_158 VGND VGND VPWR VPWR sky130_fd_sc_hd__fill_1
XFILLER_0_114_136 VGND VGND VPWR VPWR sky130_fd_sc_hd__fill_2
X_7341_ clknet_leaf_50_clk net215 net812 VGND VGND VPWR VPWR u_pe_array.g_pe_row\[0\].g_pe_col\[1\].u_pe.move_reg\[10\]
+ sky130_fd_sc_hd__dfrtp_1
X_4553_ _1615_ _1618_ _1623_ VGND VGND VPWR VPWR _1624_ sky130_fd_sc_hd__o21ai_1
XFILLER_0_40_421 VGND VGND VPWR VPWR sky130_fd_sc_hd__fill_2
XFILLER_0_114_169 VGND VGND VPWR VPWR sky130_fd_sc_hd__fill_2
X_3504_ u_pe_array.g_pe_row\[1\].g_pe_col\[0\].u_pe.act_val\[3\] u_pe_array.g_pe_row\[1\].g_pe_col\[0\].u_pe.psum_out\[3\]
+ _0756_ VGND VGND VPWR VPWR _0763_ sky130_fd_sc_hd__mux2_1
Xhold536 u_pe_array.g_pe_row\[0\].g_pe_col\[2\].u_pe.psum_out\[1\] VGND VGND VPWR
+ VPWR net612 sky130_fd_sc_hd__dlygate4sd3_1
XFILLER_0_12_134 VGND VGND VPWR VPWR sky130_fd_sc_hd__decap_4
X_4484_ u_pe_array.g_pe_row\[2\].g_pe_col\[2\].u_pe.psum_out\[2\] _1547_ _1560_ VGND
+ VGND VPWR VPWR _1561_ sky130_fd_sc_hd__a21oi_1
Xhold525 u_pe_array.g_pe_row\[2\].g_pe_col\[3\].u_pe.act_val\[1\] VGND VGND VPWR VPWR
+ net601 sky130_fd_sc_hd__dlygate4sd3_1
Xhold503 u_pe_array.g_pe_row\[1\].g_pe_col\[3\].u_pe.psum_out\[2\] VGND VGND VPWR
+ VPWR net579 sky130_fd_sc_hd__dlygate4sd3_1
Xhold514 u_pe_array.u_fifo2.buffer\[7\]\[1\] VGND VGND VPWR VPWR net590 sky130_fd_sc_hd__dlygate4sd3_1
X_7272_ clknet_leaf_79_clk _0333_ net814 VGND VGND VPWR VPWR u_pe_array.g_pe_row\[0\].g_pe_col\[3\].u_pe.act_val\[1\]
+ sky130_fd_sc_hd__dfrtp_1
X_6223_ _3010_ _3011_ _3017_ VGND VGND VPWR VPWR _3018_ sky130_fd_sc_hd__nor3_1
Xhold569 u_pe_array.g_pe_row\[3\].g_pe_col\[1\].u_pe.act_val\[3\] VGND VGND VPWR VPWR
+ net645 sky130_fd_sc_hd__dlygate4sd3_1
Xhold558 u_pe_array.g_pe_row\[2\].g_pe_col\[3\].u_pe.act_val\[3\] VGND VGND VPWR VPWR
+ net634 sky130_fd_sc_hd__dlygate4sd3_1
Xhold547 u_pe_array.g_pe_row\[3\].g_pe_col\[3\].u_pe.move_reg\[6\] VGND VGND VPWR
+ VPWR net623 sky130_fd_sc_hd__dlygate4sd3_1
XFILLER_0_110_353 VGND VGND VPWR VPWR sky130_fd_sc_hd__fill_2
XANTENNA__4030__B _1145_ VGND VGND VPWR VPWR sky130_fd_sc_hd__diode_2
XFILLER_0_0_551 VGND VGND VPWR VPWR sky130_fd_sc_hd__decap_8
X_6154_ u_pe_array.g_pe_row\[0\].g_pe_col\[1\].u_pe.psum_out\[8\] _2957_ _2959_ _2949_
+ VGND VGND VPWR VPWR _2960_ sky130_fd_sc_hd__a22o_1
XTAP_852 VGND VPWR sky130_fd_sc_hd__tapvpwrvgnd_1
XTAP_841 VGND VPWR sky130_fd_sc_hd__tapvpwrvgnd_1
XTAP_830 VGND VPWR sky130_fd_sc_hd__tapvpwrvgnd_1
X_6085_ u_pe_array.g_pe_row\[0\].g_pe_col\[1\].u_pe.w_reg\[0\] u_pe_array.g_pe_row\[0\].g_pe_col\[1\].u_pe.act_val\[2\]
+ _2882_ VGND VGND VPWR VPWR _2897_ sky130_fd_sc_hd__and3_1
XTAP_874 VGND VPWR sky130_fd_sc_hd__tapvpwrvgnd_1
XTAP_885 VGND VPWR sky130_fd_sc_hd__tapvpwrvgnd_1
XTAP_863 VGND VPWR sky130_fd_sc_hd__tapvpwrvgnd_1
XANTENNA__5056__B_N _2029_ VGND VGND VPWR VPWR sky130_fd_sc_hd__diode_2
X_5105_ net649 _1714_ _2081_ _2082_ VGND VGND VPWR VPWR _0266_ sky130_fd_sc_hd__a22o_1
XTAP_896 VGND VPWR sky130_fd_sc_hd__tapvpwrvgnd_1
X_5036_ u_pe_array.g_pe_row\[0\].g_pe_col\[2\].u_pe.psum_out\[9\] u_pe_array.g_pe_row\[0\].g_pe_col\[2\].u_pe.move_reg\[9\]
+ _1661_ VGND VGND VPWR VPWR _2023_ sky130_fd_sc_hd__mux2_1
XFILLER_0_32_3 VPWR VGND VPWR VGND sky130_ef_sc_hd__decap_12
XANTENNA__6998__RESET_B net817 VGND VGND VPWR VPWR sky130_fd_sc_hd__diode_2
XFILLER_0_79_134 VGND VGND VPWR VPWR sky130_fd_sc_hd__decap_6
XFILLER_0_79_167 VGND VGND VPWR VPWR sky130_fd_sc_hd__fill_1
XANTENNA__3851__B1 _0867_ VGND VGND VPWR VPWR sky130_fd_sc_hd__diode_2
X_6987_ clknet_leaf_38_clk _0066_ net76 VGND VGND VPWR VPWR u_pe_array.g_pe_row\[3\].g_pe_col\[1\].u_pe.w_buffer\[1\]
+ sky130_fd_sc_hd__dfrtp_1
XFILLER_0_67_329 VGND VGND VPWR VPWR sky130_fd_sc_hd__fill_2
XANTENNA__6927__RESET_B net815 VGND VGND VPWR VPWR sky130_fd_sc_hd__diode_2
XFILLER_0_48_554 VGND VGND VPWR VPWR sky130_fd_sc_hd__decap_3
X_5938_ _2775_ _2776_ u_pe_array.g_pe_row\[0\].g_pe_col\[2\].u_pe.act_val\[4\] u_pe_array.g_pe_row\[0\].g_pe_col\[2\].u_pe.w_reg\[0\]
+ VGND VGND VPWR VPWR _2777_ sky130_fd_sc_hd__and4bb_1
XFILLER_0_48_576 VGND VGND VPWR VPWR sky130_fd_sc_hd__decap_4
XFILLER_0_35_215 VGND VGND VPWR VPWR sky130_fd_sc_hd__decap_3
X_5869_ _2725_ VGND VGND VPWR VPWR _0387_ sky130_fd_sc_hd__clkbuf_1
XFILLER_0_106_637 VGND VGND VPWR VPWR sky130_fd_sc_hd__decap_6
XFILLER_0_90_365 VGND VGND VPWR VPWR sky130_fd_sc_hd__decap_4
X_7608_ clknet_leaf_22_clk _0657_ VGND VGND VPWR VPWR u_pe_array.u_fifo1.buffer\[3\]\[5\]
+ sky130_fd_sc_hd__dfxtp_1
XFILLER_0_50_207 VGND VGND VPWR VPWR sky130_fd_sc_hd__fill_2
XFILLER_0_7_161 VGND VGND VPWR VPWR sky130_fd_sc_hd__decap_6
X_7539_ clknet_leaf_78_clk _0588_ net815 VGND VGND VPWR VPWR u_pe_array.g_pe_row\[3\].g_pe_col\[3\].u_pe.act_val\[0\]
+ sky130_fd_sc_hd__dfrtp_2
XFILLER_0_113_180 VGND VGND VPWR VPWR sky130_fd_sc_hd__decap_3
Xoutput56 net56 VGND VGND VPWR VPWR psum_out1[4] sky130_fd_sc_hd__clkbuf_4
Xoutput45 net45 VGND VGND VPWR VPWR psum_out0[6] sky130_fd_sc_hd__clkbuf_4
XANTENNA__4331__A1 _1273_ VGND VGND VPWR VPWR sky130_fd_sc_hd__diode_2
XANTENNA_input16_A v_in0[1] VGND VGND VPWR VPWR sky130_fd_sc_hd__diode_2
XFILLER_0_98_421 VGND VGND VPWR VPWR sky130_fd_sc_hd__decap_8
XFILLER_0_86_649 VGND VGND VPWR VPWR sky130_fd_sc_hd__fill_2
XFILLER_0_109_431 VPWR VGND VPWR VGND sky130_ef_sc_hd__decap_12
XPHY_151 VGND VGND VPWR VPWR sky130_fd_sc_hd__decap_3
XPHY_140 VGND VGND VPWR VPWR sky130_fd_sc_hd__decap_3
XFILLER_0_66_373 VGND VGND VPWR VPWR sky130_fd_sc_hd__fill_1
XPHY_184 VGND VGND VPWR VPWR sky130_fd_sc_hd__decap_3
XPHY_173 VGND VGND VPWR VPWR sky130_fd_sc_hd__decap_3
XFILLER_0_81_332 VGND VGND VPWR VPWR sky130_fd_sc_hd__fill_2
XPHY_162 VGND VGND VPWR VPWR sky130_fd_sc_hd__decap_3
XFILLER_0_54_524 VGND VGND VPWR VPWR sky130_fd_sc_hd__decap_8
XPHY_195 VGND VGND VPWR VPWR sky130_fd_sc_hd__decap_3
XFILLER_0_81_387 VGND VGND VPWR VPWR sky130_fd_sc_hd__fill_2
XFILLER_0_41_207 VGND VGND VPWR VPWR sky130_fd_sc_hd__fill_2
XFILLER_0_78_27 VGND VGND VPWR VPWR sky130_fd_sc_hd__fill_1
XFILLER_0_22_421 VGND VGND VPWR VPWR sky130_fd_sc_hd__fill_2
XFILLER_0_1_337 VPWR VGND VPWR VGND sky130_ef_sc_hd__decap_12
XFILLER_0_94_15 VGND VGND VPWR VPWR sky130_fd_sc_hd__decap_8
XFILLER_0_94_48 VGND VGND VPWR VPWR sky130_fd_sc_hd__decap_3
XFILLER_0_89_432 VGND VGND VPWR VPWR sky130_fd_sc_hd__fill_2
X_6910_ net220 _3132_ _3427_ VGND VGND VPWR VPWR _3439_ sky130_fd_sc_hd__mux2_1
XANTENNA__6492__S _3208_ VGND VGND VPWR VPWR sky130_fd_sc_hd__diode_2
X_6841_ _3402_ VGND VGND VPWR VPWR _0682_ sky130_fd_sc_hd__clkbuf_1
XFILLER_0_89_487 VGND VGND VPWR VPWR sky130_fd_sc_hd__fill_2
XFILLER_0_9_404 VGND VGND VPWR VPWR sky130_fd_sc_hd__fill_2
XANTENNA__4389__B2 _0916_ VGND VGND VPWR VPWR sky130_fd_sc_hd__diode_2
X_6772_ net234 _3134_ net62 VGND VGND VPWR VPWR _3365_ sky130_fd_sc_hd__mux2_1
XFILLER_0_92_619 VGND VGND VPWR VPWR sky130_fd_sc_hd__fill_2
X_3984_ u_pe_array.g_pe_row\[3\].g_pe_col\[1\].u_pe.act_val\[0\] _1145_ u_pe_array.g_pe_row\[3\].g_pe_col\[1\].u_pe.psum_out\[1\]
+ VGND VGND VPWR VPWR _1147_ sky130_fd_sc_hd__and3_1
XFILLER_0_45_502 VGND VGND VPWR VPWR sky130_fd_sc_hd__fill_2
X_5723_ _0832_ VGND VGND VPWR VPWR _2600_ sky130_fd_sc_hd__clkbuf_8
X_5654_ u_pe_array.g_pe_row\[1\].g_pe_col\[0\].u_pe.psum_out\[7\] _2478_ VGND VGND
+ VPWR VPWR _2546_ sky130_fd_sc_hd__or2_1
XFILLER_0_72_365 VGND VGND VPWR VPWR sky130_fd_sc_hd__fill_2
XFILLER_0_60_505 VGND VGND VPWR VPWR sky130_fd_sc_hd__fill_1
XFILLER_0_17_248 VGND VGND VPWR VPWR sky130_fd_sc_hd__decap_4
XANTENNA__5889__B2 _0722_ VGND VGND VPWR VPWR sky130_fd_sc_hd__diode_2
X_4605_ _0729_ VGND VGND VPWR VPWR _1661_ sky130_fd_sc_hd__clkbuf_16
XFILLER_0_5_665 VGND VGND VPWR VPWR sky130_fd_sc_hd__decap_6
XFILLER_0_25_270 VGND VGND VPWR VPWR sky130_fd_sc_hd__fill_2
XFILLER_0_103_629 VPWR VGND VPWR VGND sky130_ef_sc_hd__decap_12
X_5585_ u_pe_array.g_pe_row\[1\].g_pe_col\[0\].u_pe.act_val\[1\] u_pe_array.g_pe_row\[1\].g_pe_col\[0\].u_pe.w_reg\[0\]
+ _2481_ _2482_ VGND VGND VPWR VPWR _2483_ sky130_fd_sc_hd__a22o_1
Xhold311 u_pe_array.g_pe_row\[2\].g_pe_col\[1\].u_pe.move_reg\[12\] VGND VGND VPWR
+ VPWR net387 sky130_fd_sc_hd__dlygate4sd3_1
Xhold300 u_pe_array.u_fifo2.buffer\[8\]\[8\] VGND VGND VPWR VPWR net376 sky130_fd_sc_hd__dlygate4sd3_1
XFILLER_0_4_153 VPWR VGND VPWR VGND sky130_ef_sc_hd__decap_12
XFILLER_0_13_421 VGND VGND VPWR VPWR sky130_fd_sc_hd__decap_6
XFILLER_0_25_281 VGND VGND VPWR VPWR sky130_fd_sc_hd__decap_4
X_7324_ clknet_leaf_67_clk _0381_ net13 VGND VGND VPWR VPWR u_pe_array.g_pe_row\[0\].g_pe_col\[3\].u_pe.psum_out\[8\]
+ sky130_fd_sc_hd__dfrtp_2
XFILLER_0_102_139 VGND VGND VPWR VPWR sky130_fd_sc_hd__fill_1
Xhold322 u_pe_array.g_pe_row\[3\].g_pe_col\[0\].u_pe.psum_out\[6\] VGND VGND VPWR
+ VPWR net398 sky130_fd_sc_hd__dlygate4sd3_1
Xhold333 u_pe_array.g_pe_row\[0\].g_pe_col\[0\].u_pe.move_reg\[12\] VGND VGND VPWR
+ VPWR net409 sky130_fd_sc_hd__dlygate4sd3_1
XFILLER_0_4_197 VGND VGND VPWR VPWR sky130_fd_sc_hd__decap_4
X_4536_ _1566_ _1575_ _1606_ _1607_ VGND VGND VPWR VPWR _1608_ sky130_fd_sc_hd__or4_1
XANTENNA__7197__RESET_B net815 VGND VGND VPWR VPWR sky130_fd_sc_hd__diode_2
Xhold344 u_pe_array.g_pe_row\[3\].g_pe_col\[2\].u_pe.psum_out\[0\] VGND VGND VPWR
+ VPWR net420 sky130_fd_sc_hd__dlygate4sd3_1
XFILLER_0_40_251 VGND VGND VPWR VPWR sky130_fd_sc_hd__fill_1
XFILLER_0_110_150 VGND VGND VPWR VPWR sky130_fd_sc_hd__decap_3
Xhold377 u_pe_array.u_fifo1.buffer\[5\]\[5\] VGND VGND VPWR VPWR net453 sky130_fd_sc_hd__dlygate4sd3_1
Xhold366 u_pe_array.u_fifo1.buffer\[3\]\[3\] VGND VGND VPWR VPWR net442 sky130_fd_sc_hd__dlygate4sd3_1
X_7255_ clknet_leaf_39_clk net106 net813 VGND VGND VPWR VPWR u_pe_array.g_pe_row\[1\].g_pe_col\[1\].u_pe.w_reg\[1\]
+ sky130_fd_sc_hd__dfrtp_1
XANTENNA__7126__RESET_B net76 VGND VGND VPWR VPWR sky130_fd_sc_hd__diode_2
X_4467_ u_pe_array.g_pe_row\[2\].g_pe_col\[2\].u_pe.act_val\[1\] _1536_ VGND VGND
+ VPWR VPWR _1545_ sky130_fd_sc_hd__and2b_1
XFILLER_0_7_85 VPWR VGND VPWR VGND sky130_ef_sc_hd__decap_12
XANTENNA__5571__S _2469_ VGND VGND VPWR VPWR sky130_fd_sc_hd__diode_2
Xhold355 u_pe_array.u_fifo2.buffer\[0\]\[4\] VGND VGND VPWR VPWR net431 sky130_fd_sc_hd__dlygate4sd3_1
XFILLER_0_110_183 VGND VGND VPWR VPWR sky130_fd_sc_hd__decap_4
X_6206_ _2999_ _3001_ VGND VGND VPWR VPWR _3002_ sky130_fd_sc_hd__xnor2_1
Xhold388 u_fsm.cnt\[0\] VGND VGND VPWR VPWR net464 sky130_fd_sc_hd__dlygate4sd3_1
X_7186_ clknet_leaf_61_clk _0253_ net73 VGND VGND VPWR VPWR u_pe_array.g_pe_row\[1\].g_pe_col\[2\].u_pe.act_val\[5\]
+ sky130_fd_sc_hd__dfrtp_1
Xhold399 u_pe_array.u_fifo2.buffer\[6\]\[3\] VGND VGND VPWR VPWR net475 sky130_fd_sc_hd__dlygate4sd3_1
X_4398_ _1487_ _1492_ _1495_ _1491_ VGND VGND VPWR VPWR _1496_ sky130_fd_sc_hd__a22oi_2
X_6137_ _2933_ _2940_ VGND VGND VPWR VPWR _2944_ sky130_fd_sc_hd__nand2_1
XANTENNA_input8_A h_in1[1] VGND VGND VPWR VPWR sky130_fd_sc_hd__diode_2
XTAP_660 VGND VPWR sky130_fd_sc_hd__tapvpwrvgnd_1
XTAP_671 VGND VPWR sky130_fd_sc_hd__tapvpwrvgnd_1
XTAP_682 VGND VPWR sky130_fd_sc_hd__tapvpwrvgnd_1
XTAP_693 VGND VPWR sky130_fd_sc_hd__tapvpwrvgnd_1
X_6068_ u_pe_array.g_pe_row\[0\].g_pe_col\[1\].u_pe.act_val\[0\] _2872_ _2873_ VGND
+ VGND VPWR VPWR _2881_ sky130_fd_sc_hd__a21bo_1
XFILLER_0_99_229 VGND VGND VPWR VPWR sky130_fd_sc_hd__decap_3
X_5019_ _1787_ _2010_ VGND VGND VPWR VPWR _2011_ sky130_fd_sc_hd__or2_1
XANTENNA_clkbuf_leaf_90_clk_A clknet_3_1__leaf_clk VGND VGND VPWR VPWR sky130_fd_sc_hd__diode_2
XFILLER_0_95_424 VGND VGND VPWR VPWR sky130_fd_sc_hd__fill_2
XFILLER_0_68_638 VGND VGND VPWR VPWR sky130_fd_sc_hd__fill_2
XANTENNA__5026__C1 _0819_ VGND VGND VPWR VPWR sky130_fd_sc_hd__diode_2
XANTENNA__5041__A2 _1666_ VGND VGND VPWR VPWR sky130_fd_sc_hd__diode_2
XFILLER_0_48_362 VGND VGND VPWR VPWR sky130_fd_sc_hd__fill_2
XFILLER_0_63_321 VGND VGND VPWR VPWR sky130_fd_sc_hd__fill_2
XFILLER_0_91_641 VGND VGND VPWR VPWR sky130_fd_sc_hd__fill_2
XFILLER_0_63_332 VGND VGND VPWR VPWR sky130_fd_sc_hd__fill_2
XFILLER_0_51_505 VGND VGND VPWR VPWR sky130_fd_sc_hd__fill_1
XFILLER_0_8_470 VGND VGND VPWR VPWR sky130_fd_sc_hd__decap_6
XFILLER_0_51_516 VGND VGND VPWR VPWR sky130_fd_sc_hd__fill_1
XANTENNA__6577__S _3254_ VGND VGND VPWR VPWR sky130_fd_sc_hd__diode_2
XANTENNA_clkbuf_leaf_43_clk_A clknet_3_6__leaf_clk VGND VGND VPWR VPWR sky130_fd_sc_hd__diode_2
XFILLER_0_101_172 VGND VGND VPWR VPWR sky130_fd_sc_hd__decap_3
XANTENNA__6057__A1 _2740_ VGND VGND VPWR VPWR sky130_fd_sc_hd__diode_2
XFILLER_0_64_29 VPWR VGND VPWR VGND sky130_ef_sc_hd__decap_12
XANTENNA__4607__A2 _1524_ VGND VGND VPWR VPWR sky130_fd_sc_hd__diode_2
XANTENNA_clkbuf_leaf_58_clk_A clknet_3_6__leaf_clk VGND VGND VPWR VPWR sky130_fd_sc_hd__diode_2
XANTENNA__5510__A net71 VGND VGND VPWR VPWR sky130_fd_sc_hd__diode_2
XFILLER_0_98_295 VGND VGND VPWR VPWR sky130_fd_sc_hd__fill_2
XFILLER_0_86_446 VGND VGND VPWR VPWR sky130_fd_sc_hd__fill_1
XANTENNA__5017__C1 _0819_ VGND VGND VPWR VPWR sky130_fd_sc_hd__diode_2
XFILLER_0_67_671 VGND VGND VPWR VPWR sky130_fd_sc_hd__fill_1
XFILLER_0_13_22 VGND VGND VPWR VPWR sky130_fd_sc_hd__fill_2
XFILLER_0_39_351 VGND VGND VPWR VPWR sky130_fd_sc_hd__fill_2
XFILLER_0_66_181 VPWR VGND VPWR VGND sky130_ef_sc_hd__decap_12
XFILLER_0_89_15 VPWR VGND VPWR VGND sky130_ef_sc_hd__decap_12
XFILLER_0_82_652 VGND VGND VPWR VPWR sky130_fd_sc_hd__fill_2
XFILLER_0_6_418 VGND VGND VPWR VPWR sky130_fd_sc_hd__fill_2
XFILLER_0_81_173 VGND VGND VPWR VPWR sky130_fd_sc_hd__fill_1
XFILLER_0_81_162 VGND VGND VPWR VPWR sky130_fd_sc_hd__decap_6
XFILLER_0_42_527 VGND VGND VPWR VPWR sky130_fd_sc_hd__fill_2
XANTENNA__6060__B _2873_ VGND VGND VPWR VPWR sky130_fd_sc_hd__diode_2
XFILLER_0_2_613 VPWR VGND VPWR VGND sky130_ef_sc_hd__decap_12
X_5370_ _1787_ _2307_ VGND VGND VPWR VPWR _2308_ sky130_fd_sc_hd__or2_1
XANTENNA__7290__RESET_B net813 VGND VGND VPWR VPWR sky130_fd_sc_hd__diode_2
XFILLER_0_50_560 VGND VGND VPWR VPWR sky130_fd_sc_hd__fill_2
XFILLER_0_2_657 VPWR VGND VPWR VGND sky130_ef_sc_hd__decap_12
XFILLER_0_1_167 VGND VGND VPWR VPWR sky130_fd_sc_hd__fill_1
X_4321_ u_pe_array.g_pe_row\[2\].g_pe_col\[3\].u_pe.w_reg\[0\] u_pe_array.g_pe_row\[2\].g_pe_col\[3\].u_pe.act_val\[2\]
+ _1416_ VGND VGND VPWR VPWR _1426_ sky130_fd_sc_hd__and3_1
XANTENNA__6296__A1 _2740_ VGND VGND VPWR VPWR sky130_fd_sc_hd__diode_2
X_7040_ clknet_leaf_27_clk _0115_ net817 VGND VGND VPWR VPWR u_pe_array.g_pe_row\[3\].g_pe_col\[0\].u_pe.psum_out\[7\]
+ sky130_fd_sc_hd__dfrtp_4
X_4252_ u_pe_array.g_pe_row\[3\].g_pe_col\[0\].u_pe.psum_out\[11\] _1275_ VGND VGND
+ VPWR VPWR _1377_ sky130_fd_sc_hd__and2b_1
X_4183_ _1305_ _1314_ VGND VGND VPWR VPWR _1315_ sky130_fd_sc_hd__nor2_1
XFILLER_0_38_85 VGND VGND VPWR VPWR sky130_fd_sc_hd__fill_1
XFILLER_0_77_413 VGND VGND VPWR VPWR sky130_fd_sc_hd__fill_2
XFILLER_0_89_295 VGND VGND VPWR VPWR sky130_fd_sc_hd__fill_1
XFILLER_0_77_446 VGND VGND VPWR VPWR sky130_fd_sc_hd__fill_2
XANTENNA__5008__C1 _0819_ VGND VGND VPWR VPWR sky130_fd_sc_hd__diode_2
X_6824_ net229 _3130_ _3382_ VGND VGND VPWR VPWR _3393_ sky130_fd_sc_hd__mux2_1
XANTENNA__5559__B1 _1655_ VGND VGND VPWR VPWR sky130_fd_sc_hd__diode_2
X_3967_ u_pe_array.g_pe_row\[2\].g_pe_col\[0\].u_pe.move_reg\[8\] u_pe_array.g_pe_row\[2\].g_pe_col\[0\].u_pe.psum_out\[8\]
+ _0755_ VGND VGND VPWR VPWR _1136_ sky130_fd_sc_hd__mux2_1
X_6755_ _3356_ VGND VGND VPWR VPWR _0642_ sky130_fd_sc_hd__clkbuf_1
XFILLER_0_45_310 VGND VGND VPWR VPWR sky130_fd_sc_hd__decap_4
XFILLER_0_18_524 VGND VGND VPWR VPWR sky130_fd_sc_hd__fill_2
XFILLER_0_73_641 VGND VGND VPWR VPWR sky130_fd_sc_hd__fill_2
X_5706_ net34 u_pe_array.g_pe_row\[0\].g_pe_col\[3\].u_pe.w_buffer\[1\] _0828_ VGND
+ VGND VPWR VPWR _2591_ sky130_fd_sc_hd__mux2_1
Xclkbuf_leaf_30_clk clknet_3_3__leaf_clk VGND VGND VPWR VPWR clknet_leaf_30_clk sky130_fd_sc_hd__clkbuf_16
XANTENNA__7378__RESET_B net812 VGND VGND VPWR VPWR sky130_fd_sc_hd__diode_2
XFILLER_0_72_151 VGND VGND VPWR VPWR sky130_fd_sc_hd__fill_1
X_6686_ u_pe_array.u_fifo1.count\[2\] _3314_ _3318_ u_pe_array.u_fifo1.count\[0\]
+ VGND VGND VPWR VPWR _3319_ sky130_fd_sc_hd__o211ai_1
X_3898_ _0864_ _1081_ _1082_ _0867_ net608 VGND VGND VPWR VPWR _0059_ sky130_fd_sc_hd__a32o_1
XFILLER_0_33_516 VGND VGND VPWR VPWR sky130_fd_sc_hd__decap_8
X_5637_ _2528_ _2529_ _0885_ VGND VGND VPWR VPWR _2531_ sky130_fd_sc_hd__o21a_1
XFILLER_0_60_324 VGND VGND VPWR VPWR sky130_fd_sc_hd__decap_4
XANTENNA__7307__RESET_B net814 VGND VGND VPWR VPWR sky130_fd_sc_hd__diode_2
XFILLER_0_33_549 VGND VGND VPWR VPWR sky130_fd_sc_hd__fill_1
X_5568_ net277 _2463_ _2471_ _2336_ VGND VGND VPWR VPWR _0340_ sky130_fd_sc_hd__a22o_1
Xhold152 u_pe_array.u_fifo1.buffer\[6\]\[10\] VGND VGND VPWR VPWR net228 sky130_fd_sc_hd__dlygate4sd3_1
Xhold141 u_pe_array.u_fifo1.buffer\[3\]\[7\] VGND VGND VPWR VPWR net217 sky130_fd_sc_hd__dlygate4sd3_1
Xhold130 u_pe_array.u_fifo1.buffer\[6\]\[11\] VGND VGND VPWR VPWR net206 sky130_fd_sc_hd__dlygate4sd3_1
X_7307_ clknet_leaf_66_clk net155 net814 VGND VGND VPWR VPWR u_pe_array.g_pe_row\[0\].g_pe_col\[2\].u_pe.move_reg\[6\]
+ sky130_fd_sc_hd__dfrtp_1
X_4519_ _1591_ _1592_ VGND VGND VPWR VPWR _1593_ sky130_fd_sc_hd__or2_1
Xhold185 u_pe_array.u_fifo1.buffer\[4\]\[6\] VGND VGND VPWR VPWR net261 sky130_fd_sc_hd__dlygate4sd3_1
Xhold163 u_pe_array.u_fifo1.buffer\[2\]\[9\] VGND VGND VPWR VPWR net239 sky130_fd_sc_hd__dlygate4sd3_1
X_5499_ _2375_ _2384_ _2416_ _2417_ VGND VGND VPWR VPWR _2418_ sky130_fd_sc_hd__or4_2
X_7238_ clknet_leaf_51_clk _0301_ net812 VGND VGND VPWR VPWR u_pe_array.g_pe_row\[1\].g_pe_col\[2\].u_pe.psum_out\[12\]
+ sky130_fd_sc_hd__dfrtp_1
Xhold174 u_pe_array.u_fifo2.buffer\[5\]\[12\] VGND VGND VPWR VPWR net250 sky130_fd_sc_hd__dlygate4sd3_1
Xhold196 u_pe_array.u_fifo1.buffer\[6\]\[7\] VGND VGND VPWR VPWR net272 sky130_fd_sc_hd__dlygate4sd3_1
X_7169_ clknet_leaf_33_clk _0236_ net817 VGND VGND VPWR VPWR u_pe_array.g_pe_row\[2\].g_pe_col\[0\].u_pe.psum_out\[3\]
+ sky130_fd_sc_hd__dfrtp_1
XANTENNA__6942__RESET_B net815 VGND VGND VPWR VPWR sky130_fd_sc_hd__diode_2
XTAP_490 VGND VPWR sky130_fd_sc_hd__tapvpwrvgnd_1
XFILLER_0_68_402 VGND VGND VPWR VPWR sky130_fd_sc_hd__fill_1
XTAP_1623 VGND VPWR sky130_fd_sc_hd__tapvpwrvgnd_1
XTAP_1612 VGND VPWR sky130_fd_sc_hd__tapvpwrvgnd_1
XTAP_1601 VGND VPWR sky130_fd_sc_hd__tapvpwrvgnd_1
XFILLER_0_68_457 VGND VGND VPWR VPWR sky130_fd_sc_hd__fill_2
XFILLER_0_95_254 VGND VGND VPWR VPWR sky130_fd_sc_hd__decap_4
XANTENNA__6860__S _3412_ VGND VGND VPWR VPWR sky130_fd_sc_hd__diode_2
XFILLER_0_64_630 VGND VGND VPWR VPWR sky130_fd_sc_hd__fill_2
XFILLER_0_55_129 VGND VGND VPWR VPWR sky130_fd_sc_hd__decap_3
XFILLER_0_64_652 VGND VGND VPWR VPWR sky130_fd_sc_hd__fill_2
Xclkbuf_leaf_21_clk clknet_3_2__leaf_clk VGND VGND VPWR VPWR clknet_leaf_21_clk sky130_fd_sc_hd__clkbuf_16
XANTENNA__5970__B1 _2174_ VGND VGND VPWR VPWR sky130_fd_sc_hd__diode_2
XFILLER_0_63_195 VPWR VGND VPWR VGND sky130_ef_sc_hd__decap_12
XANTENNA__7048__RESET_B net819 VGND VGND VPWR VPWR sky130_fd_sc_hd__diode_2
XFILLER_0_102_470 VGND VGND VPWR VPWR sky130_fd_sc_hd__fill_1
Xclkbuf_leaf_88_clk clknet_3_1__leaf_clk VGND VGND VPWR VPWR clknet_leaf_88_clk sky130_fd_sc_hd__clkbuf_16
XANTENNA_output47_A net47 VGND VGND VPWR VPWR sky130_fd_sc_hd__diode_2
XANTENNA__6450__A1 _1812_ VGND VGND VPWR VPWR sky130_fd_sc_hd__diode_2
X_4870_ _1864_ _1874_ _1873_ VGND VGND VPWR VPWR _1877_ sky130_fd_sc_hd__a21oi_1
XANTENNA__6202__A1 _2740_ VGND VGND VPWR VPWR sky130_fd_sc_hd__diode_2
X_3821_ _1008_ _1010_ _1011_ VGND VGND VPWR VPWR _1012_ sky130_fd_sc_hd__or3_1
X_6540_ _3236_ VGND VGND VPWR VPWR _0547_ sky130_fd_sc_hd__clkbuf_1
XFILLER_0_54_173 VGND VGND VPWR VPWR sky130_fd_sc_hd__fill_2
Xclkbuf_leaf_12_clk clknet_3_1__leaf_clk VGND VGND VPWR VPWR clknet_leaf_12_clk sky130_fd_sc_hd__clkbuf_16
X_3752_ _0954_ _0956_ _0962_ VGND VGND VPWR VPWR _0963_ sky130_fd_sc_hd__o21ai_1
XFILLER_0_27_387 VGND VGND VPWR VPWR sky130_fd_sc_hd__decap_3
XFILLER_0_40_42 VGND VGND VPWR VPWR sky130_fd_sc_hd__fill_1
XANTENNA__7400__RESET_B net817 VGND VGND VPWR VPWR sky130_fd_sc_hd__diode_2
XFILLER_0_82_493 VGND VGND VPWR VPWR sky130_fd_sc_hd__fill_2
X_3683_ _0898_ _0899_ VGND VGND VPWR VPWR _0900_ sky130_fd_sc_hd__or2b_1
X_6471_ net536 _1806_ _3194_ VGND VGND VPWR VPWR _3200_ sky130_fd_sc_hd__mux2_1
XFILLER_0_112_212 VGND VGND VPWR VPWR sky130_fd_sc_hd__fill_2
X_5422_ _2343_ _2347_ VGND VGND VPWR VPWR _2348_ sky130_fd_sc_hd__xnor2_1
XFILLER_0_2_410 VGND VGND VPWR VPWR sky130_fd_sc_hd__fill_2
XFILLER_0_2_421 VPWR VGND VPWR VGND sky130_ef_sc_hd__decap_12
XFILLER_0_30_508 VGND VGND VPWR VPWR sky130_fd_sc_hd__fill_1
X_5353_ _0836_ _2290_ _2292_ _0833_ u_pe_array.g_pe_row\[1\].g_pe_col\[0\].u_pe.act_val\[0\]
+ VGND VGND VPWR VPWR _0304_ sky130_fd_sc_hd__a32o_1
XFILLER_0_112_289 VPWR VGND VPWR VGND sky130_ef_sc_hd__decap_12
XFILLER_0_100_429 VGND VGND VPWR VPWR sky130_fd_sc_hd__fill_1
XANTENNA__5415__A u_pe_array.g_pe_row\[1\].g_pe_col\[1\].u_pe.w_reg\[0\] VGND VGND
+ VPWR VPWR sky130_fd_sc_hd__diode_2
X_4304_ _1408_ _1409_ _1406_ VGND VGND VPWR VPWR _1411_ sky130_fd_sc_hd__o21ai_1
XFILLER_0_10_221 VGND VGND VPWR VPWR sky130_fd_sc_hd__fill_1
XANTENNA__3634__S _0855_ VGND VGND VPWR VPWR sky130_fd_sc_hd__diode_2
X_5284_ _2189_ _2198_ _2208_ _2230_ VGND VGND VPWR VPWR _2231_ sky130_fd_sc_hd__or4bb_1
XFILLER_0_49_84 VGND VGND VPWR VPWR sky130_fd_sc_hd__fill_1
X_4235_ u_pe_array.g_pe_row\[3\].g_pe_col\[0\].u_pe.psum_out\[8\] _1359_ _1361_ _1351_
+ VGND VGND VPWR VPWR _1362_ sky130_fd_sc_hd__a22o_1
X_7023_ clknet_leaf_77_clk _0100_ net74 VGND VGND VPWR VPWR u_pe_array.g_pe_row\[2\].g_pe_col\[3\].u_pe.act_val\[5\]
+ sky130_fd_sc_hd__dfrtp_1
Xclkbuf_leaf_79_clk clknet_3_4__leaf_clk VGND VGND VPWR VPWR clknet_leaf_79_clk sky130_fd_sc_hd__clkbuf_16
X_4166_ u_pe_array.g_pe_row\[3\].g_pe_col\[0\].u_pe.w_reg\[0\] u_pe_array.g_pe_row\[3\].g_pe_col\[0\].u_pe.act_val\[2\]
+ _1285_ VGND VGND VPWR VPWR _1299_ sky130_fd_sc_hd__and3_1
XFILLER_0_4_53 VPWR VGND VPWR VGND sky130_ef_sc_hd__decap_12
XFILLER_0_4_97 VPWR VGND VPWR VGND sky130_ef_sc_hd__decap_12
X_4097_ _0864_ _1248_ _1249_ _1144_ net276 VGND VGND VPWR VPWR _0091_ sky130_fd_sc_hd__a32o_1
XFILLER_0_77_210 VGND VGND VPWR VPWR sky130_fd_sc_hd__decap_3
XFILLER_0_77_265 VGND VGND VPWR VPWR sky130_fd_sc_hd__fill_2
XFILLER_0_65_405 VGND VGND VPWR VPWR sky130_fd_sc_hd__decap_6
X_6807_ _3384_ VGND VGND VPWR VPWR _0666_ sky130_fd_sc_hd__clkbuf_1
XFILLER_0_92_224 VPWR VGND VPWR VGND sky130_ef_sc_hd__decap_12
XFILLER_0_77_298 VGND VGND VPWR VPWR sky130_fd_sc_hd__fill_2
XANTENNA__7559__RESET_B net816 VGND VGND VPWR VPWR sky130_fd_sc_hd__diode_2
XFILLER_0_65_449 VGND VGND VPWR VPWR sky130_fd_sc_hd__fill_2
XFILLER_0_108_529 VGND VGND VPWR VPWR sky130_fd_sc_hd__decap_3
XFILLER_0_92_268 VGND VGND VPWR VPWR sky130_fd_sc_hd__fill_2
X_4999_ u_pe_array.u_fifo2.buffer\[8\]\[2\] _1960_ _1988_ _1992_ _0819_ VGND VGND
+ VPWR VPWR _1993_ sky130_fd_sc_hd__a221o_2
X_6738_ _3347_ VGND VGND VPWR VPWR _0634_ sky130_fd_sc_hd__clkbuf_1
XFILLER_0_45_140 VGND VGND VPWR VPWR sky130_fd_sc_hd__fill_1
XFILLER_0_18_354 VGND VGND VPWR VPWR sky130_fd_sc_hd__decap_8
XFILLER_0_73_493 VGND VGND VPWR VPWR sky130_fd_sc_hd__fill_2
X_6669_ u_pe_array.u_fifo1.rd_ptr\[0\] _3306_ _3307_ VGND VGND VPWR VPWR _0605_ sky130_fd_sc_hd__o21a_1
XFILLER_0_60_132 VGND VGND VPWR VPWR sky130_fd_sc_hd__fill_2
XFILLER_0_60_110 VGND VGND VPWR VPWR sky130_fd_sc_hd__fill_2
XANTENNA__5704__A0 net33 VGND VGND VPWR VPWR sky130_fd_sc_hd__diode_2
XFILLER_0_103_223 VGND VGND VPWR VPWR sky130_fd_sc_hd__fill_1
XFILLER_0_5_281 VGND VGND VPWR VPWR sky130_fd_sc_hd__fill_2
XANTENNA__4883__B _1847_ VGND VGND VPWR VPWR sky130_fd_sc_hd__diode_2
XTAP_1431 VGND VPWR sky130_fd_sc_hd__tapvpwrvgnd_1
XTAP_1442 VGND VPWR sky130_fd_sc_hd__tapvpwrvgnd_1
XTAP_1420 VGND VPWR sky130_fd_sc_hd__tapvpwrvgnd_1
XTAP_1475 VGND VPWR sky130_fd_sc_hd__tapvpwrvgnd_1
XTAP_1464 VGND VPWR sky130_fd_sc_hd__tapvpwrvgnd_1
XTAP_1453 VGND VPWR sky130_fd_sc_hd__tapvpwrvgnd_1
XFILLER_0_83_202 VGND VGND VPWR VPWR sky130_fd_sc_hd__fill_1
XFILLER_0_56_416 VGND VGND VPWR VPWR sky130_fd_sc_hd__fill_2
XTAP_1497 VGND VPWR sky130_fd_sc_hd__tapvpwrvgnd_1
XTAP_1486 VGND VPWR sky130_fd_sc_hd__tapvpwrvgnd_1
XANTENNA__7229__RESET_B net813 VGND VGND VPWR VPWR sky130_fd_sc_hd__diode_2
XFILLER_0_107_573 VPWR VGND VPWR VGND sky130_ef_sc_hd__decap_12
XFILLER_0_3_207 VGND VGND VPWR VPWR sky130_fd_sc_hd__fill_2
XFILLER_0_51_165 VGND VGND VPWR VPWR sky130_fd_sc_hd__decap_3
XFILLER_0_3_229 VGND VGND VPWR VPWR sky130_fd_sc_hd__fill_1
XFILLER_0_20_530 VGND VGND VPWR VPWR sky130_fd_sc_hd__fill_2
XFILLER_0_20_541 VGND VGND VPWR VPWR sky130_fd_sc_hd__fill_2
XFILLER_0_19_54 VGND VGND VPWR VPWR sky130_fd_sc_hd__fill_2
X_4020_ _1178_ _1179_ VGND VGND VPWR VPWR _1180_ sky130_fd_sc_hd__nor2_1
Xclkbuf_leaf_1_clk clknet_3_0__leaf_clk VGND VGND VPWR VPWR clknet_leaf_1_clk sky130_fd_sc_hd__clkbuf_16
XANTENNA__6423__A1 _1812_ VGND VGND VPWR VPWR sky130_fd_sc_hd__diode_2
XFILLER_0_59_221 VGND VGND VPWR VPWR sky130_fd_sc_hd__fill_1
X_5971_ _2804_ VGND VGND VPWR VPWR _2807_ sky130_fd_sc_hd__inv_2
X_4922_ _1923_ _1924_ VGND VGND VPWR VPWR _1925_ sky130_fd_sc_hd__nand2_1
XFILLER_0_35_86 VGND VGND VPWR VPWR sky130_fd_sc_hd__fill_1
XFILLER_0_35_97 VGND VGND VPWR VPWR sky130_fd_sc_hd__decap_6
X_7641_ clknet_leaf_26_clk _0690_ VGND VGND VPWR VPWR u_pe_array.u_fifo1.buffer\[5\]\[12\]
+ sky130_fd_sc_hd__dfxtp_1
XFILLER_0_74_202 VGND VGND VPWR VPWR sky130_fd_sc_hd__fill_1
X_4853_ _1854_ _1860_ _0885_ VGND VGND VPWR VPWR _1862_ sky130_fd_sc_hd__o21a_1
XANTENNA__3629__S _0734_ VGND VGND VPWR VPWR sky130_fd_sc_hd__diode_2
X_7572_ clknet_leaf_29_clk _0621_ VGND VGND VPWR VPWR u_pe_array.u_fifo1.buffer\[0\]\[8\]
+ sky130_fd_sc_hd__dfxtp_1
XFILLER_0_28_674 VGND VGND VPWR VPWR sky130_fd_sc_hd__decap_3
X_4784_ _1787_ _0853_ _1002_ _0747_ VGND VGND VPWR VPWR _1814_ sky130_fd_sc_hd__a22o_4
X_3804_ u_pe_array.g_pe_row\[3\].g_pe_col\[2\].u_pe.psum_out\[8\] u_pe_array.g_pe_row\[3\].g_pe_col\[2\].u_pe.move_reg\[8\]
+ _0745_ VGND VGND VPWR VPWR _1001_ sky130_fd_sc_hd__mux2_1
XANTENNA__5934__B1 _2571_ VGND VGND VPWR VPWR sky130_fd_sc_hd__diode_2
X_6523_ net511 _1802_ _3224_ VGND VGND VPWR VPWR _3228_ sky130_fd_sc_hd__mux2_1
XFILLER_0_15_324 VGND VGND VPWR VPWR sky130_fd_sc_hd__fill_2
X_3735_ _0902_ _0911_ _0924_ _0946_ VGND VGND VPWR VPWR _0947_ sky130_fd_sc_hd__or4bb_1
XFILLER_0_27_173 VGND VGND VPWR VPWR sky130_fd_sc_hd__fill_2
X_6454_ net226 _1816_ net68 VGND VGND VPWR VPWR _3191_ sky130_fd_sc_hd__mux2_1
X_5405_ net110 _2144_ _2335_ _2336_ VGND VGND VPWR VPWR _0312_ sky130_fd_sc_hd__a22o_1
X_3666_ _0877_ _0883_ VGND VGND VPWR VPWR _0884_ sky130_fd_sc_hd__nand2_1
XANTENNA__5162__A1 _1725_ VGND VGND VPWR VPWR sky130_fd_sc_hd__diode_2
XFILLER_0_42_187 VGND VGND VPWR VPWR sky130_fd_sc_hd__fill_2
XFILLER_0_62_3 VPWR VGND VPWR VGND sky130_ef_sc_hd__decap_12
X_6385_ u_pe_array.u_fifo2.rd_ptr\[2\] _3148_ VGND VGND VPWR VPWR _3150_ sky130_fd_sc_hd__and2_1
XFILLER_0_11_541 VPWR VGND VPWR VGND sky130_ef_sc_hd__decap_12
X_3597_ _0830_ VGND VGND VPWR VPWR _0010_ sky130_fd_sc_hd__clkbuf_1
XFILLER_0_2_251 VGND VGND VPWR VPWR sky130_fd_sc_hd__fill_1
X_5336_ u_pe_array.u_fifo1.buffer\[0\]\[0\] _2275_ VGND VGND VPWR VPWR _2276_ sky130_fd_sc_hd__or2_1
XANTENNA__3712__A2 _0875_ VGND VGND VPWR VPWR sky130_fd_sc_hd__diode_2
X_5267_ u_pe_array.g_pe_row\[1\].g_pe_col\[2\].u_pe.psum_out\[5\] _2203_ _2215_ VGND
+ VGND VPWR VPWR _2216_ sky130_fd_sc_hd__a21o_1
X_4218_ _1335_ _1342_ VGND VGND VPWR VPWR _1346_ sky130_fd_sc_hd__nand2_1
X_7006_ clknet_leaf_14_clk _0083_ net816 VGND VGND VPWR VPWR u_pe_array.g_pe_row\[3\].g_pe_col\[1\].u_pe.psum_out\[3\]
+ sky130_fd_sc_hd__dfrtp_1
X_5198_ net160 _2144_ _2153_ _1665_ VGND VGND VPWR VPWR _0288_ sky130_fd_sc_hd__a22o_1
X_4149_ u_pe_array.g_pe_row\[3\].g_pe_col\[0\].u_pe.act_val\[0\] _1274_ _1275_ VGND
+ VGND VPWR VPWR _1283_ sky130_fd_sc_hd__a21bo_1
XANTENNA__4425__B1 _1258_ VGND VGND VPWR VPWR sky130_fd_sc_hd__diode_2
XFILLER_0_78_585 VGND VGND VPWR VPWR sky130_fd_sc_hd__decap_3
XANTENNA__7393__RESET_B net818 VGND VGND VPWR VPWR sky130_fd_sc_hd__diode_2
XANTENNA__6178__B1 _0866_ VGND VGND VPWR VPWR sky130_fd_sc_hd__diode_2
XANTENNA__7322__RESET_B net814 VGND VGND VPWR VPWR sky130_fd_sc_hd__diode_2
XANTENNA__4224__A _1275_ VGND VGND VPWR VPWR sky130_fd_sc_hd__diode_2
XFILLER_0_80_205 VGND VGND VPWR VPWR sky130_fd_sc_hd__decap_3
XFILLER_0_65_279 VGND VGND VPWR VPWR sky130_fd_sc_hd__fill_1
XFILLER_0_46_460 VGND VGND VPWR VPWR sky130_fd_sc_hd__fill_2
XFILLER_0_18_173 VGND VGND VPWR VPWR sky130_fd_sc_hd__fill_1
XFILLER_0_104_565 VGND VGND VPWR VPWR sky130_fd_sc_hd__fill_1
XFILLER_0_104_543 VGND VGND VPWR VPWR sky130_fd_sc_hd__decap_6
XFILLER_0_33_176 VGND VGND VPWR VPWR sky130_fd_sc_hd__fill_1
XANTENNA__6350__A0 _3126_ VGND VGND VPWR VPWR sky130_fd_sc_hd__diode_2
XANTENNA__6585__S _3254_ VGND VGND VPWR VPWR sky130_fd_sc_hd__diode_2
XFILLER_0_88_305 VGND VGND VPWR VPWR sky130_fd_sc_hd__decap_3
XFILLER_0_72_29 VPWR VGND VPWR VGND sky130_ef_sc_hd__decap_12
XFILLER_0_84_522 VGND VGND VPWR VPWR sky130_fd_sc_hd__fill_2
XTAP_1250 VGND VPWR sky130_fd_sc_hd__tapvpwrvgnd_1
XFILLER_0_29_405 VGND VGND VPWR VPWR sky130_fd_sc_hd__fill_2
XTAP_1272 VGND VPWR sky130_fd_sc_hd__tapvpwrvgnd_1
XTAP_1283 VGND VPWR sky130_fd_sc_hd__tapvpwrvgnd_1
XTAP_1261 VGND VPWR sky130_fd_sc_hd__tapvpwrvgnd_1
XFILLER_0_84_533 VGND VGND VPWR VPWR sky130_fd_sc_hd__fill_2
XANTENNA__7063__RESET_B net819 VGND VGND VPWR VPWR sky130_fd_sc_hd__diode_2
XTAP_1294 VGND VPWR sky130_fd_sc_hd__tapvpwrvgnd_1
XFILLER_0_44_419 VGND VGND VPWR VPWR sky130_fd_sc_hd__fill_1
XFILLER_0_114_307 VGND VGND VPWR VPWR sky130_fd_sc_hd__fill_1
XFILLER_0_37_493 VGND VGND VPWR VPWR sky130_fd_sc_hd__fill_2
XFILLER_0_114_329 VGND VGND VPWR VPWR sky130_fd_sc_hd__fill_1
X_3520_ u_pe_array.g_pe_row\[1\].g_pe_col\[0\].u_pe.psum_out\[8\] _0769_ _0773_ _0754_
+ VGND VGND VPWR VPWR net47 sky130_fd_sc_hd__o211a_2
XFILLER_0_97_15 VPWR VGND VPWR VGND sky130_ef_sc_hd__decap_12
XFILLER_0_52_485 VGND VGND VPWR VPWR sky130_fd_sc_hd__decap_3
XFILLER_0_12_316 VGND VGND VPWR VPWR sky130_fd_sc_hd__fill_1
Xhold718 u_pe_array.g_pe_row\[0\].g_pe_col\[3\].u_pe.act_val\[0\] VGND VGND VPWR VPWR
+ net794 sky130_fd_sc_hd__dlygate4sd3_1
Xhold707 u_pe_array.g_pe_row\[3\].g_pe_col\[3\].u_pe.psum_out\[10\] VGND VGND VPWR
+ VPWR net783 sky130_fd_sc_hd__dlygate4sd3_1
XANTENNA__6341__A0 _3120_ VGND VGND VPWR VPWR sky130_fd_sc_hd__diode_2
X_3451_ _0720_ _0725_ VGND VGND VPWR VPWR _0726_ sky130_fd_sc_hd__nand2_1
XFILLER_0_12_349 VPWR VGND VPWR VGND sky130_ef_sc_hd__decap_12
XANTENNA__5144__A1 _1725_ VGND VGND VPWR VPWR sky130_fd_sc_hd__diode_2
Xhold729 u_pe_array.g_pe_row\[2\].g_pe_col\[3\].u_pe.psum_out\[12\] VGND VGND VPWR
+ VPWR net805 sky130_fd_sc_hd__dlygate4sd3_1
XFILLER_0_110_557 VPWR VGND VPWR VGND sky130_ef_sc_hd__decap_12
X_6170_ _0914_ _2973_ _2974_ _0861_ _2970_ VGND VGND VPWR VPWR _0439_ sky130_fd_sc_hd__o32ai_1
X_5121_ _2094_ _2092_ _2096_ VGND VGND VPWR VPWR _2097_ sky130_fd_sc_hd__or3_1
X_5052_ u_pe_array.g_pe_row\[1\].g_pe_col\[3\].u_pe.w_reg\[0\] u_pe_array.g_pe_row\[1\].g_pe_col\[3\].u_pe.act_val\[1\]
+ _2032_ _2033_ VGND VGND VPWR VPWR _2034_ sky130_fd_sc_hd__a22o_1
X_4003_ u_pe_array.g_pe_row\[3\].g_pe_col\[1\].u_pe.act_val\[1\] _1145_ u_pe_array.g_pe_row\[3\].g_pe_col\[1\].u_pe.psum_out\[2\]
+ VGND VGND VPWR VPWR _1164_ sky130_fd_sc_hd__and3b_1
X_5954_ _2776_ _2777_ _2790_ VGND VGND VPWR VPWR _2792_ sky130_fd_sc_hd__nor3_1
X_4905_ _1909_ VGND VGND VPWR VPWR _1910_ sky130_fd_sc_hd__inv_2
X_5885_ net118 _2600_ _2733_ _0722_ VGND VGND VPWR VPWR _0395_ sky130_fd_sc_hd__a22o_1
XANTENNA__3630__B2 u_fsm.psum_shift_en VGND VGND VPWR VPWR sky130_fd_sc_hd__diode_2
XANTENNA__3867__B _1009_ VGND VGND VPWR VPWR sky130_fd_sc_hd__diode_2
X_7624_ clknet_leaf_30_clk _0673_ VGND VGND VPWR VPWR u_pe_array.u_fifo1.buffer\[4\]\[8\]
+ sky130_fd_sc_hd__dfxtp_1
X_4836_ u_pe_array.g_pe_row\[2\].g_pe_col\[0\].u_pe.act_val\[1\] u_pe_array.g_pe_row\[2\].g_pe_col\[0\].u_pe.w_reg\[0\]
+ VGND VGND VPWR VPWR _1846_ sky130_fd_sc_hd__nand2_1
XFILLER_0_28_460 VGND VGND VPWR VPWR sky130_fd_sc_hd__fill_2
X_7555_ clknet_leaf_18_clk _0604_ net816 VGND VGND VPWR VPWR u_pe_array.u_fifo1.wr_ptr\[3\]
+ sky130_fd_sc_hd__dfrtp_1
XFILLER_0_28_471 VGND VGND VPWR VPWR sky130_fd_sc_hd__fill_2
XFILLER_0_28_493 VGND VGND VPWR VPWR sky130_fd_sc_hd__fill_2
X_4767_ _1802_ net533 _1796_ VGND VGND VPWR VPWR _1803_ sky130_fd_sc_hd__mux2_1
X_6506_ net348 _1814_ _3208_ VGND VGND VPWR VPWR _3218_ sky130_fd_sc_hd__mux2_1
X_4698_ _1733_ _1738_ _1741_ VGND VGND VPWR VPWR _1743_ sky130_fd_sc_hd__or3_1
X_7486_ clknet_leaf_6_clk _0535_ VGND VGND VPWR VPWR u_pe_array.u_fifo2.buffer\[3\]\[12\]
+ sky130_fd_sc_hd__dfxtp_1
XFILLER_0_15_187 VGND VGND VPWR VPWR sky130_fd_sc_hd__fill_2
X_3718_ u_pe_array.g_pe_row\[3\].g_pe_col\[3\].u_pe.psum_out\[5\] _0919_ _0931_ VGND
+ VGND VPWR VPWR _0932_ sky130_fd_sc_hd__a21o_1
XFILLER_0_113_373 VPWR VGND VPWR VGND sky130_ef_sc_hd__decap_12
XFILLER_0_101_513 VGND VGND VPWR VPWR sky130_fd_sc_hd__decap_3
XFILLER_0_101_502 VGND VGND VPWR VPWR sky130_fd_sc_hd__fill_2
XANTENNA_load_slew1_A net75 VGND VGND VPWR VPWR sky130_fd_sc_hd__diode_2
X_3649_ u_pe_array.g_pe_row\[3\].g_pe_col\[3\].u_pe.act_val\[1\] u_pe_array.g_pe_row\[3\].g_pe_col\[3\].u_pe.w_reg\[0\]
+ VGND VGND VPWR VPWR _0868_ sky130_fd_sc_hd__nand2_1
X_6437_ _3182_ VGND VGND VPWR VPWR _0498_ sky130_fd_sc_hd__clkbuf_1
X_6368_ _3139_ VGND VGND VPWR VPWR _0472_ sky130_fd_sc_hd__clkbuf_1
XFILLER_0_30_157 VGND VGND VPWR VPWR sky130_fd_sc_hd__fill_2
XFILLER_0_30_179 VGND VGND VPWR VPWR sky130_fd_sc_hd__fill_2
X_5319_ _2254_ _2256_ _2262_ VGND VGND VPWR VPWR _2263_ sky130_fd_sc_hd__o21ai_1
X_6299_ u_pe_array.g_pe_row\[0\].g_pe_col\[0\].u_pe.psum_out\[10\] _2992_ VGND VGND
+ VPWR VPWR _3087_ sky130_fd_sc_hd__nand2_1
Xhold12 u_pe_array.g_pe_row\[2\].g_pe_col\[1\].u_pe.w_buffer\[1\] VGND VGND VPWR VPWR
+ net88 sky130_fd_sc_hd__dlygate4sd3_1
Xhold23 u_pe_array.g_pe_row\[1\].g_pe_col\[3\].u_pe.w_buffer\[0\] VGND VGND VPWR VPWR
+ net99 sky130_fd_sc_hd__dlygate4sd3_1
XANTENNA__6635__A1 net11 VGND VGND VPWR VPWR sky130_fd_sc_hd__diode_2
Xhold34 u_pe_array.g_pe_row\[1\].g_pe_col\[0\].u_pe.move_reg\[8\] VGND VGND VPWR VPWR
+ net110 sky130_fd_sc_hd__dlygate4sd3_1
Xhold45 u_pe_array.g_pe_row\[1\].g_pe_col\[0\].u_pe.move_reg\[6\] VGND VGND VPWR VPWR
+ net121 sky130_fd_sc_hd__dlygate4sd3_1
Xhold56 u_pe_array.g_pe_row\[0\].g_pe_col\[2\].u_pe.move_reg\[8\] VGND VGND VPWR VPWR
+ net132 sky130_fd_sc_hd__dlygate4sd3_1
Xhold67 u_pe_array.g_pe_row\[2\].g_pe_col\[0\].u_pe.move_reg\[11\] VGND VGND VPWR
+ VPWR net143 sky130_fd_sc_hd__dlygate4sd3_1
Xhold89 _0287_ VGND VGND VPWR VPWR net165 sky130_fd_sc_hd__dlygate4sd3_1
Xhold78 u_pe_array.g_pe_row\[0\].g_pe_col\[2\].u_pe.move_reg\[6\] VGND VGND VPWR VPWR
+ net154 sky130_fd_sc_hd__dlygate4sd3_1
XANTENNA__4110__A2 _1138_ VGND VGND VPWR VPWR sky130_fd_sc_hd__diode_2
XFILLER_0_97_113 VGND VGND VPWR VPWR sky130_fd_sc_hd__fill_2
XFILLER_0_85_319 VGND VGND VPWR VPWR sky130_fd_sc_hd__decap_3
XFILLER_0_78_360 VGND VGND VPWR VPWR sky130_fd_sc_hd__decap_4
XFILLER_0_93_341 VGND VGND VPWR VPWR sky130_fd_sc_hd__fill_1
XFILLER_0_93_330 VGND VGND VPWR VPWR sky130_fd_sc_hd__decap_6
XFILLER_0_81_503 VGND VGND VPWR VPWR sky130_fd_sc_hd__fill_1
XFILLER_0_26_419 VGND VGND VPWR VPWR sky130_fd_sc_hd__fill_1
XFILLER_0_108_178 VGND VGND VPWR VPWR sky130_fd_sc_hd__fill_1
XFILLER_0_21_102 VGND VGND VPWR VPWR sky130_fd_sc_hd__fill_1
XFILLER_0_34_474 VGND VGND VPWR VPWR sky130_fd_sc_hd__fill_2
XTAP_319 VGND VPWR sky130_fd_sc_hd__tapvpwrvgnd_1
XTAP_308 VGND VPWR sky130_fd_sc_hd__tapvpwrvgnd_1
XANTENNA__5513__A _2345_ VGND VGND VPWR VPWR sky130_fd_sc_hd__diode_2
XANTENNA__4637__B1 _0885_ VGND VGND VPWR VPWR sky130_fd_sc_hd__diode_2
XFILLER_0_107_57 VPWR VGND VPWR VGND sky130_ef_sc_hd__decap_12
XFILLER_0_89_625 VGND VGND VPWR VPWR sky130_fd_sc_hd__fill_1
XFILLER_0_89_669 VGND VGND VPWR VPWR sky130_fd_sc_hd__decap_3
XANTENNA__7244__RESET_B net813 VGND VGND VPWR VPWR sky130_fd_sc_hd__diode_2
XFILLER_0_57_522 VGND VGND VPWR VPWR sky130_fd_sc_hd__fill_2
XFILLER_0_57_533 VGND VGND VPWR VPWR sky130_fd_sc_hd__decap_4
X_5670_ _2545_ _2559_ _2560_ VGND VGND VPWR VPWR _2561_ sky130_fd_sc_hd__a21oi_1
XTAP_1091 VGND VPWR sky130_fd_sc_hd__tapvpwrvgnd_1
XTAP_1080 VGND VPWR sky130_fd_sc_hd__tapvpwrvgnd_1
XFILLER_0_57_577 VGND VGND VPWR VPWR sky130_fd_sc_hd__decap_8
XFILLER_0_8_129 VGND VGND VPWR VPWR sky130_fd_sc_hd__fill_1
X_4621_ u_pe_array.g_pe_row\[2\].g_pe_col\[1\].u_pe.w_reg\[1\] VGND VGND VPWR VPWR
+ _1672_ sky130_fd_sc_hd__clkbuf_8
XANTENNA_clkbuf_0_clk_A clk VGND VGND VPWR VPWR sky130_fd_sc_hd__diode_2
XFILLER_0_44_238 VGND VGND VPWR VPWR sky130_fd_sc_hd__fill_2
X_7340_ clknet_leaf_51_clk net366 net812 VGND VGND VPWR VPWR u_pe_array.g_pe_row\[0\].g_pe_col\[1\].u_pe.move_reg\[9\]
+ sky130_fd_sc_hd__dfrtp_1
XFILLER_0_4_346 VGND VGND VPWR VPWR sky130_fd_sc_hd__fill_1
X_4552_ u_pe_array.g_pe_row\[2\].g_pe_col\[2\].u_pe.psum_out\[8\] _1620_ _1622_ _1612_
+ VGND VGND VPWR VPWR _1623_ sky130_fd_sc_hd__a22o_1
X_3503_ _0762_ VGND VGND VPWR VPWR net41 sky130_fd_sc_hd__clkbuf_1
Xhold515 u_pe_array.g_pe_row\[3\].g_pe_col\[1\].u_pe.psum_out\[1\] VGND VGND VPWR
+ VPWR net591 sky130_fd_sc_hd__dlygate4sd3_1
Xhold526 u_pe_array.g_pe_row\[0\].g_pe_col\[2\].u_pe.psum_out\[9\] VGND VGND VPWR
+ VPWR net602 sky130_fd_sc_hd__dlygate4sd3_1
X_4483_ u_pe_array.g_pe_row\[2\].g_pe_col\[2\].u_pe.w_reg\[0\] u_pe_array.g_pe_row\[2\].g_pe_col\[2\].u_pe.act_val\[2\]
+ _1545_ VGND VGND VPWR VPWR _1560_ sky130_fd_sc_hd__and3_1
XFILLER_0_13_669 VGND VGND VPWR VPWR sky130_fd_sc_hd__decap_3
Xhold504 u_pe_array.u_fifo2.buffer\[6\]\[4\] VGND VGND VPWR VPWR net580 sky130_fd_sc_hd__dlygate4sd3_1
X_7271_ clknet_leaf_79_clk _0332_ net814 VGND VGND VPWR VPWR u_pe_array.g_pe_row\[0\].g_pe_col\[3\].u_pe.act_val\[0\]
+ sky130_fd_sc_hd__dfrtp_2
XFILLER_0_110_321 VPWR VGND VPWR VGND sky130_ef_sc_hd__decap_12
X_6222_ _3012_ _3016_ VGND VGND VPWR VPWR _3017_ sky130_fd_sc_hd__xnor2_1
Xhold559 u_pe_array.g_pe_row\[1\].g_pe_col\[2\].u_pe.psum_out\[9\] VGND VGND VPWR
+ VPWR net635 sky130_fd_sc_hd__dlygate4sd3_1
Xhold537 u_pe_array.g_pe_row\[3\].g_pe_col\[2\].u_pe.psum_out\[1\] VGND VGND VPWR
+ VPWR net613 sky130_fd_sc_hd__dlygate4sd3_1
Xhold548 u_pe_array.g_pe_row\[3\].g_pe_col\[3\].u_pe.move_reg\[12\] VGND VGND VPWR
+ VPWR net624 sky130_fd_sc_hd__dlygate4sd3_1
XFILLER_0_40_477 VGND VGND VPWR VPWR sky130_fd_sc_hd__decap_3
XFILLER_0_110_365 VGND VGND VPWR VPWR sky130_fd_sc_hd__decap_3
X_6153_ _2957_ _2958_ VGND VGND VPWR VPWR _2959_ sky130_fd_sc_hd__nor2_1
XFILLER_0_57_51 VGND VGND VPWR VPWR sky130_fd_sc_hd__decap_4
XTAP_853 VGND VPWR sky130_fd_sc_hd__tapvpwrvgnd_1
XTAP_842 VGND VPWR sky130_fd_sc_hd__tapvpwrvgnd_1
XTAP_831 VGND VPWR sky130_fd_sc_hd__tapvpwrvgnd_1
XTAP_820 VGND VPWR sky130_fd_sc_hd__tapvpwrvgnd_1
XANTENNA__6617__A1 _1812_ VGND VGND VPWR VPWR sky130_fd_sc_hd__diode_2
X_6084_ u_pe_array.g_pe_row\[0\].g_pe_col\[1\].u_pe.psum_out\[3\] _2895_ VGND VGND
+ VPWR VPWR _2896_ sky130_fd_sc_hd__xor2_1
XTAP_875 VGND VPWR sky130_fd_sc_hd__tapvpwrvgnd_1
XTAP_886 VGND VPWR sky130_fd_sc_hd__tapvpwrvgnd_1
XTAP_864 VGND VPWR sky130_fd_sc_hd__tapvpwrvgnd_1
X_5104_ _2078_ _2080_ _0914_ VGND VGND VPWR VPWR _2082_ sky130_fd_sc_hd__a21oi_1
XTAP_897 VGND VPWR sky130_fd_sc_hd__tapvpwrvgnd_1
X_5035_ net147 _1666_ _2022_ _1665_ VGND VGND VPWR VPWR _0256_ sky130_fd_sc_hd__a22o_1
XFILLER_0_79_113 VGND VGND VPWR VPWR sky130_fd_sc_hd__fill_2
XFILLER_0_25_3 VGND VGND VPWR VPWR sky130_fd_sc_hd__decap_4
XFILLER_0_73_50 VGND VGND VPWR VPWR sky130_fd_sc_hd__decap_6
XANTENNA__5569__S _2469_ VGND VGND VPWR VPWR sky130_fd_sc_hd__diode_2
XANTENNA__3851__A1 _0864_ VGND VGND VPWR VPWR sky130_fd_sc_hd__diode_2
X_6986_ clknet_leaf_15_clk _0065_ net816 VGND VGND VPWR VPWR u_pe_array.g_pe_row\[3\].g_pe_col\[1\].u_pe.w_buffer\[0\]
+ sky130_fd_sc_hd__dfrtp_1
XFILLER_0_87_190 VGND VGND VPWR VPWR sky130_fd_sc_hd__fill_1
X_5937_ _2774_ u_pe_array.g_pe_row\[0\].g_pe_col\[2\].u_pe.psum_out\[4\] _2743_ VGND
+ VGND VPWR VPWR _2776_ sky130_fd_sc_hd__and3_1
XANTENNA__6967__RESET_B net74 VGND VGND VPWR VPWR sky130_fd_sc_hd__diode_2
X_7607_ clknet_leaf_22_clk _0656_ VGND VGND VPWR VPWR u_pe_array.u_fifo1.buffer\[3\]\[4\]
+ sky130_fd_sc_hd__dfxtp_1
X_5868_ net32 u_pe_array.g_pe_row\[0\].g_pe_col\[2\].u_pe.w_buffer\[1\] _0827_ VGND
+ VGND VPWR VPWR _2725_ sky130_fd_sc_hd__mux2_1
XFILLER_0_63_558 VGND VGND VPWR VPWR sky130_fd_sc_hd__fill_2
XFILLER_0_28_290 VGND VGND VPWR VPWR sky130_fd_sc_hd__fill_1
X_5799_ u_pe_array.g_pe_row\[0\].g_pe_col\[3\].u_pe.psum_out\[5\] _2655_ _2663_ VGND
+ VGND VPWR VPWR _2664_ sky130_fd_sc_hd__a21o_1
X_4819_ _1836_ VGND VGND VPWR VPWR _0226_ sky130_fd_sc_hd__clkbuf_1
X_7538_ clknet_leaf_6_clk _0587_ VGND VGND VPWR VPWR u_pe_array.u_fifo2.buffer\[7\]\[12\]
+ sky130_fd_sc_hd__dfxtp_1
XANTENNA__6305__B1 _0866_ VGND VGND VPWR VPWR sky130_fd_sc_hd__diode_2
XANTENNA__4859__D _1847_ VGND VGND VPWR VPWR sky130_fd_sc_hd__diode_2
X_7469_ clknet_leaf_0_clk _0518_ VGND VGND VPWR VPWR u_pe_array.u_fifo2.buffer\[2\]\[8\]
+ sky130_fd_sc_hd__dfxtp_1
XANTENNA__6856__A1 _3134_ VGND VGND VPWR VPWR sky130_fd_sc_hd__diode_2
Xoutput46 net46 VGND VGND VPWR VPWR psum_out0[7] sky130_fd_sc_hd__clkbuf_4
Xoutput35 net35 VGND VGND VPWR VPWR done sky130_fd_sc_hd__buf_2
Xoutput57 net57 VGND VGND VPWR VPWR psum_out1[5] sky130_fd_sc_hd__clkbuf_4
XFILLER_0_101_387 VGND VGND VPWR VPWR sky130_fd_sc_hd__decap_3
XFILLER_0_101_376 VGND VGND VPWR VPWR sky130_fd_sc_hd__fill_1
XANTENNA__4619__B1 _1534_ VGND VGND VPWR VPWR sky130_fd_sc_hd__diode_2
XANTENNA__5987__B _2743_ VGND VGND VPWR VPWR sky130_fd_sc_hd__diode_2
XANTENNA_clkbuf_leaf_2_clk_A clknet_3_0__leaf_clk VGND VGND VPWR VPWR sky130_fd_sc_hd__diode_2
XFILLER_0_86_617 VGND VGND VPWR VPWR sky130_fd_sc_hd__fill_2
XFILLER_0_94_661 VGND VGND VPWR VPWR sky130_fd_sc_hd__fill_2
XPHY_152 VGND VGND VPWR VPWR sky130_fd_sc_hd__decap_3
XPHY_141 VGND VGND VPWR VPWR sky130_fd_sc_hd__decap_3
XFILLER_0_66_363 VGND VGND VPWR VPWR sky130_fd_sc_hd__fill_1
XFILLER_0_66_341 VGND VGND VPWR VPWR sky130_fd_sc_hd__fill_2
XPHY_130 VGND VGND VPWR VPWR sky130_fd_sc_hd__decap_3
XFILLER_0_109_443 VGND VGND VPWR VPWR sky130_fd_sc_hd__decap_4
XPHY_185 VGND VGND VPWR VPWR sky130_fd_sc_hd__decap_3
XPHY_174 VGND VGND VPWR VPWR sky130_fd_sc_hd__decap_3
XPHY_163 VGND VGND VPWR VPWR sky130_fd_sc_hd__decap_3
XPHY_196 VGND VGND VPWR VPWR sky130_fd_sc_hd__decap_3
XFILLER_0_81_366 VGND VGND VPWR VPWR sky130_fd_sc_hd__fill_2
Xclkbuf_3_1__f_clk clknet_0_clk VGND VGND VPWR VPWR clknet_3_1__leaf_clk sky130_fd_sc_hd__clkbuf_16
XFILLER_0_105_671 VGND VGND VPWR VPWR sky130_fd_sc_hd__fill_1
XFILLER_0_1_349 VPWR VGND VPWR VGND sky130_ef_sc_hd__decap_12
XANTENNA__4858__B1 _1847_ VGND VGND VPWR VPWR sky130_fd_sc_hd__diode_2
XANTENNA__7425__RESET_B net74 VGND VGND VPWR VPWR sky130_fd_sc_hd__diode_2
XFILLER_0_89_444 VGND VGND VPWR VPWR sky130_fd_sc_hd__fill_2
XANTENNA__3698__A net72 VGND VGND VPWR VPWR sky130_fd_sc_hd__diode_2
X_6840_ net466 _3118_ _3397_ VGND VGND VPWR VPWR _3402_ sky130_fd_sc_hd__mux2_1
XFILLER_0_89_499 VGND VGND VPWR VPWR sky130_fd_sc_hd__fill_1
XFILLER_0_49_308 VGND VGND VPWR VPWR sky130_fd_sc_hd__fill_2
XANTENNA__4293__S _0855_ VGND VGND VPWR VPWR sky130_fd_sc_hd__diode_2
X_6771_ _3364_ VGND VGND VPWR VPWR _0650_ sky130_fd_sc_hd__clkbuf_1
XFILLER_0_9_416 VPWR VGND VPWR VGND sky130_ef_sc_hd__decap_12
X_3983_ u_pe_array.g_pe_row\[3\].g_pe_col\[1\].u_pe.act_val\[0\] _1145_ u_pe_array.g_pe_row\[3\].g_pe_col\[1\].u_pe.psum_out\[1\]
+ VGND VGND VPWR VPWR _1146_ sky130_fd_sc_hd__a21oi_1
X_5722_ net154 _2463_ _2599_ _2336_ VGND VGND VPWR VPWR _0366_ sky130_fd_sc_hd__a22o_1
XFILLER_0_9_449 VGND VGND VPWR VPWR sky130_fd_sc_hd__decap_3
XFILLER_0_84_182 VGND VGND VPWR VPWR sky130_fd_sc_hd__fill_2
XFILLER_0_84_193 VGND VGND VPWR VPWR sky130_fd_sc_hd__decap_3
X_5653_ u_pe_array.g_pe_row\[1\].g_pe_col\[0\].u_pe.psum_out\[7\] _2478_ VGND VGND
+ VPWR VPWR _2545_ sky130_fd_sc_hd__nand2_1
XANTENNA__5889__A2 _2600_ VGND VGND VPWR VPWR sky130_fd_sc_hd__diode_2
XANTENNA__5418__A u_pe_array.g_pe_row\[1\].g_pe_col\[1\].u_pe.w_reg\[0\] VGND VGND
+ VPWR VPWR sky130_fd_sc_hd__diode_2
X_5584_ _2479_ _2480_ _2477_ VGND VGND VPWR VPWR _2482_ sky130_fd_sc_hd__o21ai_1
X_4604_ net620 _1524_ _1660_ _1399_ VGND VGND VPWR VPWR _0187_ sky130_fd_sc_hd__a22o_1
XFILLER_0_4_121 VPWR VGND VPWR VGND sky130_ef_sc_hd__decap_12
Xhold301 u_pe_array.g_pe_row\[0\].g_pe_col\[2\].u_pe.psum_out\[3\] VGND VGND VPWR
+ VPWR net377 sky130_fd_sc_hd__dlygate4sd3_1
XFILLER_0_4_165 VPWR VGND VPWR VGND sky130_ef_sc_hd__decap_12
XFILLER_0_13_433 VGND VGND VPWR VPWR sky130_fd_sc_hd__fill_2
X_4535_ _1596_ _1603_ VGND VGND VPWR VPWR _1607_ sky130_fd_sc_hd__nand2_1
X_7323_ clknet_leaf_67_clk _0380_ net814 VGND VGND VPWR VPWR u_pe_array.g_pe_row\[0\].g_pe_col\[3\].u_pe.psum_out\[7\]
+ sky130_fd_sc_hd__dfrtp_4
Xhold334 u_pe_array.g_pe_row\[0\].g_pe_col\[0\].u_pe.psum_out\[0\] VGND VGND VPWR
+ VPWR net410 sky130_fd_sc_hd__dlygate4sd3_1
Xhold312 u_pe_array.u_fifo1.buffer\[0\]\[0\] VGND VGND VPWR VPWR net388 sky130_fd_sc_hd__dlygate4sd3_1
Xhold323 u_pe_array.g_pe_row\[1\].g_pe_col\[0\].u_pe.psum_out\[3\] VGND VGND VPWR
+ VPWR net399 sky130_fd_sc_hd__dlygate4sd3_1
XFILLER_0_111_641 VPWR VGND VPWR VGND sky130_ef_sc_hd__decap_12
Xhold356 u_pe_array.g_pe_row\[0\].g_pe_col\[0\].u_pe.psum_out\[3\] VGND VGND VPWR
+ VPWR net432 sky130_fd_sc_hd__dlygate4sd3_1
Xhold367 u_pe_array.u_fifo1.buffer\[7\]\[3\] VGND VGND VPWR VPWR net443 sky130_fd_sc_hd__dlygate4sd3_1
X_7254_ clknet_leaf_39_clk net107 net813 VGND VGND VPWR VPWR u_pe_array.g_pe_row\[1\].g_pe_col\[1\].u_pe.w_reg\[0\]
+ sky130_fd_sc_hd__dfrtp_4
Xhold345 u_pe_array.g_pe_row\[1\].g_pe_col\[0\].u_pe.psum_out\[4\] VGND VGND VPWR
+ VPWR net421 sky130_fd_sc_hd__dlygate4sd3_1
X_4466_ u_pe_array.g_pe_row\[2\].g_pe_col\[2\].u_pe.act_val\[0\] _1535_ _1536_ VGND
+ VGND VPWR VPWR _1544_ sky130_fd_sc_hd__a21bo_1
Xhold378 u_pe_array.u_fifo2.buffer\[4\]\[0\] VGND VGND VPWR VPWR net454 sky130_fd_sc_hd__dlygate4sd3_1
X_6205_ u_pe_array.g_pe_row\[0\].g_pe_col\[0\].u_pe.psum_out\[2\] _3000_ VGND VGND
+ VPWR VPWR _3001_ sky130_fd_sc_hd__xnor2_1
Xhold389 u_pe_array.u_fifo1.buffer\[2\]\[3\] VGND VGND VPWR VPWR net465 sky130_fd_sc_hd__dlygate4sd3_1
X_7185_ clknet_leaf_61_clk _0252_ net73 VGND VGND VPWR VPWR u_pe_array.g_pe_row\[1\].g_pe_col\[2\].u_pe.act_val\[4\]
+ sky130_fd_sc_hd__dfrtp_1
XFILLER_0_7_97 VPWR VGND VPWR VGND sky130_ef_sc_hd__decap_12
X_4397_ u_pe_array.g_pe_row\[2\].g_pe_col\[3\].u_pe.psum_out\[7\] u_pe_array.g_pe_row\[2\].g_pe_col\[3\].u_pe.psum_out\[8\]
+ _1407_ VGND VGND VPWR VPWR _1495_ sky130_fd_sc_hd__o21a_1
XANTENNA__3880__B _1009_ VGND VGND VPWR VPWR sky130_fd_sc_hd__diode_2
X_6136_ _2922_ VGND VGND VPWR VPWR _2943_ sky130_fd_sc_hd__inv_2
XFILLER_0_0_393 VGND VGND VPWR VPWR sky130_fd_sc_hd__fill_2
XTAP_650 VGND VPWR sky130_fd_sc_hd__tapvpwrvgnd_1
XTAP_661 VGND VPWR sky130_fd_sc_hd__tapvpwrvgnd_1
XANTENNA__7166__RESET_B net817 VGND VGND VPWR VPWR sky130_fd_sc_hd__diode_2
XTAP_672 VGND VPWR sky130_fd_sc_hd__tapvpwrvgnd_1
XTAP_683 VGND VPWR sky130_fd_sc_hd__tapvpwrvgnd_1
XTAP_694 VGND VPWR sky130_fd_sc_hd__tapvpwrvgnd_1
X_6067_ u_pe_array.g_pe_row\[0\].g_pe_col\[1\].u_pe.psum_out\[1\] _2876_ _2879_ VGND
+ VGND VPWR VPWR _2880_ sky130_fd_sc_hd__a21o_1
XANTENNA__5274__B1 _2071_ VGND VGND VPWR VPWR sky130_fd_sc_hd__diode_2
XANTENNA__4992__A _1787_ VGND VGND VPWR VPWR sky130_fd_sc_hd__diode_2
X_5018_ u_pe_array.g_pe_row\[0\].g_pe_col\[2\].u_pe.act_val\[4\] u_pe_array.g_pe_row\[0\].g_pe_col\[2\].u_pe.psum_out\[4\]
+ _0756_ VGND VGND VPWR VPWR _2010_ sky130_fd_sc_hd__mux2_1
XFILLER_0_68_617 VGND VGND VPWR VPWR sky130_fd_sc_hd__fill_2
X_6969_ clknet_leaf_83_clk _0050_ net818 VGND VGND VPWR VPWR u_pe_array.g_pe_row\[3\].g_pe_col\[1\].u_pe.move_reg\[11\]
+ sky130_fd_sc_hd__dfrtp_1
XFILLER_0_48_396 VGND VGND VPWR VPWR sky130_fd_sc_hd__fill_2
XFILLER_0_106_413 VGND VGND VPWR VPWR sky130_fd_sc_hd__fill_2
XANTENNA__4232__A _1275_ VGND VGND VPWR VPWR sky130_fd_sc_hd__diode_2
XFILLER_0_63_399 VGND VGND VPWR VPWR sky130_fd_sc_hd__fill_1
XANTENNA__6593__S _3254_ VGND VGND VPWR VPWR sky130_fd_sc_hd__diode_2
XFILLER_0_59_617 VGND VGND VPWR VPWR sky130_fd_sc_hd__fill_2
XFILLER_0_59_606 VGND VGND VPWR VPWR sky130_fd_sc_hd__fill_2
XFILLER_0_80_29 VGND VGND VPWR VPWR sky130_fd_sc_hd__fill_2
XANTENNA__5568__B2 _2336_ VGND VGND VPWR VPWR sky130_fd_sc_hd__diode_2
XFILLER_0_27_503 VGND VGND VPWR VPWR sky130_fd_sc_hd__fill_1
XFILLER_0_27_514 VGND VGND VPWR VPWR sky130_fd_sc_hd__decap_3
XFILLER_0_82_664 VGND VGND VPWR VPWR sky130_fd_sc_hd__decap_3
XFILLER_0_82_642 VGND VGND VPWR VPWR sky130_fd_sc_hd__fill_2
XFILLER_0_66_193 VGND VGND VPWR VPWR sky130_fd_sc_hd__decap_3
XFILLER_0_54_333 VGND VGND VPWR VPWR sky130_fd_sc_hd__fill_1
XFILLER_0_13_78 VGND VGND VPWR VPWR sky130_fd_sc_hd__decap_3
XFILLER_0_112_427 VGND VGND VPWR VPWR sky130_fd_sc_hd__fill_1
XFILLER_0_1_113 VGND VGND VPWR VPWR sky130_fd_sc_hd__decap_8
XFILLER_0_2_625 VPWR VGND VPWR VGND sky130_ef_sc_hd__decap_12
XFILLER_0_50_583 VGND VGND VPWR VPWR sky130_fd_sc_hd__decap_4
X_4320_ u_pe_array.g_pe_row\[2\].g_pe_col\[3\].u_pe.act_val\[1\] _1407_ u_pe_array.g_pe_row\[2\].g_pe_col\[3\].u_pe.psum_out\[2\]
+ VGND VGND VPWR VPWR _1425_ sky130_fd_sc_hd__and3b_1
XFILLER_0_2_669 VGND VGND VPWR VPWR sky130_fd_sc_hd__decap_8
X_4251_ _0914_ _1375_ _1376_ _0861_ _1372_ VGND VGND VPWR VPWR _0118_ sky130_fd_sc_hd__o32ai_1
XFILLER_0_10_469 VGND VGND VPWR VPWR sky130_fd_sc_hd__decap_6
XFILLER_0_10_447 VGND VGND VPWR VPWR sky130_fd_sc_hd__decap_3
X_4182_ _1312_ _1313_ VGND VGND VPWR VPWR _1314_ sky130_fd_sc_hd__or2_1
XFILLER_0_54_41 VGND VGND VPWR VPWR sky130_fd_sc_hd__decap_3
XANTENNA__5420__B _2345_ VGND VGND VPWR VPWR sky130_fd_sc_hd__diode_2
XFILLER_0_77_436 VGND VGND VPWR VPWR sky130_fd_sc_hd__decap_4
X_6823_ _3392_ VGND VGND VPWR VPWR _0674_ sky130_fd_sc_hd__clkbuf_1
XFILLER_0_77_458 VGND VGND VPWR VPWR sky130_fd_sc_hd__fill_2
X_3966_ net161 _0996_ _1135_ _1004_ VGND VGND VPWR VPWR _0074_ sky130_fd_sc_hd__a22o_1
X_6754_ net465 _3116_ net63 VGND VGND VPWR VPWR _3356_ sky130_fd_sc_hd__mux2_1
X_5705_ _2590_ VGND VGND VPWR VPWR _0358_ sky130_fd_sc_hd__clkbuf_1
XANTENNA__4231__B2 _0916_ VGND VGND VPWR VPWR sky130_fd_sc_hd__diode_2
XFILLER_0_70_73 VGND VGND VPWR VPWR sky130_fd_sc_hd__fill_2
X_6685_ _3316_ _3318_ VGND VGND VPWR VPWR _0610_ sky130_fd_sc_hd__xnor2_1
XFILLER_0_57_193 VGND VGND VPWR VPWR sky130_fd_sc_hd__fill_1
XFILLER_0_9_279 VGND VGND VPWR VPWR sky130_fd_sc_hd__fill_1
XFILLER_0_18_558 VGND VGND VPWR VPWR sky130_fd_sc_hd__decap_6
XFILLER_0_72_141 VGND VGND VPWR VPWR sky130_fd_sc_hd__decap_3
X_5636_ _2528_ _2529_ VGND VGND VPWR VPWR _2530_ sky130_fd_sc_hd__nand2_1
X_3897_ _1074_ _1080_ VGND VGND VPWR VPWR _1082_ sky130_fd_sc_hd__or2_1
XANTENNA__5148__A _2029_ VGND VGND VPWR VPWR sky130_fd_sc_hd__diode_2
XANTENNA__5731__B2 _2336_ VGND VGND VPWR VPWR sky130_fd_sc_hd__diode_2
X_5567_ u_pe_array.g_pe_row\[1\].g_pe_col\[3\].u_pe.psum_out\[8\] u_pe_array.g_pe_row\[1\].g_pe_col\[3\].u_pe.move_reg\[8\]
+ _2469_ VGND VGND VPWR VPWR _2471_ sky130_fd_sc_hd__mux2_1
XFILLER_0_41_550 VGND VGND VPWR VPWR sky130_fd_sc_hd__fill_2
XFILLER_0_41_561 VGND VGND VPWR VPWR sky130_fd_sc_hd__fill_2
Xhold153 u_pe_array.u_fifo1.buffer\[4\]\[10\] VGND VGND VPWR VPWR net229 sky130_fd_sc_hd__dlygate4sd3_1
X_5498_ _2406_ _2413_ VGND VGND VPWR VPWR _2417_ sky130_fd_sc_hd__nand2_1
Xhold131 u_pe_array.g_pe_row\[1\].g_pe_col\[2\].u_pe.move_reg\[7\] VGND VGND VPWR
+ VPWR net207 sky130_fd_sc_hd__dlygate4sd3_1
Xhold142 u_pe_array.u_fifo2.buffer\[3\]\[7\] VGND VGND VPWR VPWR net218 sky130_fd_sc_hd__dlygate4sd3_1
X_4518_ _1536_ _1590_ u_pe_array.g_pe_row\[2\].g_pe_col\[2\].u_pe.psum_out\[6\] VGND
+ VGND VPWR VPWR _1592_ sky130_fd_sc_hd__a21oi_1
Xhold120 _0105_ VGND VGND VPWR VPWR net196 sky130_fd_sc_hd__dlygate4sd3_1
X_7306_ clknet_leaf_63_clk _0365_ net814 VGND VGND VPWR VPWR u_pe_array.g_pe_row\[0\].g_pe_col\[2\].u_pe.act_val\[5\]
+ sky130_fd_sc_hd__dfrtp_1
Xhold164 u_pe_array.u_fifo1.buffer\[7\]\[10\] VGND VGND VPWR VPWR net240 sky130_fd_sc_hd__dlygate4sd3_1
X_7237_ clknet_leaf_52_clk _0300_ net812 VGND VGND VPWR VPWR u_pe_array.g_pe_row\[1\].g_pe_col\[2\].u_pe.psum_out\[11\]
+ sky130_fd_sc_hd__dfrtp_1
Xhold175 u_pe_array.u_fifo2.buffer\[6\]\[12\] VGND VGND VPWR VPWR net251 sky130_fd_sc_hd__dlygate4sd3_1
X_4449_ u_pe_array.g_pe_row\[3\].g_pe_col\[1\].u_pe.psum_out\[12\] net173 _0855_ VGND
+ VGND VPWR VPWR _1530_ sky130_fd_sc_hd__mux2_1
Xhold186 u_pe_array.u_fifo2.buffer\[4\]\[7\] VGND VGND VPWR VPWR net262 sky130_fd_sc_hd__dlygate4sd3_1
XANTENNA__7347__RESET_B net818 VGND VGND VPWR VPWR sky130_fd_sc_hd__diode_2
Xhold197 u_pe_array.u_fifo1.buffer\[0\]\[8\] VGND VGND VPWR VPWR net273 sky130_fd_sc_hd__dlygate4sd3_1
X_7168_ clknet_leaf_32_clk _0235_ net817 VGND VGND VPWR VPWR u_pe_array.g_pe_row\[2\].g_pe_col\[0\].u_pe.psum_out\[2\]
+ sky130_fd_sc_hd__dfrtp_2
XANTENNA__6039__A2 _2738_ VGND VGND VPWR VPWR sky130_fd_sc_hd__diode_2
X_6119_ _2873_ _2927_ u_pe_array.g_pe_row\[0\].g_pe_col\[1\].u_pe.psum_out\[6\] VGND
+ VGND VPWR VPWR _2928_ sky130_fd_sc_hd__and3_1
X_7099_ clknet_leaf_92_clk _0170_ net819 VGND VGND VPWR VPWR u_pe_array.g_pe_row\[2\].g_pe_col\[2\].u_pe.psum_out\[6\]
+ sky130_fd_sc_hd__dfrtp_1
XTAP_491 VGND VPWR sky130_fd_sc_hd__tapvpwrvgnd_1
XTAP_480 VGND VPWR sky130_fd_sc_hd__tapvpwrvgnd_1
XANTENNA__6982__RESET_B net74 VGND VGND VPWR VPWR sky130_fd_sc_hd__diode_2
XTAP_1624 VGND VPWR sky130_fd_sc_hd__tapvpwrvgnd_1
XTAP_1613 VGND VPWR sky130_fd_sc_hd__tapvpwrvgnd_1
XTAP_1602 VGND VPWR sky130_fd_sc_hd__tapvpwrvgnd_1
XANTENNA__6145__C _2873_ VGND VGND VPWR VPWR sky130_fd_sc_hd__diode_2
XFILLER_0_68_469 VGND VGND VPWR VPWR sky130_fd_sc_hd__decap_6
XFILLER_0_95_288 VGND VGND VPWR VPWR sky130_fd_sc_hd__fill_2
XFILLER_0_36_333 VGND VGND VPWR VPWR sky130_fd_sc_hd__fill_2
XANTENNA__3981__B1 _1144_ VGND VGND VPWR VPWR sky130_fd_sc_hd__diode_2
XFILLER_0_63_185 VGND VGND VPWR VPWR sky130_fd_sc_hd__fill_2
XANTENNA__5722__B2 _2336_ VGND VGND VPWR VPWR sky130_fd_sc_hd__diode_2
XFILLER_0_32_561 VGND VGND VPWR VPWR sky130_fd_sc_hd__decap_8
XANTENNA__3733__B1 _0867_ VGND VGND VPWR VPWR sky130_fd_sc_hd__diode_2
XANTENNA__7088__RESET_B net816 VGND VGND VPWR VPWR sky130_fd_sc_hd__diode_2
XANTENNA__7017__RESET_B net817 VGND VGND VPWR VPWR sky130_fd_sc_hd__diode_2
XFILLER_0_91_39 VGND VGND VPWR VPWR sky130_fd_sc_hd__fill_1
XFILLER_0_59_458 VGND VGND VPWR VPWR sky130_fd_sc_hd__fill_2
X_3820_ u_pe_array.g_pe_row\[3\].g_pe_col\[2\].u_pe.act_val\[0\] u_pe_array.g_pe_row\[3\].g_pe_col\[2\].u_pe.psum_out\[1\]
+ _1009_ VGND VGND VPWR VPWR _1011_ sky130_fd_sc_hd__and3_1
X_3751_ _0951_ _0959_ _0960_ _0961_ VGND VGND VPWR VPWR _0962_ sky130_fd_sc_hd__a31o_1
XFILLER_0_54_141 VGND VGND VPWR VPWR sky130_fd_sc_hd__fill_2
XFILLER_0_15_528 VGND VGND VPWR VPWR sky130_fd_sc_hd__decap_4
X_3682_ _0895_ _0897_ VGND VGND VPWR VPWR _0899_ sky130_fd_sc_hd__nand2_1
X_6470_ _3199_ VGND VGND VPWR VPWR _0514_ sky130_fd_sc_hd__clkbuf_1
XFILLER_0_42_325 VGND VGND VPWR VPWR sky130_fd_sc_hd__fill_1
X_5421_ _2344_ _2346_ VGND VGND VPWR VPWR _2347_ sky130_fd_sc_hd__xor2_1
XANTENNA__6498__S _3208_ VGND VGND VPWR VPWR sky130_fd_sc_hd__diode_2
X_5352_ _1787_ _2291_ VGND VGND VPWR VPWR _2292_ sky130_fd_sc_hd__or2_1
XFILLER_0_2_433 VPWR VGND VPWR VGND sky130_ef_sc_hd__decap_12
X_4303_ _1406_ _1408_ _1409_ VGND VGND VPWR VPWR _1410_ sky130_fd_sc_hd__or3_1
XFILLER_0_2_477 VPWR VGND VPWR VGND sky130_ef_sc_hd__decap_12
X_5283_ _2217_ _2227_ VGND VGND VPWR VPWR _2230_ sky130_fd_sc_hd__and2_1
XFILLER_0_10_277 VGND VGND VPWR VPWR sky130_fd_sc_hd__fill_1
XFILLER_0_10_266 VGND VGND VPWR VPWR sky130_fd_sc_hd__fill_2
X_7022_ clknet_leaf_77_clk _0099_ net815 VGND VGND VPWR VPWR u_pe_array.g_pe_row\[2\].g_pe_col\[3\].u_pe.act_val\[4\]
+ sky130_fd_sc_hd__dfrtp_1
X_4234_ _1359_ _1360_ VGND VGND VPWR VPWR _1361_ sky130_fd_sc_hd__nor2_1
XFILLER_0_4_10 VPWR VGND VPWR VGND sky130_ef_sc_hd__decap_12
X_4165_ u_pe_array.g_pe_row\[3\].g_pe_col\[0\].u_pe.psum_out\[3\] _1297_ VGND VGND
+ VPWR VPWR _1298_ sky130_fd_sc_hd__xor2_1
XFILLER_0_65_51 VGND VGND VPWR VPWR sky130_fd_sc_hd__decap_4
XFILLER_0_4_65 VPWR VGND VPWR VGND sky130_ef_sc_hd__decap_12
XFILLER_0_97_509 VGND VGND VPWR VPWR sky130_fd_sc_hd__fill_1
X_4096_ _1239_ _1241_ _1247_ VGND VGND VPWR VPWR _1249_ sky130_fd_sc_hd__or3_1
XFILLER_0_77_222 VGND VGND VPWR VPWR sky130_fd_sc_hd__fill_2
XFILLER_0_77_255 VGND VGND VPWR VPWR sky130_fd_sc_hd__fill_1
XANTENNA_clkbuf_leaf_42_clk_A clknet_3_6__leaf_clk VGND VGND VPWR VPWR sky130_fd_sc_hd__diode_2
X_6806_ net470 _3112_ _3382_ VGND VGND VPWR VPWR _3384_ sky130_fd_sc_hd__mux2_1
XFILLER_0_77_277 VGND VGND VPWR VPWR sky130_fd_sc_hd__fill_1
XFILLER_0_92_247 VGND VGND VPWR VPWR sky130_fd_sc_hd__fill_1
XFILLER_0_92_236 VGND VGND VPWR VPWR sky130_fd_sc_hd__decap_4
XFILLER_0_58_491 VGND VGND VPWR VPWR sky130_fd_sc_hd__fill_2
X_4998_ u_pe_array.u_fifo2.buffer\[6\]\[2\] _1964_ _1989_ _1991_ VGND VGND VPWR VPWR
+ _1992_ sky130_fd_sc_hd__a211o_1
X_6737_ net235 _3126_ net64 VGND VGND VPWR VPWR _3347_ sky130_fd_sc_hd__mux2_1
XANTENNA__3963__A0 u_pe_array.g_pe_row\[2\].g_pe_col\[0\].u_pe.move_reg\[6\] VGND
+ VGND VPWR VPWR sky130_fd_sc_hd__diode_2
X_3949_ net16 _1124_ _0819_ VGND VGND VPWR VPWR _1125_ sky130_fd_sc_hd__mux2_1
XFILLER_0_45_152 VGND VGND VPWR VPWR sky130_fd_sc_hd__fill_1
X_6668_ u_pe_array.u_fifo1.rd_ptr\[0\] _2273_ _3306_ VGND VGND VPWR VPWR _3307_ sky130_fd_sc_hd__o21ai_1
XANTENNA__5704__A1 u_pe_array.g_pe_row\[0\].g_pe_col\[3\].u_pe.w_buffer\[0\] VGND
+ VGND VPWR VPWR sky130_fd_sc_hd__diode_2
XANTENNA_clkbuf_leaf_57_clk_A clknet_3_6__leaf_clk VGND VGND VPWR VPWR sky130_fd_sc_hd__diode_2
X_5619_ _2512_ _2513_ VGND VGND VPWR VPWR _2514_ sky130_fd_sc_hd__nor2_1
X_6599_ _1792_ u_pe_array.u_fifo2.wr_ptr\[1\] _3222_ VGND VGND VPWR VPWR _3268_ sky130_fd_sc_hd__and3_1
XFILLER_0_33_358 VGND VGND VPWR VPWR sky130_fd_sc_hd__fill_2
XFILLER_0_60_177 VGND VGND VPWR VPWR sky130_fd_sc_hd__fill_1
XANTENNA__7181__RESET_B net73 VGND VGND VPWR VPWR sky130_fd_sc_hd__diode_2
XFILLER_0_14_594 VGND VGND VPWR VPWR sky130_fd_sc_hd__decap_4
XANTENNA__7110__RESET_B net76 VGND VGND VPWR VPWR sky130_fd_sc_hd__diode_2
XANTENNA__3479__C1 _0747_ VGND VGND VPWR VPWR sky130_fd_sc_hd__diode_2
XANTENNA__4309__B_N _1407_ VGND VGND VPWR VPWR sky130_fd_sc_hd__diode_2
XFILLER_0_68_222 VGND VGND VPWR VPWR sky130_fd_sc_hd__fill_2
XTAP_1432 VGND VPWR sky130_fd_sc_hd__tapvpwrvgnd_1
XTAP_1421 VGND VPWR sky130_fd_sc_hd__tapvpwrvgnd_1
XTAP_1410 VGND VPWR sky130_fd_sc_hd__tapvpwrvgnd_1
XFILLER_0_96_564 VGND VGND VPWR VPWR sky130_fd_sc_hd__fill_1
XTAP_1465 VGND VPWR sky130_fd_sc_hd__tapvpwrvgnd_1
XTAP_1454 VGND VPWR sky130_fd_sc_hd__tapvpwrvgnd_1
XTAP_1443 VGND VPWR sky130_fd_sc_hd__tapvpwrvgnd_1
XFILLER_0_96_575 VGND VGND VPWR VPWR sky130_fd_sc_hd__fill_1
XFILLER_0_83_225 VGND VGND VPWR VPWR sky130_fd_sc_hd__fill_2
XFILLER_0_68_299 VGND VGND VPWR VPWR sky130_fd_sc_hd__fill_1
XANTENNA__3796__A _0832_ VGND VGND VPWR VPWR sky130_fd_sc_hd__diode_2
XTAP_1498 VGND VPWR sky130_fd_sc_hd__tapvpwrvgnd_1
XTAP_1487 VGND VPWR sky130_fd_sc_hd__tapvpwrvgnd_1
XTAP_1476 VGND VPWR sky130_fd_sc_hd__tapvpwrvgnd_1
XFILLER_0_83_247 VGND VGND VPWR VPWR sky130_fd_sc_hd__fill_1
XFILLER_0_49_480 VGND VGND VPWR VPWR sky130_fd_sc_hd__fill_2
XFILLER_0_24_303 VGND VGND VPWR VPWR sky130_fd_sc_hd__fill_2
XFILLER_0_101_15 VPWR VGND VPWR VGND sky130_ef_sc_hd__decap_12
XFILLER_0_107_585 VPWR VGND VPWR VGND sky130_ef_sc_hd__decap_12
XANTENNA__7269__RESET_B net813 VGND VGND VPWR VPWR sky130_fd_sc_hd__diode_2
XFILLER_0_10_46 VGND VGND VPWR VPWR sky130_fd_sc_hd__fill_2
XFILLER_0_10_79 VGND VGND VPWR VPWR sky130_fd_sc_hd__decap_3
XFILLER_0_20_520 VGND VGND VPWR VPWR sky130_fd_sc_hd__fill_2
XANTENNA__6120__A1 _2873_ VGND VGND VPWR VPWR sky130_fd_sc_hd__diode_2
XFILLER_0_19_44 VGND VGND VPWR VPWR sky130_fd_sc_hd__decap_4
XANTENNA__3485__A2 _0745_ VGND VGND VPWR VPWR sky130_fd_sc_hd__diode_2
XANTENNA__3470__S _0730_ VGND VGND VPWR VPWR sky130_fd_sc_hd__diode_2
XANTENNA__6781__S _3366_ VGND VGND VPWR VPWR sky130_fd_sc_hd__diode_2
XFILLER_0_59_200 VGND VGND VPWR VPWR sky130_fd_sc_hd__decap_6
X_5970_ net628 _2387_ _2174_ _2806_ VGND VGND VPWR VPWR _0407_ sky130_fd_sc_hd__a22o_1
XFILLER_0_35_54 VGND VGND VPWR VPWR sky130_fd_sc_hd__fill_2
XFILLER_0_35_65 VGND VGND VPWR VPWR sky130_fd_sc_hd__fill_2
X_4921_ u_pe_array.g_pe_row\[2\].g_pe_col\[0\].u_pe.psum_out\[8\] _1847_ VGND VGND
+ VPWR VPWR _1924_ sky130_fd_sc_hd__or2_1
X_4852_ _1854_ _1860_ VGND VGND VPWR VPWR _1861_ sky130_fd_sc_hd__nand2_1
X_7640_ clknet_leaf_24_clk _0689_ VGND VGND VPWR VPWR u_pe_array.u_fifo1.buffer\[5\]\[11\]
+ sky130_fd_sc_hd__dfxtp_1
XFILLER_0_59_277 VGND VGND VPWR VPWR sky130_fd_sc_hd__decap_3
X_3803_ net159 _0996_ _1000_ u_fsm.psum_shift_en VGND VGND VPWR VPWR _0046_ sky130_fd_sc_hd__a22o_1
X_7571_ clknet_leaf_29_clk _0620_ VGND VGND VPWR VPWR u_pe_array.u_fifo1.buffer\[0\]\[7\]
+ sky130_fd_sc_hd__dfxtp_1
XANTENNA__5395__C1 _0819_ VGND VGND VPWR VPWR sky130_fd_sc_hd__diode_2
XANTENNA__5934__A1 _2740_ VGND VGND VPWR VPWR sky130_fd_sc_hd__diode_2
X_4783_ _1813_ VGND VGND VPWR VPWR _0213_ sky130_fd_sc_hd__clkbuf_1
XFILLER_0_15_303 VGND VGND VPWR VPWR sky130_fd_sc_hd__decap_4
XFILLER_0_27_141 VGND VGND VPWR VPWR sky130_fd_sc_hd__fill_2
XFILLER_0_27_152 VGND VGND VPWR VPWR sky130_fd_sc_hd__decap_3
X_3734_ _0933_ _0943_ VGND VGND VPWR VPWR _0946_ sky130_fd_sc_hd__and2_1
XFILLER_0_27_185 VGND VGND VPWR VPWR sky130_fd_sc_hd__fill_2
X_6522_ _3227_ VGND VGND VPWR VPWR _0538_ sky130_fd_sc_hd__clkbuf_1
X_3665_ _0878_ _0882_ VGND VGND VPWR VPWR _0883_ sky130_fd_sc_hd__xor2_1
X_6453_ _3190_ VGND VGND VPWR VPWR _0506_ sky130_fd_sc_hd__clkbuf_1
XANTENNA__5698__B1 _2174_ VGND VGND VPWR VPWR sky130_fd_sc_hd__diode_2
X_5404_ _0721_ VGND VGND VPWR VPWR _2336_ sky130_fd_sc_hd__clkbuf_8
XFILLER_0_42_166 VGND VGND VPWR VPWR sky130_fd_sc_hd__decap_3
X_6384_ net402 _3148_ VGND VGND VPWR VPWR _0478_ sky130_fd_sc_hd__xor2_1
X_3596_ net90 net82 _0828_ VGND VGND VPWR VPWR _0830_ sky130_fd_sc_hd__mux2_1
X_5335_ _2273_ _2274_ VGND VGND VPWR VPWR _2275_ sky130_fd_sc_hd__or2_2
XFILLER_0_11_553 VGND VGND VPWR VPWR sky130_fd_sc_hd__decap_4
XFILLER_0_55_3 VPWR VGND VPWR VGND sky130_ef_sc_hd__decap_12
X_5266_ u_pe_array.g_pe_row\[1\].g_pe_col\[2\].u_pe.act_val\[5\] u_pe_array.g_pe_row\[1\].g_pe_col\[2\].u_pe.w_reg\[0\]
+ _2201_ VGND VGND VPWR VPWR _2215_ sky130_fd_sc_hd__and3_1
XFILLER_0_11_586 VGND VGND VPWR VPWR sky130_fd_sc_hd__fill_1
X_4217_ _1324_ VGND VGND VPWR VPWR _1345_ sky130_fd_sc_hd__inv_2
XFILLER_0_76_83 VGND VGND VPWR VPWR sky130_fd_sc_hd__fill_1
X_7005_ clknet_leaf_14_clk _0082_ net816 VGND VGND VPWR VPWR u_pe_array.g_pe_row\[3\].g_pe_col\[1\].u_pe.psum_out\[2\]
+ sky130_fd_sc_hd__dfrtp_2
X_5197_ u_pe_array.g_pe_row\[1\].g_pe_col\[2\].u_pe.psum_out\[12\] u_pe_array.g_pe_row\[1\].g_pe_col\[2\].u_pe.move_reg\[12\]
+ _1661_ VGND VGND VPWR VPWR _2153_ sky130_fd_sc_hd__mux2_1
X_4148_ u_pe_array.g_pe_row\[3\].g_pe_col\[0\].u_pe.psum_out\[1\] _1278_ _1281_ VGND
+ VGND VPWR VPWR _1282_ sky130_fd_sc_hd__a21o_1
XFILLER_0_78_531 VGND VGND VPWR VPWR sky130_fd_sc_hd__fill_1
X_4079_ _0864_ _1232_ _1233_ _1144_ net585 VGND VGND VPWR VPWR _0089_ sky130_fd_sc_hd__a32o_1
XFILLER_0_92_82 VGND VGND VPWR VPWR sky130_fd_sc_hd__fill_2
XANTENNA__6178__A1 _2740_ VGND VGND VPWR VPWR sky130_fd_sc_hd__diode_2
XFILLER_0_38_428 VGND VGND VPWR VPWR sky130_fd_sc_hd__fill_2
XANTENNA__5386__C1 _0819_ VGND VGND VPWR VPWR sky130_fd_sc_hd__diode_2
XFILLER_0_19_653 VGND VGND VPWR VPWR sky130_fd_sc_hd__fill_2
XFILLER_0_33_111 VGND VGND VPWR VPWR sky130_fd_sc_hd__fill_1
XANTENNA__3936__B1 _1009_ VGND VGND VPWR VPWR sky130_fd_sc_hd__diode_2
XFILLER_0_104_522 VGND VGND VPWR VPWR sky130_fd_sc_hd__decap_8
XANTENNA__7362__RESET_B net75 VGND VGND VPWR VPWR sky130_fd_sc_hd__diode_2
XANTENNA__6014__A_N _2743_ VGND VGND VPWR VPWR sky130_fd_sc_hd__diode_2
XANTENNA__6866__S _3412_ VGND VGND VPWR VPWR sky130_fd_sc_hd__diode_2
XANTENNA__4113__B1 _1258_ VGND VGND VPWR VPWR sky130_fd_sc_hd__diode_2
XANTENNA__5861__B1 _2611_ VGND VGND VPWR VPWR sky130_fd_sc_hd__diode_2
XANTENNA__5613__B1 _2071_ VGND VGND VPWR VPWR sky130_fd_sc_hd__diode_2
XFILLER_0_69_553 VGND VGND VPWR VPWR sky130_fd_sc_hd__fill_2
XFILLER_0_69_542 VGND VGND VPWR VPWR sky130_fd_sc_hd__fill_2
XFILLER_0_96_372 VGND VGND VPWR VPWR sky130_fd_sc_hd__fill_2
XTAP_1240 VGND VPWR sky130_fd_sc_hd__tapvpwrvgnd_1
XFILLER_0_29_417 VGND VGND VPWR VPWR sky130_fd_sc_hd__fill_2
XTAP_1273 VGND VPWR sky130_fd_sc_hd__tapvpwrvgnd_1
XTAP_1284 VGND VPWR sky130_fd_sc_hd__tapvpwrvgnd_1
XTAP_1262 VGND VPWR sky130_fd_sc_hd__tapvpwrvgnd_1
XTAP_1251 VGND VPWR sky130_fd_sc_hd__tapvpwrvgnd_1
XTAP_1295 VGND VPWR sky130_fd_sc_hd__tapvpwrvgnd_1
XANTENNA__5377__C1 _0819_ VGND VGND VPWR VPWR sky130_fd_sc_hd__diode_2
XFILLER_0_21_23 VGND VGND VPWR VPWR sky130_fd_sc_hd__decap_6
XFILLER_0_107_360 VGND VGND VPWR VPWR sky130_fd_sc_hd__decap_3
XFILLER_0_107_393 VGND VGND VPWR VPWR sky130_fd_sc_hd__fill_2
XANTENNA__7032__RESET_B net817 VGND VGND VPWR VPWR sky130_fd_sc_hd__diode_2
Xhold708 u_pe_array.g_pe_row\[0\].g_pe_col\[0\].u_pe.act_val\[3\] VGND VGND VPWR VPWR
+ net784 sky130_fd_sc_hd__dlygate4sd3_1
XFILLER_0_97_27 VPWR VGND VPWR VGND sky130_ef_sc_hd__decap_12
XFILLER_0_24_166 VGND VGND VPWR VPWR sky130_fd_sc_hd__decap_3
Xhold719 u_pe_array.g_pe_row\[0\].g_pe_col\[2\].u_pe.act_val\[1\] VGND VGND VPWR VPWR
+ net795 sky130_fd_sc_hd__dlygate4sd3_1
XFILLER_0_40_626 VGND VGND VPWR VPWR sky130_fd_sc_hd__fill_2
XANTENNA__4150__A u_pe_array.g_pe_row\[3\].g_pe_col\[0\].u_pe.w_reg\[0\] VGND VGND
+ VPWR VPWR sky130_fd_sc_hd__diode_2
X_3450_ _0717_ _0718_ _0723_ VGND VGND VPWR VPWR _0725_ sky130_fd_sc_hd__or3_1
XFILLER_0_20_361 VGND VGND VPWR VPWR sky130_fd_sc_hd__decap_3
XFILLER_0_110_569 VPWR VGND VPWR VGND sky130_ef_sc_hd__decap_12
X_5120_ u_pe_array.g_pe_row\[1\].g_pe_col\[3\].u_pe.psum_out\[7\] _2095_ _2085_ VGND
+ VGND VPWR VPWR _2096_ sky130_fd_sc_hd__mux2_1
XFILLER_0_20_394 VGND VGND VPWR VPWR sky130_fd_sc_hd__fill_2
X_5051_ _2030_ _2031_ _2028_ VGND VGND VPWR VPWR _2033_ sky130_fd_sc_hd__o21ai_1
X_4002_ _1159_ _1160_ _1162_ VGND VGND VPWR VPWR _1163_ sky130_fd_sc_hd__o21a_1
XANTENNA__5852__B1 _0861_ VGND VGND VPWR VPWR sky130_fd_sc_hd__diode_2
XFILLER_0_1_55 VGND VGND VPWR VPWR sky130_fd_sc_hd__fill_1
XFILLER_0_87_361 VGND VGND VPWR VPWR sky130_fd_sc_hd__fill_1
XFILLER_0_62_41 VPWR VGND VPWR VGND sky130_ef_sc_hd__decap_12
X_5953_ _2776_ _2777_ _2790_ VGND VGND VPWR VPWR _2791_ sky130_fd_sc_hd__o21a_1
XANTENNA__5080__A1 _2029_ VGND VGND VPWR VPWR sky130_fd_sc_hd__diode_2
X_4904_ _1906_ _1907_ _1905_ VGND VGND VPWR VPWR _1909_ sky130_fd_sc_hd__o21a_1
X_5884_ u_pe_array.g_pe_row\[1\].g_pe_col\[1\].u_pe.psum_out\[7\] u_pe_array.g_pe_row\[1\].g_pe_col\[1\].u_pe.move_reg\[7\]
+ _2469_ VGND VGND VPWR VPWR _2733_ sky130_fd_sc_hd__mux2_1
XFILLER_0_75_545 VGND VGND VPWR VPWR sky130_fd_sc_hd__decap_4
XFILLER_0_62_85 VPWR VGND VPWR VGND sky130_ef_sc_hd__decap_12
XANTENNA__3630__A2 _0834_ VGND VGND VPWR VPWR sky130_fd_sc_hd__diode_2
X_7623_ clknet_leaf_25_clk _0672_ VGND VGND VPWR VPWR u_pe_array.u_fifo1.buffer\[4\]\[7\]
+ sky130_fd_sc_hd__dfxtp_1
X_4835_ _1725_ _1843_ _1845_ _1534_ net351 VGND VGND VPWR VPWR _0233_ sky130_fd_sc_hd__a32o_1
XFILLER_0_90_504 VGND VGND VPWR VPWR sky130_fd_sc_hd__decap_3
XANTENNA__5368__C1 _0819_ VGND VGND VPWR VPWR sky130_fd_sc_hd__diode_2
XFILLER_0_7_322 VGND VGND VPWR VPWR sky130_fd_sc_hd__decap_3
XFILLER_0_90_548 VGND VGND VPWR VPWR sky130_fd_sc_hd__fill_1
XFILLER_0_90_526 VGND VGND VPWR VPWR sky130_fd_sc_hd__fill_2
X_7554_ clknet_leaf_17_clk _0603_ net816 VGND VGND VPWR VPWR u_pe_array.u_fifo1.wr_ptr\[2\]
+ sky130_fd_sc_hd__dfrtp_1
X_4766_ _1787_ _0844_ _0992_ _0747_ VGND VGND VPWR VPWR _1802_ sky130_fd_sc_hd__a22o_2
XANTENNA__4591__B1 _1258_ VGND VGND VPWR VPWR sky130_fd_sc_hd__diode_2
X_6505_ _3217_ VGND VGND VPWR VPWR _0531_ sky130_fd_sc_hd__clkbuf_1
X_3717_ u_pe_array.g_pe_row\[3\].g_pe_col\[3\].u_pe.act_val\[5\] u_pe_array.g_pe_row\[3\].g_pe_col\[3\].u_pe.w_reg\[0\]
+ _0918_ VGND VGND VPWR VPWR _0931_ sky130_fd_sc_hd__and3_1
X_4697_ _1733_ _1738_ _1741_ VGND VGND VPWR VPWR _1742_ sky130_fd_sc_hd__o21ai_1
X_7485_ clknet_leaf_0_clk _0534_ VGND VGND VPWR VPWR u_pe_array.u_fifo2.buffer\[3\]\[11\]
+ sky130_fd_sc_hd__dfxtp_1
XFILLER_0_15_177 VGND VGND VPWR VPWR sky130_fd_sc_hd__fill_1
XFILLER_0_3_561 VPWR VGND VPWR VGND sky130_ef_sc_hd__decap_12
X_3648_ _0858_ _0860_ _0864_ _0867_ net358 VGND VGND VPWR VPWR _0024_ sky130_fd_sc_hd__a32o_1
X_6436_ net448 _1798_ net69 VGND VGND VPWR VPWR _3182_ sky130_fd_sc_hd__mux2_1
XFILLER_0_113_385 VGND VGND VPWR VPWR sky130_fd_sc_hd__decap_6
XFILLER_0_101_547 VGND VGND VPWR VPWR sky130_fd_sc_hd__decap_8
XFILLER_0_87_60 VGND VGND VPWR VPWR sky130_fd_sc_hd__fill_1
X_6367_ _1794_ _3137_ _3138_ VGND VGND VPWR VPWR _3139_ sky130_fd_sc_hd__and3_1
X_3579_ net321 _0816_ _0817_ VGND VGND VPWR VPWR _0005_ sky130_fd_sc_hd__o21a_1
XFILLER_0_11_350 VGND VGND VPWR VPWR sky130_fd_sc_hd__decap_4
X_5318_ u_pe_array.g_pe_row\[1\].g_pe_col\[2\].u_pe.psum_out\[11\] _2261_ _2251_ VGND
+ VGND VPWR VPWR _2262_ sky130_fd_sc_hd__mux2_1
XFILLER_0_11_383 VGND VGND VPWR VPWR sky130_fd_sc_hd__fill_2
XFILLER_0_11_361 VPWR VGND VPWR VGND sky130_ef_sc_hd__decap_12
X_6298_ _3079_ _3080_ _3085_ _3082_ _3077_ VGND VGND VPWR VPWR _3086_ sky130_fd_sc_hd__a32o_1
Xhold13 u_pe_array.g_pe_row\[1\].g_pe_col\[3\].u_pe.w_buffer\[1\] VGND VGND VPWR VPWR
+ net89 sky130_fd_sc_hd__dlygate4sd3_1
Xhold24 u_pe_array.g_pe_row\[0\].g_pe_col\[1\].u_pe.w_buffer\[1\] VGND VGND VPWR VPWR
+ net100 sky130_fd_sc_hd__dlygate4sd3_1
Xhold35 _0312_ VGND VGND VPWR VPWR net111 sky130_fd_sc_hd__dlygate4sd3_1
X_5249_ _2189_ _2198_ _0913_ VGND VGND VPWR VPWR _2200_ sky130_fd_sc_hd__a21o_1
Xhold46 u_pe_array.g_pe_row\[3\].g_pe_col\[1\].u_pe.move_reg\[10\] VGND VGND VPWR
+ VPWR net122 sky130_fd_sc_hd__dlygate4sd3_1
Xhold68 _0190_ VGND VGND VPWR VPWR net144 sky130_fd_sc_hd__dlygate4sd3_1
Xhold79 _0366_ VGND VGND VPWR VPWR net155 sky130_fd_sc_hd__dlygate4sd3_1
Xhold57 u_pe_array.g_pe_row\[0\].g_pe_col\[3\].u_pe.move_reg\[6\] VGND VGND VPWR VPWR
+ net133 sky130_fd_sc_hd__dlygate4sd3_1
XFILLER_0_66_501 VGND VGND VPWR VPWR sky130_fd_sc_hd__fill_2
XFILLER_0_38_236 VPWR VGND VPWR VGND sky130_ef_sc_hd__decap_12
XFILLER_0_93_375 VGND VGND VPWR VPWR sky130_fd_sc_hd__fill_2
XANTENNA__5359__C1 _0819_ VGND VGND VPWR VPWR sky130_fd_sc_hd__diode_2
XANTENNA__7543__RESET_B net815 VGND VGND VPWR VPWR sky130_fd_sc_hd__diode_2
XFILLER_0_38_269 VGND VGND VPWR VPWR sky130_fd_sc_hd__fill_1
XANTENNA__4582__A0 u_pe_array.g_pe_row\[1\].g_pe_col\[1\].u_pe.w_buffer\[0\] VGND
+ VGND VPWR VPWR sky130_fd_sc_hd__diode_2
XFILLER_0_61_294 VGND VGND VPWR VPWR sky130_fd_sc_hd__fill_2
XFILLER_0_22_659 VGND VGND VPWR VPWR sky130_fd_sc_hd__fill_2
XTAP_309 VGND VPWR sky130_fd_sc_hd__tapvpwrvgnd_1
XFILLER_0_96_180 VGND VGND VPWR VPWR sky130_fd_sc_hd__fill_2
XFILLER_0_84_320 VGND VGND VPWR VPWR sky130_fd_sc_hd__fill_2
XFILLER_0_9_609 VGND VGND VPWR VPWR sky130_fd_sc_hd__decap_6
XFILLER_0_29_225 VGND VGND VPWR VPWR sky130_fd_sc_hd__fill_2
XANTENNA__7284__RESET_B net75 VGND VGND VPWR VPWR sky130_fd_sc_hd__diode_2
XTAP_1092 VGND VPWR sky130_fd_sc_hd__tapvpwrvgnd_1
XTAP_1081 VGND VPWR sky130_fd_sc_hd__tapvpwrvgnd_1
XTAP_1070 VGND VPWR sky130_fd_sc_hd__tapvpwrvgnd_1
XFILLER_0_57_589 VGND VGND VPWR VPWR sky130_fd_sc_hd__fill_2
XFILLER_0_32_33 VGND VGND VPWR VPWR sky130_fd_sc_hd__fill_1
X_4620_ u_pe_array.g_pe_row\[2\].g_pe_col\[1\].u_pe.w_reg\[0\] u_pe_array.g_pe_row\[2\].g_pe_col\[1\].u_pe.act_val\[1\]
+ VGND VGND VPWR VPWR _1671_ sky130_fd_sc_hd__nand2_1
XANTENNA__7213__RESET_B net75 VGND VGND VPWR VPWR sky130_fd_sc_hd__diode_2
XANTENNA__6011__B1 _2571_ VGND VGND VPWR VPWR sky130_fd_sc_hd__diode_2
XFILLER_0_114_105 VGND VGND VPWR VPWR sky130_fd_sc_hd__fill_1
XFILLER_0_113_3 VPWR VGND VPWR VGND sky130_ef_sc_hd__decap_12
XFILLER_0_52_261 VGND VGND VPWR VPWR sky130_fd_sc_hd__fill_1
X_4551_ _1620_ _1621_ VGND VGND VPWR VPWR _1622_ sky130_fd_sc_hd__nor2_1
X_7270_ clknet_leaf_42_clk _0331_ net75 VGND VGND VPWR VPWR u_pe_array.g_pe_row\[1\].g_pe_col\[0\].u_pe.w_buffer\[1\]
+ sky130_fd_sc_hd__dfrtp_1
X_3502_ _0754_ _0761_ VGND VGND VPWR VPWR _0762_ sky130_fd_sc_hd__and2_1
Xhold505 u_pe_array.u_fifo1.count\[2\] VGND VGND VPWR VPWR net581 sky130_fd_sc_hd__dlygate4sd3_1
Xhold516 u_pe_array.g_pe_row\[2\].g_pe_col\[1\].u_pe.act_val\[5\] VGND VGND VPWR VPWR
+ net592 sky130_fd_sc_hd__dlygate4sd3_1
X_4482_ u_pe_array.g_pe_row\[2\].g_pe_col\[2\].u_pe.psum_out\[3\] _1558_ VGND VGND
+ VPWR VPWR _1559_ sky130_fd_sc_hd__xor2_1
XFILLER_0_4_369 VGND VGND VPWR VPWR sky130_fd_sc_hd__decap_3
XFILLER_0_13_637 VPWR VGND VPWR VGND sky130_ef_sc_hd__decap_12
XANTENNA__5117__A2 _1714_ VGND VGND VPWR VPWR sky130_fd_sc_hd__diode_2
Xhold527 u_pe_array.g_pe_row\[1\].g_pe_col\[3\].u_pe.act_val\[3\] VGND VGND VPWR VPWR
+ net603 sky130_fd_sc_hd__dlygate4sd3_1
X_6221_ _3014_ _3015_ VGND VGND VPWR VPWR _3016_ sky130_fd_sc_hd__nor2_1
Xhold549 u_pe_array.g_pe_row\[2\].g_pe_col\[0\].u_pe.act_val\[3\] VGND VGND VPWR VPWR
+ net625 sky130_fd_sc_hd__dlygate4sd3_1
Xhold538 u_pe_array.g_pe_row\[1\].g_pe_col\[3\].u_pe.move_reg\[8\] VGND VGND VPWR
+ VPWR net614 sky130_fd_sc_hd__dlygate4sd3_1
XFILLER_0_40_467 VGND VGND VPWR VPWR sky130_fd_sc_hd__fill_2
XFILLER_0_110_333 VPWR VGND VPWR VGND sky130_ef_sc_hd__decap_12
X_6152_ _2873_ u_pe_array.g_pe_row\[0\].g_pe_col\[1\].u_pe.psum_out\[9\] VGND VGND
+ VPWR VPWR _2958_ sky130_fd_sc_hd__nor2_1
XTAP_810 VGND VPWR sky130_fd_sc_hd__tapvpwrvgnd_1
XFILLER_0_40_489 VGND VGND VPWR VPWR sky130_fd_sc_hd__decap_3
XTAP_843 VGND VPWR sky130_fd_sc_hd__tapvpwrvgnd_1
XTAP_832 VGND VPWR sky130_fd_sc_hd__tapvpwrvgnd_1
XTAP_821 VGND VPWR sky130_fd_sc_hd__tapvpwrvgnd_1
X_5103_ _2078_ _2080_ VGND VGND VPWR VPWR _2081_ sky130_fd_sc_hd__or2_1
X_6083_ _2892_ _2894_ VGND VGND VPWR VPWR _2895_ sky130_fd_sc_hd__nand2_1
XTAP_876 VGND VPWR sky130_fd_sc_hd__tapvpwrvgnd_1
XTAP_865 VGND VPWR sky130_fd_sc_hd__tapvpwrvgnd_1
XTAP_854 VGND VPWR sky130_fd_sc_hd__tapvpwrvgnd_1
XTAP_898 VGND VPWR sky130_fd_sc_hd__tapvpwrvgnd_1
XTAP_887 VGND VPWR sky130_fd_sc_hd__tapvpwrvgnd_1
X_5034_ u_pe_array.g_pe_row\[0\].g_pe_col\[2\].u_pe.psum_out\[8\] u_pe_array.g_pe_row\[0\].g_pe_col\[2\].u_pe.move_reg\[8\]
+ _1661_ VGND VGND VPWR VPWR _2022_ sky130_fd_sc_hd__mux2_1
XFILLER_0_18_3 VGND VGND VPWR VPWR sky130_fd_sc_hd__fill_2
XFILLER_0_79_169 VGND VGND VPWR VPWR sky130_fd_sc_hd__decap_4
XFILLER_0_67_309 VGND VGND VPWR VPWR sky130_fd_sc_hd__decap_8
X_6985_ clknet_leaf_83_clk _0064_ net818 VGND VGND VPWR VPWR u_pe_array.g_pe_row\[3\].g_pe_col\[2\].u_pe.psum_out\[12\]
+ sky130_fd_sc_hd__dfrtp_1
X_5936_ _2774_ _2743_ u_pe_array.g_pe_row\[0\].g_pe_col\[2\].u_pe.psum_out\[4\] VGND
+ VGND VPWR VPWR _2775_ sky130_fd_sc_hd__a21oi_1
X_7606_ clknet_leaf_20_clk _0655_ VGND VGND VPWR VPWR u_pe_array.u_fifo1.buffer\[3\]\[3\]
+ sky130_fd_sc_hd__dfxtp_1
XANTENNA__6002__B1 _2571_ VGND VGND VPWR VPWR sky130_fd_sc_hd__diode_2
XFILLER_0_48_589 VGND VGND VPWR VPWR sky130_fd_sc_hd__decap_3
X_5867_ _2724_ VGND VGND VPWR VPWR _0386_ sky130_fd_sc_hd__clkbuf_1
X_5798_ u_pe_array.g_pe_row\[0\].g_pe_col\[3\].u_pe.w_reg\[0\] u_pe_array.g_pe_row\[0\].g_pe_col\[3\].u_pe.act_val\[5\]
+ _2653_ VGND VGND VPWR VPWR _2663_ sky130_fd_sc_hd__and3_1
X_4818_ net576 _0833_ VGND VGND VPWR VPWR _1836_ sky130_fd_sc_hd__and2_1
XFILLER_0_71_570 VGND VGND VPWR VPWR sky130_fd_sc_hd__decap_3
X_7537_ clknet_leaf_0_clk _0586_ VGND VGND VPWR VPWR u_pe_array.u_fifo2.buffer\[7\]\[11\]
+ sky130_fd_sc_hd__dfxtp_1
XFILLER_0_16_475 VGND VGND VPWR VPWR sky130_fd_sc_hd__fill_1
X_4749_ _1787_ _0838_ _0986_ _0747_ VGND VGND VPWR VPWR _1788_ sky130_fd_sc_hd__a22o_2
XFILLER_0_114_650 VGND VGND VPWR VPWR sky130_fd_sc_hd__fill_2
XANTENNA__6305__A1 _2740_ VGND VGND VPWR VPWR sky130_fd_sc_hd__diode_2
X_7468_ clknet_leaf_5_clk _0517_ VGND VGND VPWR VPWR u_pe_array.u_fifo2.buffer\[2\]\[7\]
+ sky130_fd_sc_hd__dfxtp_1
XANTENNA__6936__RESET_B net819 VGND VGND VPWR VPWR sky130_fd_sc_hd__diode_2
X_6419_ net256 _1808_ net70 VGND VGND VPWR VPWR _3173_ sky130_fd_sc_hd__mux2_1
XFILLER_0_31_467 VGND VGND VPWR VPWR sky130_fd_sc_hd__fill_1
Xoutput58 net58 VGND VGND VPWR VPWR psum_out1[6] sky130_fd_sc_hd__clkbuf_4
X_7399_ clknet_leaf_42_clk _0449_ net817 VGND VGND VPWR VPWR u_pe_array.g_pe_row\[0\].g_pe_col\[0\].u_pe.psum_out\[3\]
+ sky130_fd_sc_hd__dfrtp_1
Xoutput36 net36 VGND VGND VPWR VPWR psum_out0[0] sky130_fd_sc_hd__clkbuf_4
Xoutput47 net47 VGND VGND VPWR VPWR psum_out0[8] sky130_fd_sc_hd__clkbuf_4
XANTENNA__4619__A1 _1273_ VGND VGND VPWR VPWR sky130_fd_sc_hd__diode_2
XANTENNA_hold555_A u_pe_array.g_pe_row\[2\].g_pe_col\[0\].u_pe.move_reg\[6\] VGND
+ VGND VPWR VPWR sky130_fd_sc_hd__diode_2
XFILLER_0_98_401 VPWR VGND VPWR VGND sky130_ef_sc_hd__decap_12
XANTENNA__3842__A2 _1009_ VGND VGND VPWR VPWR sky130_fd_sc_hd__diode_2
XFILLER_0_58_309 VGND VGND VPWR VPWR sky130_fd_sc_hd__decap_3
XPHY_142 VGND VGND VPWR VPWR sky130_fd_sc_hd__decap_3
XPHY_131 VGND VGND VPWR VPWR sky130_fd_sc_hd__decap_3
XPHY_120 VGND VGND VPWR VPWR sky130_fd_sc_hd__decap_3
XFILLER_0_93_150 VGND VGND VPWR VPWR sky130_fd_sc_hd__fill_2
XPHY_175 VGND VGND VPWR VPWR sky130_fd_sc_hd__decap_3
XPHY_164 VGND VGND VPWR VPWR sky130_fd_sc_hd__decap_3
XPHY_153 VGND VGND VPWR VPWR sky130_fd_sc_hd__decap_3
XPHY_197 VGND VGND VPWR VPWR sky130_fd_sc_hd__decap_3
XPHY_186 VGND VGND VPWR VPWR sky130_fd_sc_hd__decap_3
XFILLER_0_22_401 VGND VGND VPWR VPWR sky130_fd_sc_hd__decap_3
XANTENNA__4555__B1 _1534_ VGND VGND VPWR VPWR sky130_fd_sc_hd__diode_2
XFILLER_0_78_29 VGND VGND VPWR VPWR sky130_fd_sc_hd__decap_8
XANTENNA__4307__B1 _1144_ VGND VGND VPWR VPWR sky130_fd_sc_hd__diode_2
XFILLER_0_22_445 VGND VGND VPWR VPWR sky130_fd_sc_hd__fill_2
XANTENNA__5524__A _2345_ VGND VGND VPWR VPWR sky130_fd_sc_hd__diode_2
XFILLER_0_43_32 VGND VGND VPWR VPWR sky130_fd_sc_hd__fill_2
X_6770_ net247 _3132_ net62 VGND VGND VPWR VPWR _3364_ sky130_fd_sc_hd__mux2_1
X_3982_ u_pe_array.g_pe_row\[3\].g_pe_col\[1\].u_pe.w_reg\[1\] VGND VGND VPWR VPWR
+ _1145_ sky130_fd_sc_hd__buf_6
XANTENNA__5035__B2 _1665_ VGND VGND VPWR VPWR sky130_fd_sc_hd__diode_2
XFILLER_0_43_65 VGND VGND VPWR VPWR sky130_fd_sc_hd__fill_2
XFILLER_0_43_54 VGND VGND VPWR VPWR sky130_fd_sc_hd__fill_2
XPHY_0 VGND VGND VPWR VPWR sky130_fd_sc_hd__decap_3
XFILLER_0_85_673 VGND VGND VPWR VPWR sky130_fd_sc_hd__fill_2
XANTENNA__4794__A0 _1820_ VGND VGND VPWR VPWR sky130_fd_sc_hd__diode_2
XFILLER_0_9_428 VGND VGND VPWR VPWR sky130_fd_sc_hd__decap_8
X_5721_ u_pe_array.g_pe_row\[0\].g_pe_col\[3\].u_pe.psum_out\[6\] u_pe_array.g_pe_row\[0\].g_pe_col\[3\].u_pe.move_reg\[6\]
+ _2469_ VGND VGND VPWR VPWR _2599_ sky130_fd_sc_hd__mux2_1
XFILLER_0_84_150 VGND VGND VPWR VPWR sky130_fd_sc_hd__fill_1
XFILLER_0_57_397 VGND VGND VPWR VPWR sky130_fd_sc_hd__decap_3
X_5652_ u_pe_array.g_pe_row\[1\].g_pe_col\[0\].u_pe.psum_out\[7\] VGND VGND VPWR VPWR
+ _2544_ sky130_fd_sc_hd__inv_2
XFILLER_0_72_356 VGND VGND VPWR VPWR sky130_fd_sc_hd__fill_2
XANTENNA__6535__A1 _1814_ VGND VGND VPWR VPWR sky130_fd_sc_hd__diode_2
X_5583_ _2477_ _2479_ _2480_ VGND VGND VPWR VPWR _2481_ sky130_fd_sc_hd__or3_1
XFILLER_0_60_518 VGND VGND VPWR VPWR sky130_fd_sc_hd__fill_2
X_4603_ u_pe_array.g_pe_row\[2\].g_pe_col\[1\].u_pe.psum_out\[8\] net180 _0855_ VGND
+ VGND VPWR VPWR _1660_ sky130_fd_sc_hd__mux2_1
XFILLER_0_4_133 VGND VGND VPWR VPWR sky130_fd_sc_hd__decap_6
XFILLER_0_13_401 VGND VGND VPWR VPWR sky130_fd_sc_hd__fill_2
Xhold302 u_pe_array.g_pe_row\[3\].g_pe_col\[0\].u_pe.psum_out\[0\] VGND VGND VPWR
+ VPWR net378 sky130_fd_sc_hd__dlygate4sd3_1
X_4534_ _1585_ VGND VGND VPWR VPWR _1606_ sky130_fd_sc_hd__inv_2
XFILLER_0_25_294 VGND VGND VPWR VPWR sky130_fd_sc_hd__fill_2
X_7322_ clknet_leaf_68_clk _0379_ net814 VGND VGND VPWR VPWR u_pe_array.g_pe_row\[0\].g_pe_col\[3\].u_pe.psum_out\[6\]
+ sky130_fd_sc_hd__dfrtp_1
Xhold335 u_pe_array.g_pe_row\[1\].g_pe_col\[2\].u_pe.psum_out\[6\] VGND VGND VPWR
+ VPWR net411 sky130_fd_sc_hd__dlygate4sd3_1
XFILLER_0_4_177 VPWR VGND VPWR VGND sky130_ef_sc_hd__decap_12
Xhold324 u_pe_array.g_pe_row\[2\].g_pe_col\[3\].u_pe.psum_out\[0\] VGND VGND VPWR
+ VPWR net400 sky130_fd_sc_hd__dlygate4sd3_1
XFILLER_0_13_445 VGND VGND VPWR VPWR sky130_fd_sc_hd__decap_3
Xhold313 u_pe_array.g_pe_row\[3\].g_pe_col\[2\].u_pe.psum_out\[3\] VGND VGND VPWR
+ VPWR net389 sky130_fd_sc_hd__dlygate4sd3_1
XFILLER_0_111_653 VPWR VGND VPWR VGND sky130_ef_sc_hd__decap_12
XFILLER_0_110_130 VGND VGND VPWR VPWR sky130_fd_sc_hd__fill_1
X_7253_ clknet_leaf_48_clk _0316_ net75 VGND VGND VPWR VPWR u_pe_array.g_pe_row\[1\].g_pe_col\[0\].u_pe.move_reg\[12\]
+ sky130_fd_sc_hd__dfrtp_1
Xhold357 u_pe_array.g_pe_row\[1\].g_pe_col\[2\].u_pe.act_val\[1\] VGND VGND VPWR VPWR
+ net433 sky130_fd_sc_hd__dlygate4sd3_1
X_4465_ u_pe_array.g_pe_row\[2\].g_pe_col\[2\].u_pe.psum_out\[1\] _1539_ _1542_ VGND
+ VGND VPWR VPWR _1543_ sky130_fd_sc_hd__a21o_1
Xhold368 u_pe_array.g_pe_row\[2\].g_pe_col\[2\].u_pe.psum_out\[6\] VGND VGND VPWR
+ VPWR net444 sky130_fd_sc_hd__dlygate4sd3_1
Xhold346 u_pe_array.g_pe_row\[1\].g_pe_col\[3\].u_pe.psum_out\[12\] VGND VGND VPWR
+ VPWR net422 sky130_fd_sc_hd__dlygate4sd3_1
X_6204_ u_pe_array.g_pe_row\[0\].g_pe_col\[0\].u_pe.act_val\[1\] _2992_ VGND VGND
+ VPWR VPWR _3000_ sky130_fd_sc_hd__or2b_1
X_7184_ clknet_leaf_62_clk _0251_ net73 VGND VGND VPWR VPWR u_pe_array.g_pe_row\[1\].g_pe_col\[2\].u_pe.act_val\[3\]
+ sky130_fd_sc_hd__dfrtp_2
XFILLER_0_0_361 VGND VGND VPWR VPWR sky130_fd_sc_hd__decap_3
X_4396_ _1273_ _1493_ _1494_ _1144_ net542 VGND VGND VPWR VPWR _0145_ sky130_fd_sc_hd__a32o_1
Xhold379 u_pe_array.u_fifo2.buffer\[5\]\[5\] VGND VGND VPWR VPWR net455 sky130_fd_sc_hd__dlygate4sd3_1
X_6135_ _2740_ _2941_ _2942_ _2571_ u_pe_array.g_pe_row\[0\].g_pe_col\[1\].u_pe.psum_out\[7\]
+ VGND VGND VPWR VPWR _0436_ sky130_fd_sc_hd__a32o_1
XTAP_651 VGND VPWR sky130_fd_sc_hd__tapvpwrvgnd_1
XTAP_640 VGND VPWR sky130_fd_sc_hd__tapvpwrvgnd_1
X_6066_ _2870_ _2875_ VGND VGND VPWR VPWR _2879_ sky130_fd_sc_hd__and2_1
XTAP_662 VGND VPWR sky130_fd_sc_hd__tapvpwrvgnd_1
XTAP_673 VGND VPWR sky130_fd_sc_hd__tapvpwrvgnd_1
XTAP_684 VGND VPWR sky130_fd_sc_hd__tapvpwrvgnd_1
XTAP_695 VGND VPWR sky130_fd_sc_hd__tapvpwrvgnd_1
XANTENNA__5274__A1 _1725_ VGND VGND VPWR VPWR sky130_fd_sc_hd__diode_2
X_5017_ u_pe_array.u_fifo2.buffer\[8\]\[4\] _1960_ _2004_ _2008_ _0819_ VGND VGND
+ VPWR VPWR _2009_ sky130_fd_sc_hd__a221o_2
XANTENNA__5600__C _2478_ VGND VGND VPWR VPWR sky130_fd_sc_hd__diode_2
XFILLER_0_67_106 VGND VGND VPWR VPWR sky130_fd_sc_hd__fill_2
XANTENNA__7135__RESET_B net813 VGND VGND VPWR VPWR sky130_fd_sc_hd__diode_2
XANTENNA__5577__A2 u_pe_array.g_pe_row\[1\].g_pe_col\[0\].u_pe.w_reg\[0\] VGND VGND
+ VPWR VPWR sky130_fd_sc_hd__diode_2
X_6968_ clknet_leaf_83_clk _0049_ net818 VGND VGND VPWR VPWR u_pe_array.g_pe_row\[3\].g_pe_col\[1\].u_pe.move_reg\[10\]
+ sky130_fd_sc_hd__dfrtp_1
XANTENNA__4785__A0 _1814_ VGND VGND VPWR VPWR sky130_fd_sc_hd__diode_2
X_6899_ _3433_ VGND VGND VPWR VPWR _0709_ sky130_fd_sc_hd__clkbuf_1
XFILLER_0_63_312 VGND VGND VPWR VPWR sky130_fd_sc_hd__fill_1
XFILLER_0_36_537 VGND VGND VPWR VPWR sky130_fd_sc_hd__fill_1
X_5919_ _2753_ _2755_ VGND VGND VPWR VPWR _2759_ sky130_fd_sc_hd__nand2_1
XFILLER_0_63_389 VGND VGND VPWR VPWR sky130_fd_sc_hd__decap_3
XFILLER_0_16_250 VGND VGND VPWR VPWR sky130_fd_sc_hd__fill_2
XFILLER_0_31_220 VGND VGND VPWR VPWR sky130_fd_sc_hd__fill_2
XFILLER_0_31_264 VGND VGND VPWR VPWR sky130_fd_sc_hd__decap_3
XFILLER_0_7_3 VPWR VGND VPWR VGND sky130_ef_sc_hd__decap_12
XANTENNA__6874__S _3412_ VGND VGND VPWR VPWR sky130_fd_sc_hd__diode_2
XANTENNA_input21_A v_in1[0] VGND VGND VPWR VPWR sky130_fd_sc_hd__diode_2
XFILLER_0_98_231 VGND VGND VPWR VPWR sky130_fd_sc_hd__fill_2
XFILLER_0_98_253 VGND VGND VPWR VPWR sky130_fd_sc_hd__decap_3
XANTENNA__4407__B _1407_ VGND VGND VPWR VPWR sky130_fd_sc_hd__diode_2
XFILLER_0_86_437 VGND VGND VPWR VPWR sky130_fd_sc_hd__fill_2
XFILLER_0_104_15 VPWR VGND VPWR VGND sky130_ef_sc_hd__decap_12
XANTENNA__4776__A0 _1808_ VGND VGND VPWR VPWR sky130_fd_sc_hd__diode_2
XANTENNA__5568__A2 _2463_ VGND VGND VPWR VPWR sky130_fd_sc_hd__diode_2
XFILLER_0_39_331 VGND VGND VPWR VPWR sky130_fd_sc_hd__fill_2
XFILLER_0_94_481 VGND VGND VPWR VPWR sky130_fd_sc_hd__fill_2
XFILLER_0_73_109 VGND VGND VPWR VPWR sky130_fd_sc_hd__decap_3
XFILLER_0_67_673 VGND VGND VPWR VPWR sky130_fd_sc_hd__fill_2
XFILLER_0_66_150 VPWR VGND VPWR VGND sky130_ef_sc_hd__decap_12
XFILLER_0_13_57 VGND VGND VPWR VPWR sky130_fd_sc_hd__decap_3
XFILLER_0_39_375 VGND VGND VPWR VPWR sky130_fd_sc_hd__fill_2
XFILLER_0_39_386 VGND VGND VPWR VPWR sky130_fd_sc_hd__fill_2
XANTENNA__4528__B1 _1534_ VGND VGND VPWR VPWR sky130_fd_sc_hd__diode_2
XFILLER_0_112_406 VPWR VGND VPWR VGND sky130_ef_sc_hd__decap_12
XFILLER_0_81_197 VGND VGND VPWR VPWR sky130_fd_sc_hd__fill_2
XFILLER_0_2_637 VGND VGND VPWR VPWR sky130_fd_sc_hd__decap_6
XFILLER_0_22_253 VGND VGND VPWR VPWR sky130_fd_sc_hd__decap_3
XANTENNA__3473__S _0730_ VGND VGND VPWR VPWR sky130_fd_sc_hd__diode_2
XFILLER_0_10_426 VGND VGND VPWR VPWR sky130_fd_sc_hd__decap_4
XANTENNA__6069__B _2873_ VGND VGND VPWR VPWR sky130_fd_sc_hd__diode_2
X_4250_ _1366_ _1368_ _1374_ VGND VGND VPWR VPWR _1376_ sky130_fd_sc_hd__a21oi_2
XFILLER_0_10_459 VGND VGND VPWR VPWR sky130_fd_sc_hd__decap_8
XFILLER_0_1_169 VPWR VGND VPWR VGND sky130_ef_sc_hd__decap_12
X_4181_ _1309_ _1310_ _1311_ VGND VGND VPWR VPWR _1313_ sky130_fd_sc_hd__a21oi_1
XFILLER_0_89_242 VGND VGND VPWR VPWR sky130_fd_sc_hd__fill_2
XANTENNA__3502__A _0754_ VGND VGND VPWR VPWR sky130_fd_sc_hd__diode_2
X_6822_ net356 _3128_ _3382_ VGND VGND VPWR VPWR _3392_ sky130_fd_sc_hd__mux2_1
XFILLER_0_89_275 VGND VGND VPWR VPWR sky130_fd_sc_hd__fill_2
XFILLER_0_49_139 VGND VGND VPWR VPWR sky130_fd_sc_hd__decap_3
XFILLER_0_9_225 VGND VGND VPWR VPWR sky130_fd_sc_hd__decap_4
XANTENNA__5559__A2 _2463_ VGND VGND VPWR VPWR sky130_fd_sc_hd__diode_2
X_3965_ u_pe_array.g_pe_row\[2\].g_pe_col\[0\].u_pe.move_reg\[7\] u_pe_array.g_pe_row\[2\].g_pe_col\[0\].u_pe.psum_out\[7\]
+ _0755_ VGND VGND VPWR VPWR _1135_ sky130_fd_sc_hd__mux2_1
XFILLER_0_92_429 VGND VGND VPWR VPWR sky130_fd_sc_hd__fill_2
X_6753_ _3355_ VGND VGND VPWR VPWR _0641_ sky130_fd_sc_hd__clkbuf_1
XFILLER_0_70_41 VPWR VGND VPWR VGND sky130_ef_sc_hd__decap_12
XFILLER_0_9_258 VGND VGND VPWR VPWR sky130_fd_sc_hd__decap_3
XFILLER_0_9_236 VGND VGND VPWR VPWR sky130_fd_sc_hd__decap_4
XANTENNA__6024__S _0827_ VGND VGND VPWR VPWR sky130_fd_sc_hd__diode_2
X_5704_ net33 u_pe_array.g_pe_row\[0\].g_pe_col\[3\].u_pe.w_buffer\[0\] _0828_ VGND
+ VGND VPWR VPWR _2590_ sky130_fd_sc_hd__mux2_1
XFILLER_0_70_85 VGND VGND VPWR VPWR sky130_fd_sc_hd__decap_8
X_6684_ _3317_ u_pe_array.u_fifo1.count\[0\] u_pe_array.u_fifo1.count\[3\] _1787_
+ u_pe_array.u_fifo1.count\[1\] VGND VGND VPWR VPWR _3318_ sky130_fd_sc_hd__a41o_1
X_3896_ _1074_ _1080_ VGND VGND VPWR VPWR _1081_ sky130_fd_sc_hd__nand2_1
XANTENNA__6508__A1 _1816_ VGND VGND VPWR VPWR sky130_fd_sc_hd__diode_2
X_5635_ _2518_ _2519_ _2516_ VGND VGND VPWR VPWR _2529_ sky130_fd_sc_hd__o21ai_2
XFILLER_0_5_420 VGND VGND VPWR VPWR sky130_fd_sc_hd__fill_2
XFILLER_0_85_3 VGND VGND VPWR VPWR sky130_fd_sc_hd__decap_6
XFILLER_0_72_197 VGND VGND VPWR VPWR sky130_fd_sc_hd__decap_3
XFILLER_0_79_50 VGND VGND VPWR VPWR sky130_fd_sc_hd__decap_6
XANTENNA__5731__A2 _2600_ VGND VGND VPWR VPWR sky130_fd_sc_hd__diode_2
X_5566_ net139 _2463_ _2470_ _2336_ VGND VGND VPWR VPWR _0339_ sky130_fd_sc_hd__a22o_1
Xhold110 u_pe_array.g_pe_row\[3\].g_pe_col\[2\].u_pe.move_reg\[8\] VGND VGND VPWR
+ VPWR net186 sky130_fd_sc_hd__dlygate4sd3_1
XANTENNA__3891__B _1009_ VGND VGND VPWR VPWR sky130_fd_sc_hd__diode_2
Xhold121 u_pe_array.u_fifo1.buffer\[5\]\[11\] VGND VGND VPWR VPWR net197 sky130_fd_sc_hd__dlygate4sd3_1
Xhold143 u_pe_array.g_pe_row\[0\].g_pe_col\[0\].u_pe.move_reg\[7\] VGND VGND VPWR
+ VPWR net219 sky130_fd_sc_hd__dlygate4sd3_1
X_5497_ _2395_ VGND VGND VPWR VPWR _2416_ sky130_fd_sc_hd__inv_2
Xhold132 _0255_ VGND VGND VPWR VPWR net208 sky130_fd_sc_hd__dlygate4sd3_1
X_4517_ _1536_ _1590_ u_pe_array.g_pe_row\[2\].g_pe_col\[2\].u_pe.psum_out\[6\] VGND
+ VGND VPWR VPWR _1591_ sky130_fd_sc_hd__and3_1
XANTENNA_clkbuf_leaf_1_clk_A clknet_3_0__leaf_clk VGND VGND VPWR VPWR sky130_fd_sc_hd__diode_2
X_7305_ clknet_leaf_63_clk _0364_ net814 VGND VGND VPWR VPWR u_pe_array.g_pe_row\[0\].g_pe_col\[2\].u_pe.act_val\[4\]
+ sky130_fd_sc_hd__dfrtp_1
Xhold154 u_pe_array.u_fifo1.buffer\[4\]\[12\] VGND VGND VPWR VPWR net230 sky130_fd_sc_hd__dlygate4sd3_1
XFILLER_0_111_461 VPWR VGND VPWR VGND sky130_ef_sc_hd__decap_12
Xhold165 u_pe_array.u_fifo1.buffer\[6\]\[8\] VGND VGND VPWR VPWR net241 sky130_fd_sc_hd__dlygate4sd3_1
X_7236_ clknet_leaf_52_clk _0299_ net812 VGND VGND VPWR VPWR u_pe_array.g_pe_row\[1\].g_pe_col\[2\].u_pe.psum_out\[10\]
+ sky130_fd_sc_hd__dfrtp_2
X_4448_ net384 _1524_ _1529_ _1399_ VGND VGND VPWR VPWR _0162_ sky130_fd_sc_hd__a22o_1
Xhold176 u_pe_array.u_fifo2.buffer\[5\]\[6\] VGND VGND VPWR VPWR net252 sky130_fd_sc_hd__dlygate4sd3_1
Xhold198 u_pe_array.u_fifo1.buffer\[1\]\[9\] VGND VGND VPWR VPWR net274 sky130_fd_sc_hd__dlygate4sd3_1
Xhold187 u_pe_array.u_fifo2.buffer\[1\]\[12\] VGND VGND VPWR VPWR net263 sky130_fd_sc_hd__dlygate4sd3_1
X_7167_ clknet_leaf_32_clk _0234_ net817 VGND VGND VPWR VPWR u_pe_array.g_pe_row\[2\].g_pe_col\[0\].u_pe.psum_out\[1\]
+ sky130_fd_sc_hd__dfrtp_1
XANTENNA__7387__RESET_B net817 VGND VGND VPWR VPWR sky130_fd_sc_hd__diode_2
X_4379_ _1441_ _1443_ _1453_ VGND VGND VPWR VPWR _1479_ sky130_fd_sc_hd__a21oi_1
X_6118_ u_pe_array.g_pe_row\[0\].g_pe_col\[1\].u_pe.act_val\[5\] VGND VGND VPWR VPWR
+ _2927_ sky130_fd_sc_hd__inv_2
X_7098_ clknet_leaf_91_clk _0169_ net819 VGND VGND VPWR VPWR u_pe_array.g_pe_row\[2\].g_pe_col\[2\].u_pe.psum_out\[5\]
+ sky130_fd_sc_hd__dfrtp_1
XTAP_470 VGND VPWR sky130_fd_sc_hd__tapvpwrvgnd_1
XTAP_492 VGND VPWR sky130_fd_sc_hd__tapvpwrvgnd_1
XTAP_481 VGND VPWR sky130_fd_sc_hd__tapvpwrvgnd_1
X_6049_ net417 _2738_ _2866_ _0722_ VGND VGND VPWR VPWR _0426_ sky130_fd_sc_hd__a22o_1
XANTENNA__7316__RESET_B net814 VGND VGND VPWR VPWR sky130_fd_sc_hd__diode_2
XTAP_1614 VGND VPWR sky130_fd_sc_hd__tapvpwrvgnd_1
XTAP_1603 VGND VPWR sky130_fd_sc_hd__tapvpwrvgnd_1
XFILLER_0_95_223 VGND VGND VPWR VPWR sky130_fd_sc_hd__fill_1
XTAP_1625 VGND VPWR sky130_fd_sc_hd__tapvpwrvgnd_1
XFILLER_0_95_267 VGND VGND VPWR VPWR sky130_fd_sc_hd__fill_2
XFILLER_0_95_234 VGND VGND VPWR VPWR sky130_fd_sc_hd__fill_1
XFILLER_0_49_673 VGND VGND VPWR VPWR sky130_fd_sc_hd__fill_2
XFILLER_0_49_662 VGND VGND VPWR VPWR sky130_fd_sc_hd__fill_2
XFILLER_0_48_150 VGND VGND VPWR VPWR sky130_fd_sc_hd__fill_2
XANTENNA__4243__A _1275_ VGND VGND VPWR VPWR sky130_fd_sc_hd__diode_2
XFILLER_0_76_481 VGND VGND VPWR VPWR sky130_fd_sc_hd__decap_4
XANTENNA__6951__RESET_B net815 VGND VGND VPWR VPWR sky130_fd_sc_hd__diode_2
XANTENNA__3981__A1 _0864_ VGND VGND VPWR VPWR sky130_fd_sc_hd__diode_2
XFILLER_0_63_164 VGND VGND VPWR VPWR sky130_fd_sc_hd__fill_2
XANTENNA__5970__A2 _2387_ VGND VGND VPWR VPWR sky130_fd_sc_hd__diode_2
XFILLER_0_51_337 VGND VGND VPWR VPWR sky130_fd_sc_hd__decap_8
XFILLER_0_51_348 VGND VGND VPWR VPWR sky130_fd_sc_hd__fill_2
XANTENNA__5722__A2 _2463_ VGND VGND VPWR VPWR sky130_fd_sc_hd__diode_2
XANTENNA__3733__A1 _0864_ VGND VGND VPWR VPWR sky130_fd_sc_hd__diode_2
XFILLER_0_102_483 VGND VGND VPWR VPWR sky130_fd_sc_hd__decap_8
XFILLER_0_75_19 VPWR VGND VPWR VGND sky130_ef_sc_hd__decap_12
XANTENNA__7057__RESET_B net74 VGND VGND VPWR VPWR sky130_fd_sc_hd__diode_2
XFILLER_0_99_595 VGND VGND VPWR VPWR sky130_fd_sc_hd__decap_3
XANTENNA__4749__B1 _0986_ VGND VGND VPWR VPWR sky130_fd_sc_hd__diode_2
X_3750_ _0958_ _0959_ VGND VGND VPWR VPWR _0961_ sky130_fd_sc_hd__nor2_1
XFILLER_0_27_312 VGND VGND VPWR VPWR sky130_fd_sc_hd__fill_2
XFILLER_0_27_334 VGND VGND VPWR VPWR sky130_fd_sc_hd__fill_2
XANTENNA__6779__S _3366_ VGND VGND VPWR VPWR sky130_fd_sc_hd__diode_2
XFILLER_0_54_197 VGND VGND VPWR VPWR sky130_fd_sc_hd__fill_1
X_3681_ _0895_ _0897_ VGND VGND VPWR VPWR _0898_ sky130_fd_sc_hd__nor2_1
XFILLER_0_42_337 VGND VGND VPWR VPWR sky130_fd_sc_hd__fill_2
XANTENNA__6910__A1 _3132_ VGND VGND VPWR VPWR sky130_fd_sc_hd__diode_2
X_5420_ u_pe_array.g_pe_row\[1\].g_pe_col\[1\].u_pe.act_val\[0\] _2345_ VGND VGND
+ VPWR VPWR _2346_ sky130_fd_sc_hd__nand2_1
XFILLER_0_112_236 VPWR VGND VPWR VGND sky130_ef_sc_hd__decap_12
X_5351_ u_pe_array.g_pe_row\[0\].g_pe_col\[0\].u_pe.act_val\[0\] u_pe_array.g_pe_row\[0\].g_pe_col\[0\].u_pe.psum_out\[0\]
+ _0756_ VGND VGND VPWR VPWR _2291_ sky130_fd_sc_hd__mux2_1
XFILLER_0_2_445 VPWR VGND VPWR VGND sky130_ef_sc_hd__decap_12
X_5282_ _1725_ _2228_ _2229_ _2071_ net639 VGND VGND VPWR VPWR _0296_ sky130_fd_sc_hd__a32o_1
XFILLER_0_50_381 VGND VGND VPWR VPWR sky130_fd_sc_hd__fill_1
X_4302_ u_pe_array.g_pe_row\[2\].g_pe_col\[3\].u_pe.act_val\[0\] _1407_ u_pe_array.g_pe_row\[2\].g_pe_col\[3\].u_pe.psum_out\[1\]
+ VGND VGND VPWR VPWR _1409_ sky130_fd_sc_hd__and3_1
XFILLER_0_10_234 VGND VGND VPWR VPWR sky130_fd_sc_hd__decap_6
XFILLER_0_2_489 VPWR VGND VPWR VGND sky130_ef_sc_hd__decap_12
X_4233_ _1275_ u_pe_array.g_pe_row\[3\].g_pe_col\[0\].u_pe.psum_out\[9\] VGND VGND
+ VPWR VPWR _1360_ sky130_fd_sc_hd__nor2_1
X_7021_ clknet_leaf_77_clk _0098_ net819 VGND VGND VPWR VPWR u_pe_array.g_pe_row\[2\].g_pe_col\[3\].u_pe.act_val\[3\]
+ sky130_fd_sc_hd__dfrtp_2
XFILLER_0_4_22 VGND VGND VPWR VPWR sky130_fd_sc_hd__decap_6
X_4164_ _1294_ _1296_ VGND VGND VPWR VPWR _1297_ sky130_fd_sc_hd__nand2_1
X_4095_ _1239_ _1241_ _1247_ VGND VGND VPWR VPWR _1248_ sky130_fd_sc_hd__o21ai_1
XFILLER_0_4_77 VGND VGND VPWR VPWR sky130_fd_sc_hd__decap_6
XFILLER_0_77_201 VGND VGND VPWR VPWR sky130_fd_sc_hd__fill_1
X_6805_ _3383_ VGND VGND VPWR VPWR _0665_ sky130_fd_sc_hd__clkbuf_1
XFILLER_0_81_95 VGND VGND VPWR VPWR sky130_fd_sc_hd__fill_2
XFILLER_0_77_289 VGND VGND VPWR VPWR sky130_fd_sc_hd__decap_3
XFILLER_0_37_109 VGND VGND VPWR VPWR sky130_fd_sc_hd__fill_1
X_6736_ _3346_ VGND VGND VPWR VPWR _0633_ sky130_fd_sc_hd__clkbuf_1
X_4997_ u_pe_array.u_fifo2.buffer\[3\]\[2\] _1969_ _1970_ u_pe_array.u_fifo2.buffer\[2\]\[2\]
+ _1990_ VGND VGND VPWR VPWR _1991_ sky130_fd_sc_hd__a221o_1
X_3948_ u_pe_array.g_pe_row\[2\].g_pe_col\[0\].u_pe.act_val\[1\] u_pe_array.g_pe_row\[2\].g_pe_col\[0\].u_pe.psum_out\[1\]
+ _0755_ VGND VGND VPWR VPWR _1124_ sky130_fd_sc_hd__mux2_1
XFILLER_0_61_602 VGND VGND VPWR VPWR sky130_fd_sc_hd__fill_2
X_6667_ u_pe_array.u_fifo1.count\[1\] u_pe_array.u_fifo1.count\[2\] u_pe_array.u_fifo1.count\[0\]
+ u_pe_array.u_fifo1.count\[3\] _0787_ VGND VGND VPWR VPWR _3306_ sky130_fd_sc_hd__o41a_2
X_3879_ _1063_ _1009_ u_pe_array.g_pe_row\[3\].g_pe_col\[2\].u_pe.psum_out\[6\] VGND
+ VGND VPWR VPWR _1065_ sky130_fd_sc_hd__a21o_1
X_5618_ u_pe_array.g_pe_row\[1\].g_pe_col\[0\].u_pe.act_val\[4\] u_pe_array.g_pe_row\[1\].g_pe_col\[0\].u_pe.w_reg\[0\]
+ _2510_ _2511_ VGND VGND VPWR VPWR _2513_ sky130_fd_sc_hd__o2bb2a_1
X_6598_ _3267_ VGND VGND VPWR VPWR _0574_ sky130_fd_sc_hd__clkbuf_1
XFILLER_0_14_551 VGND VGND VPWR VPWR sky130_fd_sc_hd__decap_8
XFILLER_0_103_225 VGND VGND VPWR VPWR sky130_fd_sc_hd__fill_2
X_5549_ u_pe_array.g_pe_row\[1\].g_pe_col\[3\].u_pe.act_val\[0\] u_pe_array.g_pe_row\[1\].g_pe_col\[3\].u_pe.psum_out\[0\]
+ _0770_ VGND VGND VPWR VPWR _2461_ sky130_fd_sc_hd__mux2_1
X_7219_ clknet_leaf_53_clk net394 net812 VGND VGND VPWR VPWR u_pe_array.g_pe_row\[1\].g_pe_col\[1\].u_pe.move_reg\[8\]
+ sky130_fd_sc_hd__dfrtp_1
XANTENNA__7150__RESET_B net817 VGND VGND VPWR VPWR sky130_fd_sc_hd__diode_2
XTAP_1433 VGND VPWR sky130_fd_sc_hd__tapvpwrvgnd_1
XTAP_1422 VGND VPWR sky130_fd_sc_hd__tapvpwrvgnd_1
XTAP_1411 VGND VPWR sky130_fd_sc_hd__tapvpwrvgnd_1
XTAP_1400 VGND VPWR sky130_fd_sc_hd__tapvpwrvgnd_1
XFILLER_0_68_234 VGND VGND VPWR VPWR sky130_fd_sc_hd__decap_4
XTAP_1466 VGND VPWR sky130_fd_sc_hd__tapvpwrvgnd_1
XTAP_1455 VGND VPWR sky130_fd_sc_hd__tapvpwrvgnd_1
XTAP_1444 VGND VPWR sky130_fd_sc_hd__tapvpwrvgnd_1
XFILLER_0_96_587 VGND VGND VPWR VPWR sky130_fd_sc_hd__fill_1
XANTENNA__6196__A2 _2992_ VGND VGND VPWR VPWR sky130_fd_sc_hd__diode_2
XTAP_1499 VGND VPWR sky130_fd_sc_hd__tapvpwrvgnd_1
XTAP_1488 VGND VPWR sky130_fd_sc_hd__tapvpwrvgnd_1
XTAP_1477 VGND VPWR sky130_fd_sc_hd__tapvpwrvgnd_1
XFILLER_0_49_492 VGND VGND VPWR VPWR sky130_fd_sc_hd__fill_2
XFILLER_0_107_542 VPWR VGND VPWR VGND sky130_ef_sc_hd__decap_12
XFILLER_0_91_281 VGND VGND VPWR VPWR sky130_fd_sc_hd__fill_2
XFILLER_0_24_315 VGND VGND VPWR VPWR sky130_fd_sc_hd__fill_2
XFILLER_0_36_186 VGND VGND VPWR VPWR sky130_fd_sc_hd__decap_8
XFILLER_0_107_597 VPWR VGND VPWR VGND sky130_ef_sc_hd__decap_12
XFILLER_0_101_27 VPWR VGND VPWR VGND sky130_ef_sc_hd__decap_12
XFILLER_0_36_197 VGND VGND VPWR VPWR sky130_fd_sc_hd__decap_3
XANTENNA__7238__RESET_B net812 VGND VGND VPWR VPWR sky130_fd_sc_hd__diode_2
XFILLER_0_20_554 VGND VGND VPWR VPWR sky130_fd_sc_hd__decap_4
XFILLER_0_20_565 VGND VGND VPWR VPWR sky130_fd_sc_hd__fill_1
XFILLER_0_20_576 VGND VGND VPWR VPWR sky130_fd_sc_hd__fill_2
XANTENNA__4131__B2 _1004_ VGND VGND VPWR VPWR sky130_fd_sc_hd__diode_2
XANTENNA__5251__B _2158_ VGND VGND VPWR VPWR sky130_fd_sc_hd__diode_2
XANTENNA_output52_A net52 VGND VGND VPWR VPWR sky130_fd_sc_hd__diode_2
XFILLER_0_35_33 VGND VGND VPWR VPWR sky130_fd_sc_hd__fill_2
X_4920_ u_pe_array.g_pe_row\[2\].g_pe_col\[0\].u_pe.psum_out\[8\] _1847_ VGND VGND
+ VPWR VPWR _1923_ sky130_fd_sc_hd__nand2_1
XANTENNA__4582__S _0828_ VGND VGND VPWR VPWR sky130_fd_sc_hd__diode_2
XANTENNA__3642__B1 _0861_ VGND VGND VPWR VPWR sky130_fd_sc_hd__diode_2
X_4851_ _1855_ _1859_ VGND VGND VPWR VPWR _1860_ sky130_fd_sc_hd__xor2_1
XFILLER_0_51_54 VGND VGND VPWR VPWR sky130_fd_sc_hd__fill_2
X_3802_ u_pe_array.g_pe_row\[3\].g_pe_col\[2\].u_pe.psum_out\[7\] net809 _0745_ VGND
+ VGND VPWR VPWR _1000_ sky130_fd_sc_hd__mux2_1
X_7570_ clknet_leaf_29_clk _0619_ VGND VGND VPWR VPWR u_pe_array.u_fifo1.buffer\[0\]\[6\]
+ sky130_fd_sc_hd__dfxtp_1
X_4782_ _1812_ net376 _1796_ VGND VGND VPWR VPWR _1813_ sky130_fd_sc_hd__mux2_1
XFILLER_0_70_421 VGND VGND VPWR VPWR sky130_fd_sc_hd__fill_2
XFILLER_0_7_559 VGND VGND VPWR VPWR sky130_fd_sc_hd__fill_1
X_3733_ _0864_ _0944_ _0945_ _0867_ net642 VGND VGND VPWR VPWR _0031_ sky130_fd_sc_hd__a32o_1
XFILLER_0_27_164 VGND VGND VPWR VPWR sky130_fd_sc_hd__fill_2
X_6521_ net534 _1800_ _3224_ VGND VGND VPWR VPWR _3227_ sky130_fd_sc_hd__mux2_1
XFILLER_0_42_112 VGND VGND VPWR VPWR sky130_fd_sc_hd__fill_2
X_3664_ u_pe_array.g_pe_row\[3\].g_pe_col\[3\].u_pe.psum_out\[2\] _0881_ VGND VGND
+ VPWR VPWR _0882_ sky130_fd_sc_hd__xnor2_1
XFILLER_0_15_337 VGND VGND VPWR VPWR sky130_fd_sc_hd__decap_3
X_6452_ net307 _1814_ net68 VGND VGND VPWR VPWR _3190_ sky130_fd_sc_hd__mux2_1
X_5403_ u_pe_array.g_pe_row\[0\].g_pe_col\[0\].u_pe.psum_out\[8\] u_pe_array.g_pe_row\[0\].g_pe_col\[0\].u_pe.move_reg\[8\]
+ _1661_ VGND VGND VPWR VPWR _2335_ sky130_fd_sc_hd__mux2_1
XFILLER_0_42_178 VGND VGND VPWR VPWR sky130_fd_sc_hd__fill_2
X_6383_ _3148_ _3149_ VGND VGND VPWR VPWR _0477_ sky130_fd_sc_hd__nor2_1
X_3595_ _0829_ VGND VGND VPWR VPWR _0009_ sky130_fd_sc_hd__clkbuf_1
XFILLER_0_2_253 VGND VGND VPWR VPWR sky130_fd_sc_hd__decap_8
XFILLER_0_23_381 VGND VGND VPWR VPWR sky130_fd_sc_hd__fill_2
X_5334_ _2271_ _2272_ VGND VGND VPWR VPWR _2274_ sky130_fd_sc_hd__and2_1
X_5265_ _2212_ _2213_ VGND VGND VPWR VPWR _2214_ sky130_fd_sc_hd__or2_1
X_4216_ _1273_ _1343_ _1344_ _1144_ u_pe_array.g_pe_row\[3\].g_pe_col\[0\].u_pe.psum_out\[7\]
+ VGND VGND VPWR VPWR _0115_ sky130_fd_sc_hd__a32o_1
X_7004_ clknet_leaf_14_clk _0081_ net816 VGND VGND VPWR VPWR u_pe_array.g_pe_row\[3\].g_pe_col\[1\].u_pe.psum_out\[1\]
+ sky130_fd_sc_hd__dfrtp_1
X_5196_ net164 _2144_ _2152_ _1665_ VGND VGND VPWR VPWR _0287_ sky130_fd_sc_hd__a22o_1
XANTENNA__4408__A_N _1407_ VGND VGND VPWR VPWR sky130_fd_sc_hd__diode_2
XANTENNA__6257__B _2992_ VGND VGND VPWR VPWR sky130_fd_sc_hd__diode_2
X_4147_ _1271_ _1277_ VGND VGND VPWR VPWR _1281_ sky130_fd_sc_hd__and2_1
XANTENNA__4425__A2 _1392_ VGND VGND VPWR VPWR sky130_fd_sc_hd__diode_2
X_4078_ _1224_ _1226_ _1231_ VGND VGND VPWR VPWR _1233_ sky130_fd_sc_hd__or3_1
XFILLER_0_78_565 VGND VGND VPWR VPWR sky130_fd_sc_hd__fill_1
XFILLER_0_93_535 VGND VGND VPWR VPWR sky130_fd_sc_hd__fill_2
XANTENNA__5925__A2 _2743_ VGND VGND VPWR VPWR sky130_fd_sc_hd__diode_2
X_6719_ _3337_ VGND VGND VPWR VPWR _0625_ sky130_fd_sc_hd__clkbuf_1
XFILLER_0_73_281 VGND VGND VPWR VPWR sky130_fd_sc_hd__fill_2
XFILLER_0_61_421 VGND VGND VPWR VPWR sky130_fd_sc_hd__fill_2
XFILLER_0_46_473 VGND VGND VPWR VPWR sky130_fd_sc_hd__decap_3
XFILLER_0_6_581 VGND VGND VPWR VPWR sky130_fd_sc_hd__decap_6
XFILLER_0_34_668 VGND VGND VPWR VPWR sky130_fd_sc_hd__fill_2
XFILLER_0_33_167 VGND VGND VPWR VPWR sky130_fd_sc_hd__fill_1
XFILLER_0_104_589 VGND VGND VPWR VPWR sky130_fd_sc_hd__fill_2
XANTENNA__4361__A1 _1407_ VGND VGND VPWR VPWR sky130_fd_sc_hd__diode_2
XANTENNA__7331__RESET_B net812 VGND VGND VPWR VPWR sky130_fd_sc_hd__diode_2
XANTENNA__6638__B1 _0836_ VGND VGND VPWR VPWR sky130_fd_sc_hd__diode_2
XANTENNA__5352__A _1787_ VGND VGND VPWR VPWR sky130_fd_sc_hd__diode_2
XANTENNA__6882__S _3412_ VGND VGND VPWR VPWR sky130_fd_sc_hd__diode_2
XANTENNA__5613__A1 _2258_ VGND VGND VPWR VPWR sky130_fd_sc_hd__diode_2
XFILLER_0_96_362 VGND VGND VPWR VPWR sky130_fd_sc_hd__fill_2
XTAP_1241 VGND VPWR sky130_fd_sc_hd__tapvpwrvgnd_1
XTAP_1230 VGND VPWR sky130_fd_sc_hd__tapvpwrvgnd_1
XANTENNA__3600__A _0832_ VGND VGND VPWR VPWR sky130_fd_sc_hd__diode_2
XANTENNA_clkbuf_3_4__f_clk_A clknet_0_clk VGND VGND VPWR VPWR sky130_fd_sc_hd__diode_2
XTAP_1263 VGND VPWR sky130_fd_sc_hd__tapvpwrvgnd_1
XTAP_1274 VGND VPWR sky130_fd_sc_hd__tapvpwrvgnd_1
XTAP_1252 VGND VPWR sky130_fd_sc_hd__tapvpwrvgnd_1
XFILLER_0_56_248 VGND VGND VPWR VPWR sky130_fd_sc_hd__fill_2
XFILLER_0_112_15 VPWR VGND VPWR VGND sky130_ef_sc_hd__decap_12
XTAP_1296 VGND VPWR sky130_fd_sc_hd__tapvpwrvgnd_1
XTAP_1285 VGND VPWR sky130_fd_sc_hd__tapvpwrvgnd_1
XFILLER_0_37_440 VGND VGND VPWR VPWR sky130_fd_sc_hd__fill_2
XFILLER_0_25_624 VGND VGND VPWR VPWR sky130_fd_sc_hd__decap_3
XFILLER_0_37_484 VGND VGND VPWR VPWR sky130_fd_sc_hd__fill_1
XFILLER_0_114_309 VPWR VGND VPWR VGND sky130_ef_sc_hd__decap_12
XFILLER_0_107_372 VGND VGND VPWR VPWR sky130_fd_sc_hd__fill_2
XANTENNA__5527__A _2345_ VGND VGND VPWR VPWR sky130_fd_sc_hd__diode_2
XFILLER_0_25_646 VGND VGND VPWR VPWR sky130_fd_sc_hd__fill_1
XFILLER_0_52_465 VGND VGND VPWR VPWR sky130_fd_sc_hd__fill_2
Xhold709 u_pe_array.g_pe_row\[3\].g_pe_col\[1\].u_pe.psum_out\[7\] VGND VGND VPWR
+ VPWR net785 sky130_fd_sc_hd__dlygate4sd3_1
XFILLER_0_24_178 VGND VGND VPWR VPWR sky130_fd_sc_hd__fill_2
XFILLER_0_97_39 VGND VGND VPWR VPWR sky130_fd_sc_hd__fill_1
XFILLER_0_52_498 VGND VGND VPWR VPWR sky130_fd_sc_hd__fill_2
XFILLER_0_40_638 VGND VGND VPWR VPWR sky130_fd_sc_hd__decap_3
XFILLER_0_40_649 VGND VGND VPWR VPWR sky130_fd_sc_hd__decap_3
XANTENNA__6629__A0 _0988_ VGND VGND VPWR VPWR sky130_fd_sc_hd__diode_2
XANTENNA__7072__RESET_B net74 VGND VGND VPWR VPWR sky130_fd_sc_hd__diode_2
XANTENNA_clkbuf_leaf_41_clk_A clknet_3_6__leaf_clk VGND VGND VPWR VPWR sky130_fd_sc_hd__diode_2
XANTENNA__7001__RESET_B net816 VGND VGND VPWR VPWR sky130_fd_sc_hd__diode_2
X_5050_ _2028_ _2030_ _2031_ VGND VGND VPWR VPWR _2032_ sky130_fd_sc_hd__or3_1
X_4001_ _1156_ _1158_ VGND VGND VPWR VPWR _1162_ sky130_fd_sc_hd__nand2_1
XANTENNA__5852__A1 _0914_ VGND VGND VPWR VPWR sky130_fd_sc_hd__diode_2
XANTENNA_clkbuf_leaf_56_clk_A clknet_3_6__leaf_clk VGND VGND VPWR VPWR sky130_fd_sc_hd__diode_2
X_5952_ _2787_ _2789_ VGND VGND VPWR VPWR _2790_ sky130_fd_sc_hd__xor2_1
XANTENNA__3615__A0 net24 VGND VGND VPWR VPWR sky130_fd_sc_hd__diode_2
X_4903_ _1905_ _1906_ _1907_ VGND VGND VPWR VPWR _1908_ sky130_fd_sc_hd__or3_1
XFILLER_0_62_53 VPWR VGND VPWR VGND sky130_ef_sc_hd__decap_12
X_5883_ net149 _2600_ _2732_ _0722_ VGND VGND VPWR VPWR _0394_ sky130_fd_sc_hd__a22o_1
XFILLER_0_62_97 VGND VGND VPWR VPWR sky130_fd_sc_hd__decap_3
X_7622_ clknet_leaf_29_clk _0671_ VGND VGND VPWR VPWR u_pe_array.u_fifo1.buffer\[4\]\[6\]
+ sky130_fd_sc_hd__dfxtp_1
X_4834_ _1844_ VGND VGND VPWR VPWR _1845_ sky130_fd_sc_hd__inv_2
XFILLER_0_75_568 VGND VGND VPWR VPWR sky130_fd_sc_hd__fill_2
XFILLER_0_47_248 VGND VGND VPWR VPWR sky130_fd_sc_hd__fill_2
X_7553_ clknet_leaf_17_clk _0602_ net816 VGND VGND VPWR VPWR u_pe_array.u_fifo1.wr_ptr\[1\]
+ sky130_fd_sc_hd__dfrtp_4
XFILLER_0_62_207 VGND VGND VPWR VPWR sky130_fd_sc_hd__fill_1
XFILLER_0_43_410 VGND VGND VPWR VPWR sky130_fd_sc_hd__fill_2
X_4765_ _1801_ VGND VGND VPWR VPWR _0207_ sky130_fd_sc_hd__clkbuf_1
XANTENNA__6032__S _0770_ VGND VGND VPWR VPWR sky130_fd_sc_hd__diode_2
X_6504_ net338 _1812_ _3208_ VGND VGND VPWR VPWR _3217_ sky130_fd_sc_hd__mux2_1
X_3716_ _0928_ _0929_ VGND VGND VPWR VPWR _0930_ sky130_fd_sc_hd__or2_1
X_4696_ _1740_ u_pe_array.g_pe_row\[2\].g_pe_col\[1\].u_pe.psum_out\[7\] _1729_ VGND
+ VGND VPWR VPWR _1741_ sky130_fd_sc_hd__mux2_1
X_7484_ clknet_leaf_0_clk _0533_ VGND VGND VPWR VPWR u_pe_array.u_fifo2.buffer\[3\]\[10\]
+ sky130_fd_sc_hd__dfxtp_1
XFILLER_0_31_605 VGND VGND VPWR VPWR sky130_fd_sc_hd__decap_8
X_3647_ _0866_ VGND VGND VPWR VPWR _0867_ sky130_fd_sc_hd__buf_8
XFILLER_0_3_573 VPWR VGND VPWR VGND sky130_ef_sc_hd__decap_12
X_6435_ _3181_ VGND VGND VPWR VPWR _0497_ sky130_fd_sc_hd__clkbuf_1
XFILLER_0_101_537 VGND VGND VPWR VPWR sky130_fd_sc_hd__fill_2
XANTENNA__5540__B1 _2345_ VGND VGND VPWR VPWR sky130_fd_sc_hd__diode_2
X_3578_ net321 _0816_ _0815_ VGND VGND VPWR VPWR _0817_ sky130_fd_sc_hd__a21oi_1
X_6366_ _1792_ _3136_ VGND VGND VPWR VPWR _3138_ sky130_fd_sc_hd__nand2_1
X_5317_ _2259_ _2260_ VGND VGND VPWR VPWR _2261_ sky130_fd_sc_hd__or2_1
XFILLER_0_11_373 VGND VGND VPWR VPWR sky130_fd_sc_hd__fill_2
X_6297_ u_pe_array.g_pe_row\[0\].g_pe_col\[0\].u_pe.psum_out\[7\] u_pe_array.g_pe_row\[0\].g_pe_col\[0\].u_pe.psum_out\[8\]
+ _2992_ VGND VGND VPWR VPWR _3085_ sky130_fd_sc_hd__o21a_1
Xhold14 u_pe_array.g_pe_row\[2\].g_pe_col\[3\].u_pe.w_buffer\[1\] VGND VGND VPWR VPWR
+ net90 sky130_fd_sc_hd__dlygate4sd3_1
Xhold25 u_pe_array.g_pe_row\[1\].g_pe_col\[0\].u_pe.w_buffer\[1\] VGND VGND VPWR VPWR
+ net101 sky130_fd_sc_hd__dlygate4sd3_1
Xhold36 u_pe_array.g_pe_row\[1\].g_pe_col\[0\].u_pe.move_reg\[9\] VGND VGND VPWR VPWR
+ net112 sky130_fd_sc_hd__dlygate4sd3_1
Xhold47 u_pe_array.g_pe_row\[1\].g_pe_col\[2\].u_pe.move_reg\[12\] VGND VGND VPWR
+ VPWR net123 sky130_fd_sc_hd__dlygate4sd3_1
X_5248_ _2189_ _2198_ VGND VGND VPWR VPWR _2199_ sky130_fd_sc_hd__nor2_1
XFILLER_0_98_616 VGND VGND VPWR VPWR sky130_fd_sc_hd__fill_2
Xhold69 u_pe_array.g_pe_row\[0\].g_pe_col\[1\].u_pe.move_reg\[8\] VGND VGND VPWR VPWR
+ net145 sky130_fd_sc_hd__dlygate4sd3_1
X_5179_ net781 _1666_ _1655_ _2143_ VGND VGND VPWR VPWR _0279_ sky130_fd_sc_hd__a22o_1
Xhold58 _0338_ VGND VGND VPWR VPWR net134 sky130_fd_sc_hd__dlygate4sd3_1
XANTENNA__3606__A0 net21 VGND VGND VPWR VPWR sky130_fd_sc_hd__diode_2
XFILLER_0_78_351 VGND VGND VPWR VPWR sky130_fd_sc_hd__fill_1
XFILLER_0_38_204 VPWR VGND VPWR VGND sky130_ef_sc_hd__decap_12
XFILLER_0_109_615 VGND VGND VPWR VPWR sky130_fd_sc_hd__fill_1
XFILLER_0_66_524 VGND VGND VPWR VPWR sky130_fd_sc_hd__fill_2
XFILLER_0_66_557 VGND VGND VPWR VPWR sky130_fd_sc_hd__fill_2
XFILLER_0_38_248 VGND VGND VPWR VPWR sky130_fd_sc_hd__fill_2
XFILLER_0_93_398 VGND VGND VPWR VPWR sky130_fd_sc_hd__fill_2
XFILLER_0_34_432 VGND VGND VPWR VPWR sky130_fd_sc_hd__fill_2
XFILLER_0_34_498 VGND VGND VPWR VPWR sky130_fd_sc_hd__fill_2
XANTENNA__5531__B1 _0861_ VGND VGND VPWR VPWR sky130_fd_sc_hd__diode_2
XANTENNA__4098__B1 _1145_ VGND VGND VPWR VPWR sky130_fd_sc_hd__diode_2
XFILLER_0_107_15 VPWR VGND VPWR VGND sky130_ef_sc_hd__decap_12
XFILLER_0_16_13 VGND VGND VPWR VPWR sky130_fd_sc_hd__fill_1
XFILLER_0_16_24 VGND VGND VPWR VPWR sky130_fd_sc_hd__fill_2
XFILLER_0_88_137 VGND VGND VPWR VPWR sky130_fd_sc_hd__decap_3
XFILLER_0_57_502 VGND VGND VPWR VPWR sky130_fd_sc_hd__fill_2
XANTENNA__4270__B1 _1258_ VGND VGND VPWR VPWR sky130_fd_sc_hd__diode_2
XFILLER_0_29_237 VGND VGND VPWR VPWR sky130_fd_sc_hd__decap_4
XFILLER_0_96_192 VGND VGND VPWR VPWR sky130_fd_sc_hd__fill_2
XFILLER_0_84_354 VGND VGND VPWR VPWR sky130_fd_sc_hd__fill_2
XTAP_1082 VGND VPWR sky130_fd_sc_hd__tapvpwrvgnd_1
XTAP_1071 VGND VPWR sky130_fd_sc_hd__tapvpwrvgnd_1
XTAP_1060 VGND VPWR sky130_fd_sc_hd__tapvpwrvgnd_1
XFILLER_0_57_557 VGND VGND VPWR VPWR sky130_fd_sc_hd__decap_3
XFILLER_0_84_376 VGND VGND VPWR VPWR sky130_fd_sc_hd__decap_8
XTAP_1093 VGND VPWR sky130_fd_sc_hd__tapvpwrvgnd_1
XANTENNA__3984__B _1145_ VGND VGND VPWR VPWR sky130_fd_sc_hd__diode_2
XANTENNA__6011__A1 _2740_ VGND VGND VPWR VPWR sky130_fd_sc_hd__diode_2
XFILLER_0_37_281 VGND VGND VPWR VPWR sky130_fd_sc_hd__fill_2
XFILLER_0_106_3 VPWR VGND VPWR VGND sky130_ef_sc_hd__decap_12
XANTENNA__4253__A_N _1275_ VGND VGND VPWR VPWR sky130_fd_sc_hd__diode_2
XFILLER_0_80_560 VGND VGND VPWR VPWR sky130_fd_sc_hd__fill_1
XFILLER_0_25_476 VGND VGND VPWR VPWR sky130_fd_sc_hd__fill_2
X_4550_ _1536_ u_pe_array.g_pe_row\[2\].g_pe_col\[2\].u_pe.psum_out\[9\] VGND VGND
+ VPWR VPWR _1621_ sky130_fd_sc_hd__nor2_1
XANTENNA__6787__S _3366_ VGND VGND VPWR VPWR sky130_fd_sc_hd__diode_2
XANTENNA__7253__RESET_B net75 VGND VGND VPWR VPWR sky130_fd_sc_hd__diode_2
X_3501_ u_pe_array.g_pe_row\[1\].g_pe_col\[0\].u_pe.act_val\[2\] u_pe_array.g_pe_row\[1\].g_pe_col\[0\].u_pe.psum_out\[2\]
+ _0756_ VGND VGND VPWR VPWR _0761_ sky130_fd_sc_hd__mux2_1
Xhold506 u_pe_array.g_pe_row\[1\].g_pe_col\[1\].u_pe.act_val\[4\] VGND VGND VPWR VPWR
+ net582 sky130_fd_sc_hd__dlygate4sd3_1
X_4481_ _1555_ _1557_ VGND VGND VPWR VPWR _1558_ sky130_fd_sc_hd__nand2_1
XFILLER_0_13_649 VPWR VGND VPWR VGND sky130_ef_sc_hd__decap_12
Xhold517 u_pe_array.u_fifo2.buffer\[4\]\[4\] VGND VGND VPWR VPWR net593 sky130_fd_sc_hd__dlygate4sd3_1
X_6220_ _3013_ u_pe_array.g_pe_row\[0\].g_pe_col\[0\].u_pe.psum_out\[3\] _2992_ VGND
+ VGND VPWR VPWR _3015_ sky130_fd_sc_hd__and3_1
Xhold539 u_pe_array.g_pe_row\[3\].g_pe_col\[0\].u_pe.act_val\[3\] VGND VGND VPWR VPWR
+ net615 sky130_fd_sc_hd__dlygate4sd3_1
Xhold528 u_pe_array.g_pe_row\[1\].g_pe_col\[3\].u_pe.move_reg\[10\] VGND VGND VPWR
+ VPWR net604 sky130_fd_sc_hd__dlygate4sd3_1
XFILLER_0_40_457 VGND VGND VPWR VPWR sky130_fd_sc_hd__decap_3
XFILLER_0_110_345 VGND VGND VPWR VPWR sky130_fd_sc_hd__decap_8
X_6151_ _2873_ u_pe_array.g_pe_row\[0\].g_pe_col\[1\].u_pe.psum_out\[9\] VGND VGND
+ VPWR VPWR _2957_ sky130_fd_sc_hd__and2_1
XTAP_800 VGND VPWR sky130_fd_sc_hd__tapvpwrvgnd_1
XFILLER_0_21_671 VGND VGND VPWR VPWR sky130_fd_sc_hd__fill_1
XANTENNA__3505__A _0754_ VGND VGND VPWR VPWR sky130_fd_sc_hd__diode_2
XTAP_844 VGND VPWR sky130_fd_sc_hd__tapvpwrvgnd_1
XTAP_833 VGND VPWR sky130_fd_sc_hd__tapvpwrvgnd_1
XTAP_822 VGND VPWR sky130_fd_sc_hd__tapvpwrvgnd_1
XTAP_811 VGND VPWR sky130_fd_sc_hd__tapvpwrvgnd_1
XFILLER_0_0_576 VPWR VGND VPWR VGND sky130_ef_sc_hd__decap_12
X_5102_ _2066_ _2068_ _2079_ VGND VGND VPWR VPWR _2080_ sky130_fd_sc_hd__o21ai_2
X_6082_ _2893_ VGND VGND VPWR VPWR _2894_ sky130_fd_sc_hd__inv_2
XTAP_877 VGND VPWR sky130_fd_sc_hd__tapvpwrvgnd_1
XTAP_866 VGND VPWR sky130_fd_sc_hd__tapvpwrvgnd_1
XTAP_855 VGND VPWR sky130_fd_sc_hd__tapvpwrvgnd_1
XTAP_899 VGND VPWR sky130_fd_sc_hd__tapvpwrvgnd_1
X_5033_ net207 _1666_ _2021_ _1665_ VGND VGND VPWR VPWR _0255_ sky130_fd_sc_hd__a22o_1
XTAP_888 VGND VPWR sky130_fd_sc_hd__tapvpwrvgnd_1
XFILLER_0_79_159 VGND VGND VPWR VPWR sky130_fd_sc_hd__fill_2
XANTENNA__3878__C _1009_ VGND VGND VPWR VPWR sky130_fd_sc_hd__diode_2
X_6984_ clknet_leaf_81_clk _0063_ net74 VGND VGND VPWR VPWR u_pe_array.g_pe_row\[3\].g_pe_col\[2\].u_pe.psum_out\[11\]
+ sky130_fd_sc_hd__dfrtp_1
XFILLER_0_48_524 VGND VGND VPWR VPWR sky130_fd_sc_hd__fill_2
X_5935_ u_pe_array.g_pe_row\[0\].g_pe_col\[2\].u_pe.act_val\[3\] VGND VGND VPWR VPWR
+ _2774_ sky130_fd_sc_hd__inv_2
XANTENNA__5866__S _0827_ VGND VGND VPWR VPWR sky130_fd_sc_hd__diode_2
XANTENNA__4770__S _1796_ VGND VGND VPWR VPWR sky130_fd_sc_hd__diode_2
X_5866_ net31 u_pe_array.g_pe_row\[0\].g_pe_col\[2\].u_pe.w_buffer\[0\] _0827_ VGND
+ VGND VPWR VPWR _2724_ sky130_fd_sc_hd__mux2_1
XFILLER_0_90_313 VGND VGND VPWR VPWR sky130_fd_sc_hd__fill_1
X_7605_ clknet_leaf_19_clk _0654_ VGND VGND VPWR VPWR u_pe_array.u_fifo1.buffer\[3\]\[2\]
+ sky130_fd_sc_hd__dfxtp_1
Xclkbuf_leaf_60_clk clknet_3_4__leaf_clk VGND VGND VPWR VPWR clknet_leaf_60_clk sky130_fd_sc_hd__clkbuf_16
XANTENNA__6002__A1 _2740_ VGND VGND VPWR VPWR sky130_fd_sc_hd__diode_2
XFILLER_0_8_643 VGND VGND VPWR VPWR sky130_fd_sc_hd__fill_1
X_4817_ net703 _1666_ _1655_ _1835_ VGND VGND VPWR VPWR _0225_ sky130_fd_sc_hd__a22o_1
XFILLER_0_16_421 VPWR VGND VPWR VGND sky130_ef_sc_hd__decap_12
X_5797_ net721 _2387_ _2661_ _2662_ VGND VGND VPWR VPWR _0378_ sky130_fd_sc_hd__a22o_1
X_4748_ _0787_ VGND VGND VPWR VPWR _1787_ sky130_fd_sc_hd__buf_12
X_7536_ clknet_leaf_0_clk _0585_ VGND VGND VPWR VPWR u_pe_array.u_fifo2.buffer\[7\]\[10\]
+ sky130_fd_sc_hd__dfxtp_1
X_4679_ _0863_ VGND VGND VPWR VPWR _1725_ sky130_fd_sc_hd__buf_8
X_7467_ clknet_leaf_2_clk _0516_ VGND VGND VPWR VPWR u_pe_array.u_fifo2.buffer\[2\]\[6\]
+ sky130_fd_sc_hd__dfxtp_1
X_6418_ _3172_ VGND VGND VPWR VPWR _0489_ sky130_fd_sc_hd__clkbuf_1
Xoutput48 net48 VGND VGND VPWR VPWR psum_out0[9] sky130_fd_sc_hd__clkbuf_4
Xoutput37 net37 VGND VGND VPWR VPWR psum_out0[10] sky130_fd_sc_hd__clkbuf_4
XFILLER_0_101_345 VGND VGND VPWR VPWR sky130_fd_sc_hd__decap_6
X_7398_ clknet_leaf_42_clk _0448_ net817 VGND VGND VPWR VPWR u_pe_array.g_pe_row\[0\].g_pe_col\[0\].u_pe.psum_out\[2\]
+ sky130_fd_sc_hd__dfrtp_1
XANTENNA__3524__C1 _0754_ VGND VGND VPWR VPWR sky130_fd_sc_hd__diode_2
Xoutput59 net59 VGND VGND VPWR VPWR psum_out1[7] sky130_fd_sc_hd__clkbuf_4
X_6349_ _1787_ _1136_ net60 VGND VGND VPWR VPWR _3126_ sky130_fd_sc_hd__a21o_2
XFILLER_0_9_7 VGND VGND VPWR VPWR sky130_fd_sc_hd__decap_8
XANTENNA__6976__RESET_B net819 VGND VGND VPWR VPWR sky130_fd_sc_hd__diode_2
XFILLER_0_98_413 VGND VGND VPWR VPWR sky130_fd_sc_hd__decap_6
XFILLER_0_98_435 VGND VGND VPWR VPWR sky130_fd_sc_hd__fill_2
XFILLER_0_93_140 VGND VGND VPWR VPWR sky130_fd_sc_hd__fill_1
XPHY_143 VGND VGND VPWR VPWR sky130_fd_sc_hd__decap_3
XFILLER_0_66_354 VGND VGND VPWR VPWR sky130_fd_sc_hd__fill_2
XPHY_132 VGND VGND VPWR VPWR sky130_fd_sc_hd__decap_3
XPHY_121 VGND VGND VPWR VPWR sky130_fd_sc_hd__decap_3
XPHY_110 VGND VGND VPWR VPWR sky130_fd_sc_hd__decap_3
XPHY_176 VGND VGND VPWR VPWR sky130_fd_sc_hd__decap_3
XPHY_165 VGND VGND VPWR VPWR sky130_fd_sc_hd__decap_3
XPHY_154 VGND VGND VPWR VPWR sky130_fd_sc_hd__decap_3
Xclkbuf_leaf_51_clk clknet_3_7__leaf_clk VGND VGND VPWR VPWR clknet_leaf_51_clk sky130_fd_sc_hd__clkbuf_16
XFILLER_0_66_365 VGND VGND VPWR VPWR sky130_fd_sc_hd__fill_2
XPHY_198 VGND VGND VPWR VPWR sky130_fd_sc_hd__decap_3
XPHY_187 VGND VGND VPWR VPWR sky130_fd_sc_hd__decap_3
XFILLER_0_54_549 VGND VGND VPWR VPWR sky130_fd_sc_hd__fill_1
XFILLER_0_81_379 VGND VGND VPWR VPWR sky130_fd_sc_hd__fill_2
XANTENNA__4555__A1 _1273_ VGND VGND VPWR VPWR sky130_fd_sc_hd__diode_2
XANTENNA__5227__D _2158_ VGND VGND VPWR VPWR sky130_fd_sc_hd__diode_2
XFILLER_0_22_413 VGND VGND VPWR VPWR sky130_fd_sc_hd__fill_2
XFILLER_0_105_673 VGND VGND VPWR VPWR sky130_fd_sc_hd__decap_4
XANTENNA__4307__A1 _1273_ VGND VGND VPWR VPWR sky130_fd_sc_hd__diode_2
XFILLER_0_104_194 VGND VGND VPWR VPWR sky130_fd_sc_hd__fill_2
XFILLER_0_94_29 VGND VGND VPWR VPWR sky130_fd_sc_hd__fill_1
XFILLER_0_89_479 VGND VGND VPWR VPWR sky130_fd_sc_hd__fill_2
XANTENNA__5035__A2 _1666_ VGND VGND VPWR VPWR sky130_fd_sc_hd__diode_2
XFILLER_0_43_11 VPWR VGND VPWR VGND sky130_ef_sc_hd__decap_12
X_3981_ _0864_ _1142_ _1143_ _1144_ net379 VGND VGND VPWR VPWR _0080_ sky130_fd_sc_hd__a32o_1
XPHY_1 VGND VGND VPWR VPWR sky130_fd_sc_hd__decap_3
XFILLER_0_85_652 VGND VGND VPWR VPWR sky130_fd_sc_hd__fill_2
XANTENNA__4590__S _0770_ VGND VGND VPWR VPWR sky130_fd_sc_hd__diode_2
X_5720_ net688 _2463_ _2592_ _2598_ VGND VGND VPWR VPWR _0365_ sky130_fd_sc_hd__a22o_1
Xclkbuf_leaf_42_clk clknet_3_6__leaf_clk VGND VGND VPWR VPWR clknet_leaf_42_clk sky130_fd_sc_hd__clkbuf_16
XANTENNA__7434__RESET_B net816 VGND VGND VPWR VPWR sky130_fd_sc_hd__diode_2
XFILLER_0_45_505 VGND VGND VPWR VPWR sky130_fd_sc_hd__decap_3
X_5651_ _2542_ _2540_ _2537_ VGND VGND VPWR VPWR _2543_ sky130_fd_sc_hd__a21oi_1
XFILLER_0_17_229 VGND VGND VPWR VPWR sky130_fd_sc_hd__fill_2
X_5582_ u_pe_array.g_pe_row\[1\].g_pe_col\[0\].u_pe.act_val\[0\] u_pe_array.g_pe_row\[1\].g_pe_col\[0\].u_pe.psum_out\[1\]
+ _2478_ VGND VGND VPWR VPWR _2480_ sky130_fd_sc_hd__and3_1
X_4602_ net621 _1524_ _1659_ _1399_ VGND VGND VPWR VPWR _0186_ sky130_fd_sc_hd__a22o_1
XFILLER_0_60_508 VGND VGND VPWR VPWR sky130_fd_sc_hd__fill_2
XFILLER_0_25_251 VGND VGND VPWR VPWR sky130_fd_sc_hd__decap_3
X_4533_ _1273_ _1604_ _1605_ _1534_ u_pe_array.g_pe_row\[2\].g_pe_col\[2\].u_pe.psum_out\[7\]
+ VGND VGND VPWR VPWR _0171_ sky130_fd_sc_hd__a32o_1
X_7321_ clknet_leaf_68_clk _0378_ net814 VGND VGND VPWR VPWR u_pe_array.g_pe_row\[0\].g_pe_col\[3\].u_pe.psum_out\[5\]
+ sky130_fd_sc_hd__dfrtp_1
XFILLER_0_102_109 VGND VGND VPWR VPWR sky130_fd_sc_hd__fill_1
X_7252_ clknet_leaf_57_clk net116 net75 VGND VGND VPWR VPWR u_pe_array.g_pe_row\[1\].g_pe_col\[0\].u_pe.move_reg\[11\]
+ sky130_fd_sc_hd__dfrtp_1
Xhold303 u_pe_array.g_pe_row\[3\].g_pe_col\[1\].u_pe.psum_out\[0\] VGND VGND VPWR
+ VPWR net379 sky130_fd_sc_hd__dlygate4sd3_1
Xhold325 u_pe_array.g_pe_row\[1\].g_pe_col\[0\].u_pe.psum_out\[0\] VGND VGND VPWR
+ VPWR net401 sky130_fd_sc_hd__dlygate4sd3_1
XFILLER_0_4_189 VGND VGND VPWR VPWR sky130_fd_sc_hd__decap_6
Xhold314 u_pe_array.g_pe_row\[2\].g_pe_col\[2\].u_pe.psum_out\[11\] VGND VGND VPWR
+ VPWR net390 sky130_fd_sc_hd__dlygate4sd3_1
X_6203_ u_pe_array.g_pe_row\[0\].g_pe_col\[0\].u_pe.act_val\[2\] u_pe_array.g_pe_row\[0\].g_pe_col\[0\].u_pe.w_reg\[0\]
+ VGND VGND VPWR VPWR _2999_ sky130_fd_sc_hd__nand2_1
Xhold369 u_pe_array.u_fifo1.buffer\[4\]\[3\] VGND VGND VPWR VPWR net445 sky130_fd_sc_hd__dlygate4sd3_1
Xhold336 u_pe_array.u_fifo1.buffer\[0\]\[3\] VGND VGND VPWR VPWR net412 sky130_fd_sc_hd__dlygate4sd3_1
Xhold358 u_pe_array.g_pe_row\[2\].g_pe_col\[1\].u_pe.psum_out\[12\] VGND VGND VPWR
+ VPWR net434 sky130_fd_sc_hd__dlygate4sd3_1
XFILLER_0_68_41 VPWR VGND VPWR VGND sky130_ef_sc_hd__decap_12
Xhold347 u_pe_array.g_pe_row\[2\].g_pe_col\[0\].u_pe.move_reg\[10\] VGND VGND VPWR
+ VPWR net423 sky130_fd_sc_hd__dlygate4sd3_1
XFILLER_0_7_66 VGND VGND VPWR VPWR sky130_fd_sc_hd__fill_2
XFILLER_0_13_479 VGND VGND VPWR VPWR sky130_fd_sc_hd__fill_1
X_4464_ _1532_ _1538_ VGND VGND VPWR VPWR _1542_ sky130_fd_sc_hd__and2_1
XFILLER_0_40_287 VGND VGND VPWR VPWR sky130_fd_sc_hd__fill_2
XFILLER_0_111_665 VGND VGND VPWR VPWR sky130_fd_sc_hd__decap_4
X_7183_ clknet_leaf_62_clk _0250_ net73 VGND VGND VPWR VPWR u_pe_array.g_pe_row\[1\].g_pe_col\[2\].u_pe.act_val\[2\]
+ sky130_fd_sc_hd__dfrtp_2
X_4395_ _1485_ _1487_ _1492_ VGND VGND VPWR VPWR _1494_ sky130_fd_sc_hd__or3_1
XFILLER_0_21_490 VGND VGND VPWR VPWR sky130_fd_sc_hd__fill_2
XFILLER_0_110_197 VGND VGND VPWR VPWR sky130_fd_sc_hd__fill_2
X_6134_ _2932_ _2937_ _2940_ VGND VGND VPWR VPWR _2942_ sky130_fd_sc_hd__or3_1
XTAP_630 VGND VPWR sky130_fd_sc_hd__tapvpwrvgnd_1
XTAP_652 VGND VPWR sky130_fd_sc_hd__tapvpwrvgnd_1
XTAP_641 VGND VPWR sky130_fd_sc_hd__tapvpwrvgnd_1
X_6065_ _2740_ _2877_ _2878_ _2571_ net489 VGND VGND VPWR VPWR _0430_ sky130_fd_sc_hd__a32o_1
XTAP_663 VGND VPWR sky130_fd_sc_hd__tapvpwrvgnd_1
XTAP_674 VGND VPWR sky130_fd_sc_hd__tapvpwrvgnd_1
XTAP_685 VGND VPWR sky130_fd_sc_hd__tapvpwrvgnd_1
X_5016_ u_pe_array.u_fifo2.buffer\[6\]\[4\] _1964_ _2005_ _2007_ VGND VGND VPWR VPWR
+ _2008_ sky130_fd_sc_hd__a211o_1
XANTENNA__6471__A1 _1806_ VGND VGND VPWR VPWR sky130_fd_sc_hd__diode_2
XTAP_696 VGND VPWR sky130_fd_sc_hd__tapvpwrvgnd_1
XANTENNA__4066__A _1145_ VGND VGND VPWR VPWR sky130_fd_sc_hd__diode_2
X_6967_ clknet_leaf_84_clk _0048_ net74 VGND VGND VPWR VPWR u_pe_array.g_pe_row\[3\].g_pe_col\[1\].u_pe.move_reg\[9\]
+ sky130_fd_sc_hd__dfrtp_1
X_5918_ net689 _2387_ _2174_ _2758_ VGND VGND VPWR VPWR _0403_ sky130_fd_sc_hd__a22o_1
XFILLER_0_91_611 VGND VGND VPWR VPWR sky130_fd_sc_hd__fill_2
Xclkbuf_leaf_33_clk clknet_3_3__leaf_clk VGND VGND VPWR VPWR clknet_leaf_33_clk sky130_fd_sc_hd__clkbuf_16
XANTENNA__7175__RESET_B net813 VGND VGND VPWR VPWR sky130_fd_sc_hd__diode_2
X_6898_ net583 _3120_ _3427_ VGND VGND VPWR VPWR _3433_ sky130_fd_sc_hd__mux2_1
XFILLER_0_48_365 VGND VGND VPWR VPWR sky130_fd_sc_hd__decap_3
X_5849_ _2707_ _2709_ VGND VGND VPWR VPWR _2710_ sky130_fd_sc_hd__or2_1
XANTENNA__5694__A_N _2478_ VGND VGND VPWR VPWR sky130_fd_sc_hd__diode_2
XANTENNA__7104__RESET_B net74 VGND VGND VPWR VPWR sky130_fd_sc_hd__diode_2
X_7519_ clknet_leaf_2_clk _0568_ VGND VGND VPWR VPWR u_pe_array.u_fifo2.buffer\[6\]\[6\]
+ sky130_fd_sc_hd__dfxtp_1
XFILLER_0_31_232 VGND VGND VPWR VPWR sky130_fd_sc_hd__fill_2
XANTENNA_hold498_A u_pe_array.g_pe_row\[1\].g_pe_col\[0\].u_pe.act_val\[4\] VGND VGND
+ VPWR VPWR sky130_fd_sc_hd__diode_2
XFILLER_0_101_164 VGND VGND VPWR VPWR sky130_fd_sc_hd__fill_2
XFILLER_0_101_186 VGND VGND VPWR VPWR sky130_fd_sc_hd__fill_1
XANTENNA__5998__C _2743_ VGND VGND VPWR VPWR sky130_fd_sc_hd__diode_2
XANTENNA__4473__B1 _0885_ VGND VGND VPWR VPWR sky130_fd_sc_hd__diode_2
XANTENNA__6890__S _3427_ VGND VGND VPWR VPWR sky130_fd_sc_hd__diode_2
XANTENNA_input14_A start VGND VGND VPWR VPWR sky130_fd_sc_hd__diode_2
XFILLER_0_58_107 VGND VGND VPWR VPWR sky130_fd_sc_hd__decap_4
XFILLER_0_104_27 VGND VGND VPWR VPWR sky130_fd_sc_hd__fill_1
Xclkbuf_leaf_24_clk clknet_3_2__leaf_clk VGND VGND VPWR VPWR clknet_leaf_24_clk sky130_fd_sc_hd__clkbuf_16
XFILLER_0_66_162 VGND VGND VPWR VPWR sky130_fd_sc_hd__decap_3
XFILLER_0_54_313 VGND VGND VPWR VPWR sky130_fd_sc_hd__fill_1
XFILLER_0_54_379 VGND VGND VPWR VPWR sky130_fd_sc_hd__fill_2
XANTENNA__4528__A1 _1273_ VGND VGND VPWR VPWR sky130_fd_sc_hd__diode_2
XFILLER_0_35_571 VGND VGND VPWR VPWR sky130_fd_sc_hd__decap_3
XFILLER_0_112_418 VGND VGND VPWR VPWR sky130_fd_sc_hd__fill_2
XFILLER_0_105_492 VGND VGND VPWR VPWR sky130_fd_sc_hd__decap_3
XFILLER_0_22_276 VGND VGND VPWR VPWR sky130_fd_sc_hd__decap_4
XFILLER_0_50_596 VGND VGND VPWR VPWR sky130_fd_sc_hd__fill_2
X_4180_ _1309_ _1310_ _1311_ VGND VGND VPWR VPWR _1312_ sky130_fd_sc_hd__and3_1
X_6821_ _3391_ VGND VGND VPWR VPWR _0673_ sky130_fd_sc_hd__clkbuf_1
XANTENNA__4216__B1 _1144_ VGND VGND VPWR VPWR sky130_fd_sc_hd__diode_2
XFILLER_0_77_449 VGND VGND VPWR VPWR sky130_fd_sc_hd__decap_6
XFILLER_0_58_641 VGND VGND VPWR VPWR sky130_fd_sc_hd__fill_1
X_3964_ net119 _0996_ _1134_ _1004_ VGND VGND VPWR VPWR _0073_ sky130_fd_sc_hd__a22o_1
XFILLER_0_92_419 VGND VGND VPWR VPWR sky130_fd_sc_hd__fill_1
Xclkbuf_leaf_15_clk clknet_3_3__leaf_clk VGND VGND VPWR VPWR clknet_leaf_15_clk sky130_fd_sc_hd__clkbuf_16
X_6752_ net549 _3114_ net63 VGND VGND VPWR VPWR _3355_ sky130_fd_sc_hd__mux2_1
XFILLER_0_70_53 VGND VGND VPWR VPWR sky130_fd_sc_hd__decap_3
X_5703_ net512 _2387_ _2174_ _2589_ VGND VGND VPWR VPWR _0357_ sky130_fd_sc_hd__a22o_1
XFILLER_0_73_633 VGND VGND VPWR VPWR sky130_fd_sc_hd__fill_1
XANTENNA__5429__B _2345_ VGND VGND VPWR VPWR sky130_fd_sc_hd__diode_2
X_6683_ u_pe_array.u_fifo1.count\[2\] VGND VGND VPWR VPWR _3317_ sky130_fd_sc_hd__inv_2
XFILLER_0_57_173 VGND VGND VPWR VPWR sky130_fd_sc_hd__decap_3
XFILLER_0_18_538 VGND VGND VPWR VPWR sky130_fd_sc_hd__decap_3
X_3895_ _1075_ _1079_ _1064_ VGND VGND VPWR VPWR _1080_ sky130_fd_sc_hd__mux2_1
X_5634_ _2526_ _2527_ VGND VGND VPWR VPWR _2528_ sky130_fd_sc_hd__nor2_1
XFILLER_0_60_305 VGND VGND VPWR VPWR sky130_fd_sc_hd__decap_3
XANTENNA__5716__B1 _2592_ VGND VGND VPWR VPWR sky130_fd_sc_hd__diode_2
XANTENNA__6040__S _2469_ VGND VGND VPWR VPWR sky130_fd_sc_hd__diode_2
XFILLER_0_78_3 VPWR VGND VPWR VGND sky130_ef_sc_hd__decap_12
XANTENNA__5192__B2 _1665_ VGND VGND VPWR VPWR sky130_fd_sc_hd__diode_2
XANTENNA__5445__A u_pe_array.g_pe_row\[1\].g_pe_col\[1\].u_pe.w_reg\[0\] VGND VGND
+ VPWR VPWR sky130_fd_sc_hd__diode_2
Xhold100 u_pe_array.g_pe_row\[1\].g_pe_col\[1\].u_pe.move_reg\[9\] VGND VGND VPWR
+ VPWR net176 sky130_fd_sc_hd__dlygate4sd3_1
X_5565_ u_pe_array.g_pe_row\[1\].g_pe_col\[3\].u_pe.psum_out\[7\] u_pe_array.g_pe_row\[1\].g_pe_col\[3\].u_pe.move_reg\[7\]
+ _2469_ VGND VGND VPWR VPWR _2470_ sky130_fd_sc_hd__mux2_1
X_7304_ clknet_leaf_63_clk _0363_ net814 VGND VGND VPWR VPWR u_pe_array.g_pe_row\[0\].g_pe_col\[2\].u_pe.act_val\[3\]
+ sky130_fd_sc_hd__dfrtp_2
X_5496_ _2258_ _2414_ _2415_ _2071_ u_pe_array.g_pe_row\[1\].g_pe_col\[1\].u_pe.psum_out\[7\]
+ VGND VGND VPWR VPWR _0324_ sky130_fd_sc_hd__a32o_1
XFILLER_0_79_73 VGND VGND VPWR VPWR sky130_fd_sc_hd__fill_2
Xhold144 u_pe_array.u_fifo1.buffer\[7\]\[11\] VGND VGND VPWR VPWR net220 sky130_fd_sc_hd__dlygate4sd3_1
Xhold133 u_pe_array.g_pe_row\[2\].g_pe_col\[1\].u_pe.move_reg\[9\] VGND VGND VPWR
+ VPWR net209 sky130_fd_sc_hd__dlygate4sd3_1
Xhold122 u_pe_array.g_pe_row\[3\].g_pe_col\[1\].u_pe.move_reg\[11\] VGND VGND VPWR
+ VPWR net198 sky130_fd_sc_hd__dlygate4sd3_1
X_4516_ u_pe_array.g_pe_row\[2\].g_pe_col\[2\].u_pe.act_val\[5\] VGND VGND VPWR VPWR
+ _1590_ sky130_fd_sc_hd__inv_2
Xhold111 u_pe_array.g_pe_row\[2\].g_pe_col\[2\].u_pe.move_reg\[8\] VGND VGND VPWR
+ VPWR net187 sky130_fd_sc_hd__dlygate4sd3_1
XFILLER_0_111_473 VPWR VGND VPWR VGND sky130_ef_sc_hd__decap_12
Xhold177 u_pe_array.u_fifo1.buffer\[0\]\[7\] VGND VGND VPWR VPWR net253 sky130_fd_sc_hd__dlygate4sd3_1
Xhold166 u_pe_array.u_fifo1.buffer\[2\]\[8\] VGND VGND VPWR VPWR net242 sky130_fd_sc_hd__dlygate4sd3_1
Xhold155 u_pe_array.u_fifo1.buffer\[4\]\[11\] VGND VGND VPWR VPWR net231 sky130_fd_sc_hd__dlygate4sd3_1
X_7235_ clknet_leaf_53_clk _0298_ net812 VGND VGND VPWR VPWR u_pe_array.g_pe_row\[1\].g_pe_col\[2\].u_pe.psum_out\[9\]
+ sky130_fd_sc_hd__dfrtp_1
X_4447_ u_pe_array.g_pe_row\[3\].g_pe_col\[1\].u_pe.psum_out\[11\] net198 _0855_ VGND
+ VGND VPWR VPWR _1529_ sky130_fd_sc_hd__mux2_1
Xhold188 u_pe_array.u_fifo1.buffer\[7\]\[6\] VGND VGND VPWR VPWR net264 sky130_fd_sc_hd__dlygate4sd3_1
X_7166_ clknet_leaf_31_clk _0233_ net817 VGND VGND VPWR VPWR u_pe_array.g_pe_row\[2\].g_pe_col\[0\].u_pe.psum_out\[0\]
+ sky130_fd_sc_hd__dfrtp_1
Xhold199 u_pe_array.u_fifo1.buffer\[2\]\[6\] VGND VGND VPWR VPWR net275 sky130_fd_sc_hd__dlygate4sd3_1
XFILLER_0_0_181 VPWR VGND VPWR VGND sky130_ef_sc_hd__decap_12
X_6117_ u_pe_array.g_pe_row\[0\].g_pe_col\[1\].u_pe.psum_out\[5\] _2917_ _2925_ VGND
+ VGND VPWR VPWR _2926_ sky130_fd_sc_hd__a21o_1
X_4378_ _1467_ _1473_ VGND VGND VPWR VPWR _1478_ sky130_fd_sc_hd__or2b_1
XANTENNA_input6_A h_in0[5] VGND VGND VPWR VPWR sky130_fd_sc_hd__diode_2
XTAP_460 VGND VPWR sky130_fd_sc_hd__tapvpwrvgnd_1
XANTENNA__5180__A _0832_ VGND VGND VPWR VPWR sky130_fd_sc_hd__diode_2
X_7097_ clknet_leaf_92_clk _0168_ net819 VGND VGND VPWR VPWR u_pe_array.g_pe_row\[2\].g_pe_col\[2\].u_pe.psum_out\[4\]
+ sky130_fd_sc_hd__dfrtp_1
XTAP_482 VGND VPWR sky130_fd_sc_hd__tapvpwrvgnd_1
XTAP_471 VGND VPWR sky130_fd_sc_hd__tapvpwrvgnd_1
XTAP_493 VGND VPWR sky130_fd_sc_hd__tapvpwrvgnd_1
XANTENNA__6444__A1 _1806_ VGND VGND VPWR VPWR sky130_fd_sc_hd__diode_2
X_6048_ u_pe_array.g_pe_row\[0\].g_pe_col\[1\].u_pe.psum_out\[10\] net214 _2469_ VGND
+ VGND VPWR VPWR _2866_ sky130_fd_sc_hd__mux2_1
XANTENNA__3552__C_N net14 VGND VGND VPWR VPWR sky130_fd_sc_hd__diode_2
XANTENNA__4455__B1 _1534_ VGND VGND VPWR VPWR sky130_fd_sc_hd__diode_2
XTAP_1615 VGND VPWR sky130_fd_sc_hd__tapvpwrvgnd_1
XTAP_1604 VGND VPWR sky130_fd_sc_hd__tapvpwrvgnd_1
XFILLER_0_68_416 VGND VGND VPWR VPWR sky130_fd_sc_hd__fill_2
XANTENNA__7356__RESET_B net818 VGND VGND VPWR VPWR sky130_fd_sc_hd__diode_2
XTAP_1626 VGND VPWR sky130_fd_sc_hd__tapvpwrvgnd_1
XFILLER_0_95_246 VGND VGND VPWR VPWR sky130_fd_sc_hd__fill_2
XFILLER_0_51_305 VGND VGND VPWR VPWR sky130_fd_sc_hd__fill_2
XFILLER_0_36_346 VGND VGND VPWR VPWR sky130_fd_sc_hd__fill_2
XANTENNA__5183__A1 _1834_ VGND VGND VPWR VPWR sky130_fd_sc_hd__diode_2
XFILLER_0_51_327 VGND VGND VPWR VPWR sky130_fd_sc_hd__fill_1
XFILLER_0_106_278 VGND VGND VPWR VPWR sky130_fd_sc_hd__fill_1
XANTENNA__6991__RESET_B net76 VGND VGND VPWR VPWR sky130_fd_sc_hd__diode_2
XANTENNA__6920__RESET_B net73 VGND VGND VPWR VPWR sky130_fd_sc_hd__diode_2
XFILLER_0_102_462 VGND VGND VPWR VPWR sky130_fd_sc_hd__fill_1
XFILLER_0_102_451 VGND VGND VPWR VPWR sky130_fd_sc_hd__fill_2
XANTENNA__4694__B1 _1534_ VGND VGND VPWR VPWR sky130_fd_sc_hd__diode_2
XANTENNA__7097__RESET_B net819 VGND VGND VPWR VPWR sky130_fd_sc_hd__diode_2
XFILLER_0_86_246 VGND VGND VPWR VPWR sky130_fd_sc_hd__fill_2
XFILLER_0_59_449 VGND VGND VPWR VPWR sky130_fd_sc_hd__decap_6
XFILLER_0_55_611 VGND VGND VPWR VPWR sky130_fd_sc_hd__fill_2
XANTENNA__7026__RESET_B net74 VGND VGND VPWR VPWR sky130_fd_sc_hd__diode_2
XANTENNA__4749__B2 _0747_ VGND VGND VPWR VPWR sky130_fd_sc_hd__diode_2
XANTENNA__4749__A1 _1787_ VGND VGND VPWR VPWR sky130_fd_sc_hd__diode_2
XFILLER_0_40_23 VGND VGND VPWR VPWR sky130_fd_sc_hd__fill_2
Xload_slew1 net75 VGND VGND VPWR VPWR net812 sky130_fd_sc_hd__buf_12
XFILLER_0_54_187 VGND VGND VPWR VPWR sky130_fd_sc_hd__decap_6
X_3680_ u_pe_array.g_pe_row\[3\].g_pe_col\[3\].u_pe.psum_out\[2\] _0881_ _0896_ VGND
+ VGND VPWR VPWR _0897_ sky130_fd_sc_hd__a21oi_1
XFILLER_0_27_379 VGND VGND VPWR VPWR sky130_fd_sc_hd__fill_2
XFILLER_0_42_305 VGND VGND VPWR VPWR sky130_fd_sc_hd__fill_1
XANTENNA__5174__A1 _1826_ VGND VGND VPWR VPWR sky130_fd_sc_hd__diode_2
XFILLER_0_112_248 VGND VGND VPWR VPWR sky130_fd_sc_hd__decap_4
X_5350_ u_pe_array.u_fifo1.buffer\[8\]\[0\] _2273_ _2276_ _2289_ _0819_ VGND VGND
+ VPWR VPWR _2290_ sky130_fd_sc_hd__a221o_1
XFILLER_0_49_21 VGND VGND VPWR VPWR sky130_fd_sc_hd__decap_4
XFILLER_0_2_457 VPWR VGND VPWR VGND sky130_ef_sc_hd__decap_12
XANTENNA__6795__S _3366_ VGND VGND VPWR VPWR sky130_fd_sc_hd__diode_2
X_5281_ _2223_ _2221_ _2227_ VGND VGND VPWR VPWR _2229_ sky130_fd_sc_hd__or3_1
X_4301_ u_pe_array.g_pe_row\[2\].g_pe_col\[3\].u_pe.act_val\[0\] _1407_ u_pe_array.g_pe_row\[2\].g_pe_col\[3\].u_pe.psum_out\[1\]
+ VGND VGND VPWR VPWR _1408_ sky130_fd_sc_hd__a21oi_1
XFILLER_0_10_224 VGND VGND VPWR VPWR sky130_fd_sc_hd__decap_3
XFILLER_0_10_213 VGND VGND VPWR VPWR sky130_fd_sc_hd__fill_2
X_4232_ _1275_ u_pe_array.g_pe_row\[3\].g_pe_col\[0\].u_pe.psum_out\[9\] VGND VGND
+ VPWR VPWR _1359_ sky130_fd_sc_hd__and2_1
X_7020_ clknet_leaf_77_clk _0097_ net819 VGND VGND VPWR VPWR u_pe_array.g_pe_row\[2\].g_pe_col\[3\].u_pe.act_val\[2\]
+ sky130_fd_sc_hd__dfrtp_2
Xclkbuf_leaf_4_clk clknet_3_0__leaf_clk VGND VGND VPWR VPWR clknet_leaf_4_clk sky130_fd_sc_hd__clkbuf_16
X_4163_ _1295_ VGND VGND VPWR VPWR _1296_ sky130_fd_sc_hd__inv_2
XANTENNA__3513__A _0745_ VGND VGND VPWR VPWR sky130_fd_sc_hd__diode_2
X_4094_ u_pe_array.g_pe_row\[3\].g_pe_col\[1\].u_pe.psum_out\[10\] _1243_ _1246_ VGND
+ VGND VPWR VPWR _1247_ sky130_fd_sc_hd__a21oi_1
XFILLER_0_65_97 VGND VGND VPWR VPWR sky130_fd_sc_hd__decap_3
X_6804_ net446 _3103_ _3382_ VGND VGND VPWR VPWR _3383_ sky130_fd_sc_hd__mux2_1
XFILLER_0_81_74 VGND VGND VPWR VPWR sky130_fd_sc_hd__fill_2
X_4996_ u_pe_array.u_fifo2.buffer\[5\]\[2\] _1971_ _1972_ u_pe_array.u_fifo2.buffer\[1\]\[2\]
+ _1973_ VGND VGND VPWR VPWR _1990_ sky130_fd_sc_hd__a221o_1
X_6735_ net314 _3124_ net64 VGND VGND VPWR VPWR _3346_ sky130_fd_sc_hd__mux2_1
X_3947_ net690 _0996_ _0837_ _1123_ VGND VGND VPWR VPWR _0067_ sky130_fd_sc_hd__a22o_1
XFILLER_0_18_335 VGND VGND VPWR VPWR sky130_fd_sc_hd__fill_2
XANTENNA__5874__S _0770_ VGND VGND VPWR VPWR sky130_fd_sc_hd__diode_2
XFILLER_0_73_485 VGND VGND VPWR VPWR sky130_fd_sc_hd__fill_1
X_6666_ net178 _3302_ _3305_ VGND VGND VPWR VPWR _0604_ sky130_fd_sc_hd__a21oi_1
XFILLER_0_61_636 VGND VGND VPWR VPWR sky130_fd_sc_hd__fill_2
XFILLER_0_61_614 VGND VGND VPWR VPWR sky130_fd_sc_hd__fill_2
XFILLER_0_45_176 VGND VGND VPWR VPWR sky130_fd_sc_hd__decap_4
XFILLER_0_45_165 VGND VGND VPWR VPWR sky130_fd_sc_hd__fill_1
X_3878_ _1063_ u_pe_array.g_pe_row\[3\].g_pe_col\[2\].u_pe.psum_out\[6\] _1009_ VGND
+ VGND VPWR VPWR _1064_ sky130_fd_sc_hd__nand3_2
XANTENNA__6362__A0 _3134_ VGND VGND VPWR VPWR sky130_fd_sc_hd__diode_2
X_5617_ _2510_ _2511_ u_pe_array.g_pe_row\[1\].g_pe_col\[0\].u_pe.act_val\[4\] u_pe_array.g_pe_row\[1\].g_pe_col\[0\].u_pe.w_reg\[0\]
+ VGND VGND VPWR VPWR _2512_ sky130_fd_sc_hd__and4bb_1
X_6597_ net251 _1820_ _3254_ VGND VGND VPWR VPWR _3267_ sky130_fd_sc_hd__mux2_1
XFILLER_0_33_349 VGND VGND VPWR VPWR sky130_fd_sc_hd__fill_2
X_5548_ _2460_ VGND VGND VPWR VPWR _0331_ sky130_fd_sc_hd__clkbuf_1
XANTENNA__3715__A2 _0869_ VGND VGND VPWR VPWR sky130_fd_sc_hd__diode_2
XFILLER_0_41_360 VGND VGND VPWR VPWR sky130_fd_sc_hd__fill_2
XANTENNA__6114__B1 _0885_ VGND VGND VPWR VPWR sky130_fd_sc_hd__diode_2
XFILLER_0_111_281 VPWR VGND VPWR VGND sky130_ef_sc_hd__decap_12
X_5479_ u_pe_array.g_pe_row\[1\].g_pe_col\[1\].u_pe.act_val\[5\] VGND VGND VPWR VPWR
+ _2400_ sky130_fd_sc_hd__inv_2
X_7218_ clknet_leaf_53_clk net285 net812 VGND VGND VPWR VPWR u_pe_array.g_pe_row\[1\].g_pe_col\[1\].u_pe.move_reg\[7\]
+ sky130_fd_sc_hd__dfrtp_1
X_7149_ clknet_leaf_42_clk _0218_ net817 VGND VGND VPWR VPWR u_pe_array.g_pe_row\[2\].g_pe_col\[0\].u_pe.w_buffer\[0\]
+ sky130_fd_sc_hd__dfrtp_1
XTAP_290 VGND VPWR sky130_fd_sc_hd__tapvpwrvgnd_1
XANTENNA__6417__A1 _1806_ VGND VGND VPWR VPWR sky130_fd_sc_hd__diode_2
XANTENNA__7190__RESET_B net73 VGND VGND VPWR VPWR sky130_fd_sc_hd__diode_2
XTAP_1423 VGND VPWR sky130_fd_sc_hd__tapvpwrvgnd_1
XTAP_1412 VGND VPWR sky130_fd_sc_hd__tapvpwrvgnd_1
XTAP_1401 VGND VPWR sky130_fd_sc_hd__tapvpwrvgnd_1
XTAP_1456 VGND VPWR sky130_fd_sc_hd__tapvpwrvgnd_1
XTAP_1434 VGND VPWR sky130_fd_sc_hd__tapvpwrvgnd_1
XTAP_1445 VGND VPWR sky130_fd_sc_hd__tapvpwrvgnd_1
XFILLER_0_83_216 VGND VGND VPWR VPWR sky130_fd_sc_hd__fill_2
XTAP_1489 VGND VPWR sky130_fd_sc_hd__tapvpwrvgnd_1
XTAP_1478 VGND VPWR sky130_fd_sc_hd__tapvpwrvgnd_1
XTAP_1467 VGND VPWR sky130_fd_sc_hd__tapvpwrvgnd_1
XFILLER_0_36_110 VGND VGND VPWR VPWR sky130_fd_sc_hd__fill_1
XFILLER_0_107_554 VGND VGND VPWR VPWR sky130_fd_sc_hd__decap_6
XFILLER_0_91_271 VGND VGND VPWR VPWR sky130_fd_sc_hd__decap_4
XFILLER_0_51_113 VGND VGND VPWR VPWR sky130_fd_sc_hd__fill_2
XANTENNA__6353__A0 _3128_ VGND VGND VPWR VPWR sky130_fd_sc_hd__diode_2
XFILLER_0_101_39 VPWR VGND VPWR VGND sky130_ef_sc_hd__decap_12
XFILLER_0_20_533 VGND VGND VPWR VPWR sky130_fd_sc_hd__fill_2
XFILLER_0_102_281 VGND VGND VPWR VPWR sky130_fd_sc_hd__fill_1
XANTENNA__5813__A _2611_ VGND VGND VPWR VPWR sky130_fd_sc_hd__diode_2
XFILLER_0_19_24 VGND VGND VPWR VPWR sky130_fd_sc_hd__decap_3
XANTENNA__5532__B _2345_ VGND VGND VPWR VPWR sky130_fd_sc_hd__diode_2
XANTENNA__4131__A2 _1138_ VGND VGND VPWR VPWR sky130_fd_sc_hd__diode_2
XANTENNA__7278__RESET_B net814 VGND VGND VPWR VPWR sky130_fd_sc_hd__diode_2
XANTENNA_output45_A net45 VGND VGND VPWR VPWR sky130_fd_sc_hd__diode_2
XANTENNA__7207__RESET_B net814 VGND VGND VPWR VPWR sky130_fd_sc_hd__diode_2
XANTENNA__4419__B1 _0887_ VGND VGND VPWR VPWR sky130_fd_sc_hd__diode_2
Xclkbuf_3_7__f_clk clknet_0_clk VGND VGND VPWR VPWR clknet_3_7__leaf_clk sky130_fd_sc_hd__clkbuf_16
XFILLER_0_59_213 VGND VGND VPWR VPWR sky130_fd_sc_hd__decap_8
XFILLER_0_99_393 VGND VGND VPWR VPWR sky130_fd_sc_hd__fill_2
XFILLER_0_87_533 VGND VGND VPWR VPWR sky130_fd_sc_hd__decap_4
XFILLER_0_35_89 VGND VGND VPWR VPWR sky130_fd_sc_hd__fill_1
X_4850_ u_pe_array.g_pe_row\[2\].g_pe_col\[0\].u_pe.psum_out\[2\] _1858_ VGND VGND
+ VPWR VPWR _1859_ sky130_fd_sc_hd__xnor2_1
XANTENNA_clkbuf_leaf_0_clk_A clknet_3_0__leaf_clk VGND VGND VPWR VPWR sky130_fd_sc_hd__diode_2
X_3801_ net135 _0996_ _0999_ u_fsm.psum_shift_en VGND VGND VPWR VPWR _0045_ sky130_fd_sc_hd__a22o_1
XFILLER_0_7_505 VPWR VGND VPWR VGND sky130_ef_sc_hd__decap_12
XFILLER_0_28_611 VGND VGND VPWR VPWR sky130_fd_sc_hd__fill_1
XFILLER_0_55_441 VGND VGND VPWR VPWR sky130_fd_sc_hd__decap_6
X_6520_ _3226_ VGND VGND VPWR VPWR _0537_ sky130_fd_sc_hd__clkbuf_1
X_4781_ _1787_ _0852_ _1001_ _0747_ VGND VGND VPWR VPWR _1812_ sky130_fd_sc_hd__a22o_4
X_3732_ _0939_ _0937_ _0943_ VGND VGND VPWR VPWR _0945_ sky130_fd_sc_hd__or3_1
X_3663_ _0879_ _0880_ VGND VGND VPWR VPWR _0881_ sky130_fd_sc_hd__xnor2_1
XFILLER_0_15_349 VGND VGND VPWR VPWR sky130_fd_sc_hd__fill_2
X_6451_ _3189_ VGND VGND VPWR VPWR _0505_ sky130_fd_sc_hd__clkbuf_1
XANTENNA__4103__S _0828_ VGND VGND VPWR VPWR sky130_fd_sc_hd__diode_2
X_5402_ net126 _2144_ _2334_ _1665_ VGND VGND VPWR VPWR _0311_ sky130_fd_sc_hd__a22o_1
XANTENNA__5698__A2 _2387_ VGND VGND VPWR VPWR sky130_fd_sc_hd__diode_2
XFILLER_0_70_477 VGND VGND VPWR VPWR sky130_fd_sc_hd__decap_6
XANTENNA__3508__A _0754_ VGND VGND VPWR VPWR sky130_fd_sc_hd__diode_2
X_6382_ u_pe_array.u_fifo2.rd_ptr\[0\] _3146_ net748 VGND VGND VPWR VPWR _3149_ sky130_fd_sc_hd__a21oi_1
XFILLER_0_2_221 VPWR VGND VPWR VGND sky130_ef_sc_hd__decap_12
X_5333_ _2271_ _2272_ VGND VGND VPWR VPWR _2273_ sky130_fd_sc_hd__nor2_4
X_3594_ net87 net78 _0828_ VGND VGND VPWR VPWR _0829_ sky130_fd_sc_hd__mux2_1
XANTENNA__5723__A _0832_ VGND VGND VPWR VPWR sky130_fd_sc_hd__diode_2
X_5264_ _2211_ _2158_ u_pe_array.g_pe_row\[1\].g_pe_col\[2\].u_pe.psum_out\[6\] VGND
+ VGND VPWR VPWR _2213_ sky130_fd_sc_hd__a21oi_1
X_4215_ _1334_ _1339_ _1342_ VGND VGND VPWR VPWR _1344_ sky130_fd_sc_hd__or3_1
X_7003_ clknet_leaf_15_clk _0080_ net816 VGND VGND VPWR VPWR u_pe_array.g_pe_row\[3\].g_pe_col\[1\].u_pe.psum_out\[0\]
+ sky130_fd_sc_hd__dfrtp_1
X_5195_ u_pe_array.g_pe_row\[1\].g_pe_col\[2\].u_pe.psum_out\[11\] u_pe_array.g_pe_row\[1\].g_pe_col\[2\].u_pe.move_reg\[11\]
+ _1661_ VGND VGND VPWR VPWR _2152_ sky130_fd_sc_hd__mux2_1
X_4146_ _1273_ _1279_ _1280_ _1144_ net485 VGND VGND VPWR VPWR _0109_ sky130_fd_sc_hd__a32o_1
XANTENNA__4773__S _1796_ VGND VGND VPWR VPWR sky130_fd_sc_hd__diode_2
XFILLER_0_97_319 VGND VGND VPWR VPWR sky130_fd_sc_hd__decap_3
XFILLER_0_92_62 VGND VGND VPWR VPWR sky130_fd_sc_hd__fill_1
X_4077_ _1224_ _1226_ _1231_ VGND VGND VPWR VPWR _1232_ sky130_fd_sc_hd__o21ai_1
XANTENNA__4074__A _1145_ VGND VGND VPWR VPWR sky130_fd_sc_hd__diode_2
XFILLER_0_38_408 VGND VGND VPWR VPWR sky130_fd_sc_hd__decap_3
XFILLER_0_38_419 VGND VGND VPWR VPWR sky130_fd_sc_hd__fill_1
XFILLER_0_108_307 VGND VGND VPWR VPWR sky130_fd_sc_hd__fill_1
XFILLER_0_46_452 VGND VGND VPWR VPWR sky130_fd_sc_hd__fill_2
XFILLER_0_19_644 VGND VGND VPWR VPWR sky130_fd_sc_hd__fill_2
X_4979_ u_pe_array.u_fifo2.buffer\[3\]\[0\] _1969_ _1970_ u_pe_array.u_fifo2.buffer\[2\]\[0\]
+ _1974_ VGND VGND VPWR VPWR _1975_ sky130_fd_sc_hd__a221o_1
X_6718_ net319 _3134_ net66 VGND VGND VPWR VPWR _3337_ sky130_fd_sc_hd__mux2_1
XFILLER_0_73_260 VGND VGND VPWR VPWR sky130_fd_sc_hd__fill_2
XFILLER_0_18_165 VGND VGND VPWR VPWR sky130_fd_sc_hd__fill_2
XFILLER_0_73_293 VGND VGND VPWR VPWR sky130_fd_sc_hd__decap_3
XFILLER_0_61_444 VGND VGND VPWR VPWR sky130_fd_sc_hd__fill_2
XFILLER_0_46_496 VGND VGND VPWR VPWR sky130_fd_sc_hd__fill_2
X_6649_ net636 _0833_ VGND VGND VPWR VPWR _3294_ sky130_fd_sc_hd__and2_1
XFILLER_0_33_113 VGND VGND VPWR VPWR sky130_fd_sc_hd__fill_1
XFILLER_0_33_146 VGND VGND VPWR VPWR sky130_fd_sc_hd__fill_1
XFILLER_0_104_557 VGND VGND VPWR VPWR sky130_fd_sc_hd__decap_8
XFILLER_0_14_360 VGND VGND VPWR VPWR sky130_fd_sc_hd__fill_2
XANTENNA__4113__A2 _1138_ VGND VGND VPWR VPWR sky130_fd_sc_hd__diode_2
XANTENNA__7371__RESET_B net812 VGND VGND VPWR VPWR sky130_fd_sc_hd__diode_2
XANTENNA__7300__RESET_B net814 VGND VGND VPWR VPWR sky130_fd_sc_hd__diode_2
XFILLER_0_84_514 VGND VGND VPWR VPWR sky130_fd_sc_hd__fill_2
XTAP_1231 VGND VPWR sky130_fd_sc_hd__tapvpwrvgnd_1
XTAP_1220 VGND VPWR sky130_fd_sc_hd__tapvpwrvgnd_1
XANTENNA__3624__B2 u_fsm.psum_shift_en VGND VGND VPWR VPWR sky130_fd_sc_hd__diode_2
XTAP_1264 VGND VPWR sky130_fd_sc_hd__tapvpwrvgnd_1
XTAP_1275 VGND VPWR sky130_fd_sc_hd__tapvpwrvgnd_1
XTAP_1253 VGND VPWR sky130_fd_sc_hd__tapvpwrvgnd_1
XTAP_1242 VGND VPWR sky130_fd_sc_hd__tapvpwrvgnd_1
XFILLER_0_56_216 VGND VGND VPWR VPWR sky130_fd_sc_hd__fill_2
XTAP_1297 VGND VPWR sky130_fd_sc_hd__tapvpwrvgnd_1
XTAP_1286 VGND VPWR sky130_fd_sc_hd__tapvpwrvgnd_1
XFILLER_0_112_27 VGND VGND VPWR VPWR sky130_fd_sc_hd__fill_1
XFILLER_0_108_7 VPWR VGND VPWR VGND sky130_ef_sc_hd__decap_12
XANTENNA__6629__A1 net8 VGND VGND VPWR VPWR sky130_fd_sc_hd__diode_2
X_4000_ net643 _1152_ _0887_ _1161_ VGND VGND VPWR VPWR _0082_ sky130_fd_sc_hd__a22o_1
XANTENNA__7041__RESET_B net817 VGND VGND VPWR VPWR sky130_fd_sc_hd__diode_2
XANTENNA__5604__A2 _2478_ VGND VGND VPWR VPWR sky130_fd_sc_hd__diode_2
X_5951_ u_pe_array.g_pe_row\[0\].g_pe_col\[2\].u_pe.psum_out\[5\] _2788_ VGND VGND
+ VPWR VPWR _2789_ sky130_fd_sc_hd__xnor2_1
XANTENNA__3615__A1 _0844_ VGND VGND VPWR VPWR sky130_fd_sc_hd__diode_2
X_4902_ _1887_ _1896_ VGND VGND VPWR VPWR _1907_ sky130_fd_sc_hd__and2_1
XFILLER_0_75_503 VGND VGND VPWR VPWR sky130_fd_sc_hd__fill_1
XFILLER_0_1_57 VPWR VGND VPWR VGND sky130_ef_sc_hd__decap_12
X_5882_ u_pe_array.g_pe_row\[1\].g_pe_col\[1\].u_pe.psum_out\[6\] u_pe_array.g_pe_row\[1\].g_pe_col\[1\].u_pe.move_reg\[6\]
+ _2469_ VGND VGND VPWR VPWR _2732_ sky130_fd_sc_hd__mux2_1
XFILLER_0_62_65 VPWR VGND VPWR VGND sky130_ef_sc_hd__decap_12
X_4833_ u_pe_array.g_pe_row\[2\].g_pe_col\[0\].u_pe.act_val\[0\] u_pe_array.g_pe_row\[2\].g_pe_col\[0\].u_pe.psum_out\[0\]
+ u_pe_array.g_pe_row\[2\].g_pe_col\[0\].u_pe.w_reg\[0\] VGND VGND VPWR VPWR _1844_
+ sky130_fd_sc_hd__and3_1
X_7621_ clknet_leaf_22_clk _0670_ VGND VGND VPWR VPWR u_pe_array.u_fifo1.buffer\[4\]\[5\]
+ sky130_fd_sc_hd__dfxtp_1
XFILLER_0_7_313 VGND VGND VPWR VPWR sky130_fd_sc_hd__fill_1
X_7552_ clknet_leaf_17_clk _0601_ net816 VGND VGND VPWR VPWR u_pe_array.u_fifo1.wr_ptr\[0\]
+ sky130_fd_sc_hd__dfrtp_1
XFILLER_0_28_485 VGND VGND VPWR VPWR sky130_fd_sc_hd__fill_2
X_4764_ _1800_ net541 _1796_ VGND VGND VPWR VPWR _1801_ sky130_fd_sc_hd__mux2_1
XANTENNA__6317__B1 _2174_ VGND VGND VPWR VPWR sky130_fd_sc_hd__diode_2
XANTENNA__4591__A2 _1524_ VGND VGND VPWR VPWR sky130_fd_sc_hd__diode_2
X_6503_ _3216_ VGND VGND VPWR VPWR _0530_ sky130_fd_sc_hd__clkbuf_1
XFILLER_0_7_379 VGND VGND VPWR VPWR sky130_fd_sc_hd__fill_2
XFILLER_0_15_113 VGND VGND VPWR VPWR sky130_fd_sc_hd__fill_1
X_7483_ clknet_leaf_0_clk _0532_ VGND VGND VPWR VPWR u_pe_array.u_fifo2.buffer\[3\]\[9\]
+ sky130_fd_sc_hd__dfxtp_1
X_3715_ _0927_ _0869_ u_pe_array.g_pe_row\[3\].g_pe_col\[3\].u_pe.psum_out\[6\] VGND
+ VGND VPWR VPWR _0929_ sky130_fd_sc_hd__a21oi_1
X_4695_ _1672_ u_pe_array.g_pe_row\[2\].g_pe_col\[1\].u_pe.psum_out\[7\] VGND VGND
+ VPWR VPWR _1740_ sky130_fd_sc_hd__xor2_1
XFILLER_0_31_617 VGND VGND VPWR VPWR sky130_fd_sc_hd__fill_2
X_6434_ net486 _1788_ net69 VGND VGND VPWR VPWR _3181_ sky130_fd_sc_hd__mux2_1
XFILLER_0_101_505 VGND VGND VPWR VPWR sky130_fd_sc_hd__fill_2
X_3646_ _0865_ VGND VGND VPWR VPWR _0866_ sky130_fd_sc_hd__buf_8
XFILLER_0_43_499 VGND VGND VPWR VPWR sky130_fd_sc_hd__fill_2
XFILLER_0_3_541 VPWR VGND VPWR VGND sky130_ef_sc_hd__decap_12
XFILLER_0_30_116 VGND VGND VPWR VPWR sky130_fd_sc_hd__fill_2
X_6365_ _1792_ _3136_ VGND VGND VPWR VPWR _3137_ sky130_fd_sc_hd__or2_1
X_3577_ net216 _0814_ _0816_ VGND VGND VPWR VPWR _0004_ sky130_fd_sc_hd__o21ba_1
XFILLER_0_3_585 VPWR VGND VPWR VGND sky130_ef_sc_hd__decap_12
XFILLER_0_30_149 VGND VGND VPWR VPWR sky130_fd_sc_hd__fill_2
X_6296_ _2740_ _3083_ _3084_ _0866_ net679 VGND VGND VPWR VPWR _0455_ sky130_fd_sc_hd__a32o_1
X_5316_ _2158_ u_pe_array.g_pe_row\[1\].g_pe_col\[2\].u_pe.psum_out\[11\] VGND VGND
+ VPWR VPWR _2260_ sky130_fd_sc_hd__and2b_1
XANTENNA__6268__B _2992_ VGND VGND VPWR VPWR sky130_fd_sc_hd__diode_2
XANTENNA__7129__RESET_B net816 VGND VGND VPWR VPWR sky130_fd_sc_hd__diode_2
X_5247_ _2196_ _2197_ VGND VGND VPWR VPWR _2198_ sky130_fd_sc_hd__or2_1
Xhold26 u_pe_array.g_pe_row\[0\].g_pe_col\[0\].u_pe.w_buffer\[1\] VGND VGND VPWR VPWR
+ net102 sky130_fd_sc_hd__dlygate4sd3_1
Xhold37 _0313_ VGND VGND VPWR VPWR net113 sky130_fd_sc_hd__dlygate4sd3_1
Xhold15 u_pe_array.g_pe_row\[1\].g_pe_col\[2\].u_pe.w_buffer\[1\] VGND VGND VPWR VPWR
+ net91 sky130_fd_sc_hd__dlygate4sd3_1
X_5178_ _0763_ _1830_ _0747_ VGND VGND VPWR VPWR _2143_ sky130_fd_sc_hd__mux2_1
Xhold48 _0260_ VGND VGND VPWR VPWR net124 sky130_fd_sc_hd__dlygate4sd3_1
Xhold59 u_pe_array.g_pe_row\[3\].g_pe_col\[1\].u_pe.move_reg\[6\] VGND VGND VPWR VPWR
+ net135 sky130_fd_sc_hd__dlygate4sd3_1
X_4129_ net195 _1138_ _1267_ _1004_ VGND VGND VPWR VPWR _0105_ sky130_fd_sc_hd__a22o_1
XFILLER_0_97_127 VGND VGND VPWR VPWR sky130_fd_sc_hd__fill_2
XFILLER_0_93_322 VGND VGND VPWR VPWR sky130_fd_sc_hd__fill_2
XFILLER_0_78_396 VGND VGND VPWR VPWR sky130_fd_sc_hd__fill_1
XFILLER_0_38_216 VPWR VGND VPWR VGND sky130_ef_sc_hd__decap_12
XFILLER_0_34_400 VGND VGND VPWR VPWR sky130_fd_sc_hd__fill_2
XFILLER_0_34_411 VGND VGND VPWR VPWR sky130_fd_sc_hd__fill_2
XFILLER_0_34_444 VGND VGND VPWR VPWR sky130_fd_sc_hd__decap_8
XFILLER_0_61_285 VGND VGND VPWR VPWR sky130_fd_sc_hd__decap_3
XFILLER_0_21_116 VGND VGND VPWR VPWR sky130_fd_sc_hd__fill_2
XFILLER_0_104_365 VGND VGND VPWR VPWR sky130_fd_sc_hd__decap_4
XANTENNA__5531__A1 _0914_ VGND VGND VPWR VPWR sky130_fd_sc_hd__diode_2
XANTENNA__7552__RESET_B net816 VGND VGND VPWR VPWR sky130_fd_sc_hd__diode_2
XANTENNA__3542__B1 _0788_ VGND VGND VPWR VPWR sky130_fd_sc_hd__diode_2
XFILLER_0_107_27 VPWR VGND VPWR VGND sky130_ef_sc_hd__decap_12
XFILLER_0_89_617 VGND VGND VPWR VPWR sky130_fd_sc_hd__fill_2
XANTENNA__4707__A _1672_ VGND VGND VPWR VPWR sky130_fd_sc_hd__diode_2
XTAP_1083 VGND VPWR sky130_fd_sc_hd__tapvpwrvgnd_1
XTAP_1072 VGND VPWR sky130_fd_sc_hd__tapvpwrvgnd_1
XTAP_1061 VGND VPWR sky130_fd_sc_hd__tapvpwrvgnd_1
XTAP_1050 VGND VPWR sky130_fd_sc_hd__tapvpwrvgnd_1
XANTENNA__6641__B _0833_ VGND VGND VPWR VPWR sky130_fd_sc_hd__diode_2
XTAP_1094 VGND VPWR sky130_fd_sc_hd__tapvpwrvgnd_1
XFILLER_0_25_400 VGND VGND VPWR VPWR sky130_fd_sc_hd__fill_2
XFILLER_0_37_260 VGND VGND VPWR VPWR sky130_fd_sc_hd__decap_8
XFILLER_0_65_591 VGND VGND VPWR VPWR sky130_fd_sc_hd__fill_2
XFILLER_0_114_118 VGND VGND VPWR VPWR sky130_fd_sc_hd__fill_2
X_3500_ _0760_ VGND VGND VPWR VPWR net40 sky130_fd_sc_hd__clkbuf_1
Xhold518 u_pe_array.g_pe_row\[1\].g_pe_col\[0\].u_pe.act_val\[1\] VGND VGND VPWR VPWR
+ net594 sky130_fd_sc_hd__dlygate4sd3_1
Xhold507 u_pe_array.u_fifo1.buffer\[7\]\[5\] VGND VGND VPWR VPWR net583 sky130_fd_sc_hd__dlygate4sd3_1
XFILLER_0_12_127 VGND VGND VPWR VPWR sky130_fd_sc_hd__fill_2
X_4480_ _1556_ VGND VGND VPWR VPWR _1557_ sky130_fd_sc_hd__inv_2
XFILLER_0_40_425 VGND VGND VPWR VPWR sky130_fd_sc_hd__fill_1
XANTENNA__4588__S _0769_ VGND VGND VPWR VPWR sky130_fd_sc_hd__diode_2
Xhold529 u_pe_array.g_pe_row\[0\].g_pe_col\[3\].u_pe.act_val\[5\] VGND VGND VPWR VPWR
+ net605 sky130_fd_sc_hd__dlygate4sd3_1
X_6150_ _2954_ _2956_ net730 _0875_ VGND VGND VPWR VPWR _0437_ sky130_fd_sc_hd__a2bb2o_1
XANTENNA__7293__RESET_B net75 VGND VGND VPWR VPWR sky130_fd_sc_hd__diode_2
XTAP_801 VGND VPWR sky130_fd_sc_hd__tapvpwrvgnd_1
XANTENNA__7222__RESET_B net812 VGND VGND VPWR VPWR sky130_fd_sc_hd__diode_2
XTAP_834 VGND VPWR sky130_fd_sc_hd__tapvpwrvgnd_1
XTAP_823 VGND VPWR sky130_fd_sc_hd__tapvpwrvgnd_1
XTAP_812 VGND VPWR sky130_fd_sc_hd__tapvpwrvgnd_1
X_5101_ _2063_ _2065_ VGND VGND VPWR VPWR _2079_ sky130_fd_sc_hd__nand2_1
X_6081_ u_pe_array.g_pe_row\[0\].g_pe_col\[1\].u_pe.act_val\[2\] u_pe_array.g_pe_row\[0\].g_pe_col\[1\].u_pe.act_val\[3\]
+ u_pe_array.g_pe_row\[0\].g_pe_col\[1\].u_pe.w_reg\[0\] _2873_ VGND VGND VPWR VPWR
+ _2893_ sky130_fd_sc_hd__and4b_1
XFILLER_0_57_65 VGND VGND VPWR VPWR sky130_fd_sc_hd__fill_2
XTAP_867 VGND VPWR sky130_fd_sc_hd__tapvpwrvgnd_1
XTAP_856 VGND VPWR sky130_fd_sc_hd__tapvpwrvgnd_1
XANTENNA__4089__B2 _0916_ VGND VGND VPWR VPWR sky130_fd_sc_hd__diode_2
XTAP_845 VGND VPWR sky130_fd_sc_hd__tapvpwrvgnd_1
XTAP_889 VGND VPWR sky130_fd_sc_hd__tapvpwrvgnd_1
XTAP_878 VGND VPWR sky130_fd_sc_hd__tapvpwrvgnd_1
X_5032_ u_pe_array.g_pe_row\[0\].g_pe_col\[2\].u_pe.psum_out\[7\] u_pe_array.g_pe_row\[0\].g_pe_col\[2\].u_pe.move_reg\[7\]
+ _1661_ VGND VGND VPWR VPWR _2021_ sky130_fd_sc_hd__mux2_1
XFILLER_0_88_672 VGND VGND VPWR VPWR sky130_fd_sc_hd__fill_2
X_6983_ clknet_leaf_84_clk _0062_ net74 VGND VGND VPWR VPWR u_pe_array.g_pe_row\[3\].g_pe_col\[2\].u_pe.psum_out\[10\]
+ sky130_fd_sc_hd__dfrtp_2
X_5934_ _2740_ _2772_ _2773_ _2571_ net377 VGND VGND VPWR VPWR _0404_ sky130_fd_sc_hd__a32o_1
XFILLER_0_87_193 VGND VGND VPWR VPWR sky130_fd_sc_hd__fill_2
X_5865_ net406 _2387_ _2174_ _2723_ VGND VGND VPWR VPWR _0385_ sky130_fd_sc_hd__a22o_1
X_7604_ clknet_leaf_22_clk _0653_ VGND VGND VPWR VPWR u_pe_array.u_fifo1.buffer\[3\]\[1\]
+ sky130_fd_sc_hd__dfxtp_1
X_4816_ _1834_ net6 _0754_ VGND VGND VPWR VPWR _1835_ sky130_fd_sc_hd__mux2_1
XFILLER_0_113_81 VPWR VGND VPWR VGND sky130_ef_sc_hd__decap_12
XANTENNA__5210__B1 _2071_ VGND VGND VPWR VPWR sky130_fd_sc_hd__diode_2
XFILLER_0_16_433 VPWR VGND VPWR VGND sky130_ef_sc_hd__decap_12
XFILLER_0_28_271 VGND VGND VPWR VPWR sky130_fd_sc_hd__decap_4
X_5796_ _2648_ _2651_ _2660_ _0885_ VGND VGND VPWR VPWR _2662_ sky130_fd_sc_hd__o31a_1
XANTENNA__5882__S _2469_ VGND VGND VPWR VPWR sky130_fd_sc_hd__diode_2
X_4747_ net434 _1714_ _0887_ _1786_ VGND VGND VPWR VPWR _0204_ sky130_fd_sc_hd__a22o_1
X_7535_ clknet_leaf_0_clk _0584_ VGND VGND VPWR VPWR u_pe_array.u_fifo2.buffer\[7\]\[9\]
+ sky130_fd_sc_hd__dfxtp_1
XFILLER_0_16_477 VGND VGND VPWR VPWR sky130_fd_sc_hd__fill_2
XFILLER_0_114_641 VGND VGND VPWR VPWR sky130_fd_sc_hd__decap_3
X_4678_ net732 _1714_ _1723_ _1724_ VGND VGND VPWR VPWR _0197_ sky130_fd_sc_hd__a22o_1
XFILLER_0_16_499 VGND VGND VPWR VPWR sky130_fd_sc_hd__fill_1
XANTENNA__3772__B1 _0869_ VGND VGND VPWR VPWR sky130_fd_sc_hd__diode_2
X_7466_ clknet_leaf_4_clk _0515_ VGND VGND VPWR VPWR u_pe_array.u_fifo2.buffer\[2\]\[5\]
+ sky130_fd_sc_hd__dfxtp_1
XFILLER_0_98_94 VGND VGND VPWR VPWR sky130_fd_sc_hd__fill_2
X_7397_ clknet_leaf_41_clk _0447_ net817 VGND VGND VPWR VPWR u_pe_array.g_pe_row\[0\].g_pe_col\[0\].u_pe.psum_out\[1\]
+ sky130_fd_sc_hd__dfrtp_1
X_3629_ u_pe_array.g_pe_row\[2\].g_pe_col\[2\].u_pe.psum_out\[9\] u_pe_array.g_pe_row\[2\].g_pe_col\[2\].u_pe.move_reg\[9\]
+ _0734_ VGND VGND VPWR VPWR _0853_ sky130_fd_sc_hd__mux2_1
X_6417_ net415 _1806_ _3166_ VGND VGND VPWR VPWR _3172_ sky130_fd_sc_hd__mux2_1
X_6348_ _3125_ VGND VGND VPWR VPWR _0466_ sky130_fd_sc_hd__clkbuf_1
Xoutput49 net49 VGND VGND VPWR VPWR psum_out1[0] sky130_fd_sc_hd__clkbuf_4
Xoutput38 net38 VGND VGND VPWR VPWR psum_out0[11] sky130_fd_sc_hd__clkbuf_4
XFILLER_0_101_379 VGND VGND VPWR VPWR sky130_fd_sc_hd__fill_2
X_6279_ _3041_ _3053_ _3063_ _3068_ VGND VGND VPWR VPWR _3069_ sky130_fd_sc_hd__or4_1
XANTENNA__5029__B1 _0833_ VGND VGND VPWR VPWR sky130_fd_sc_hd__diode_2
XANTENNA__6945__RESET_B net815 VGND VGND VPWR VPWR sky130_fd_sc_hd__diode_2
XFILLER_0_94_620 VGND VGND VPWR VPWR sky130_fd_sc_hd__fill_1
XPHY_100 VGND VGND VPWR VPWR sky130_fd_sc_hd__decap_3
XFILLER_0_39_536 VGND VGND VPWR VPWR sky130_fd_sc_hd__fill_2
XPHY_133 VGND VGND VPWR VPWR sky130_fd_sc_hd__decap_3
XPHY_122 VGND VGND VPWR VPWR sky130_fd_sc_hd__decap_3
XPHY_111 VGND VGND VPWR VPWR sky130_fd_sc_hd__decap_3
XFILLER_0_93_163 VGND VGND VPWR VPWR sky130_fd_sc_hd__fill_2
XANTENNA_clkbuf_leaf_40_clk_A clknet_3_6__leaf_clk VGND VGND VPWR VPWR sky130_fd_sc_hd__diode_2
XPHY_166 VGND VGND VPWR VPWR sky130_fd_sc_hd__decap_3
XFILLER_0_81_314 VGND VGND VPWR VPWR sky130_fd_sc_hd__decap_3
XPHY_155 VGND VGND VPWR VPWR sky130_fd_sc_hd__decap_3
XPHY_144 VGND VGND VPWR VPWR sky130_fd_sc_hd__decap_3
XPHY_199 VGND VGND VPWR VPWR sky130_fd_sc_hd__decap_3
XPHY_188 VGND VGND VPWR VPWR sky130_fd_sc_hd__decap_3
XPHY_177 VGND VGND VPWR VPWR sky130_fd_sc_hd__decap_3
XANTENNA__6888__S _3427_ VGND VGND VPWR VPWR sky130_fd_sc_hd__diode_2
XFILLER_0_105_641 VPWR VGND VPWR VGND sky130_ef_sc_hd__decap_12
XFILLER_0_62_594 VGND VGND VPWR VPWR sky130_fd_sc_hd__decap_3
XFILLER_0_22_425 VGND VGND VPWR VPWR sky130_fd_sc_hd__fill_1
XANTENNA__3763__B1 _0885_ VGND VGND VPWR VPWR sky130_fd_sc_hd__diode_2
XFILLER_0_104_151 VGND VGND VPWR VPWR sky130_fd_sc_hd__fill_1
XFILLER_0_89_436 VGND VGND VPWR VPWR sky130_fd_sc_hd__fill_2
XANTENNA__5032__S _1661_ VGND VGND VPWR VPWR sky130_fd_sc_hd__diode_2
XFILLER_0_27_79 VGND VGND VPWR VPWR sky130_fd_sc_hd__decap_3
XFILLER_0_89_458 VGND VGND VPWR VPWR sky130_fd_sc_hd__decap_3
XFILLER_0_43_23 VGND VGND VPWR VPWR sky130_fd_sc_hd__decap_6
X_3980_ _0865_ VGND VGND VPWR VPWR _1144_ sky130_fd_sc_hd__buf_8
XFILLER_0_9_408 VGND VGND VPWR VPWR sky130_fd_sc_hd__fill_2
XPHY_2 VGND VGND VPWR VPWR sky130_fd_sc_hd__decap_3
X_5650_ _2539_ VGND VGND VPWR VPWR _2542_ sky130_fd_sc_hd__inv_2
XFILLER_0_57_388 VGND VGND VPWR VPWR sky130_fd_sc_hd__fill_1
Xclkbuf_0_clk clk VGND VGND VPWR VPWR clknet_0_clk sky130_fd_sc_hd__clkbuf_16
XFILLER_0_45_517 VGND VGND VPWR VPWR sky130_fd_sc_hd__fill_2
X_4601_ u_pe_array.g_pe_row\[2\].g_pe_col\[1\].u_pe.psum_out\[7\] net153 _0855_ VGND
+ VGND VPWR VPWR _1659_ sky130_fd_sc_hd__mux2_1
X_5581_ u_pe_array.g_pe_row\[1\].g_pe_col\[0\].u_pe.act_val\[0\] _2478_ u_pe_array.g_pe_row\[1\].g_pe_col\[0\].u_pe.psum_out\[1\]
+ VGND VGND VPWR VPWR _2479_ sky130_fd_sc_hd__a21oi_1
XFILLER_0_53_561 VGND VGND VPWR VPWR sky130_fd_sc_hd__decap_8
XFILLER_0_53_550 VGND VGND VPWR VPWR sky130_fd_sc_hd__fill_1
X_4532_ _1595_ _1600_ _1603_ VGND VGND VPWR VPWR _1605_ sky130_fd_sc_hd__or3_1
XFILLER_0_25_263 VGND VGND VPWR VPWR sky130_fd_sc_hd__fill_1
X_7320_ clknet_leaf_63_clk _0377_ net814 VGND VGND VPWR VPWR u_pe_array.g_pe_row\[0\].g_pe_col\[3\].u_pe.psum_out\[4\]
+ sky130_fd_sc_hd__dfrtp_1
XFILLER_0_40_211 VGND VGND VPWR VPWR sky130_fd_sc_hd__fill_2
XANTENNA__7403__RESET_B net817 VGND VGND VPWR VPWR sky130_fd_sc_hd__diode_2
Xhold304 u_pe_array.g_pe_row\[3\].g_pe_col\[0\].u_pe.psum_out\[11\] VGND VGND VPWR
+ VPWR net380 sky130_fd_sc_hd__dlygate4sd3_1
X_7251_ clknet_leaf_39_clk net192 net813 VGND VGND VPWR VPWR u_pe_array.g_pe_row\[1\].g_pe_col\[0\].u_pe.move_reg\[10\]
+ sky130_fd_sc_hd__dfrtp_1
Xhold326 u_pe_array.u_fifo2.rd_ptr\[2\] VGND VGND VPWR VPWR net402 sky130_fd_sc_hd__dlygate4sd3_1
X_4463_ _1273_ _1540_ _1541_ _1534_ net560 VGND VGND VPWR VPWR _0165_ sky130_fd_sc_hd__a32o_1
Xhold315 u_pe_array.g_pe_row\[3\].g_pe_col\[3\].u_pe.psum_out\[6\] VGND VGND VPWR
+ VPWR net391 sky130_fd_sc_hd__dlygate4sd3_1
X_6202_ _2740_ _2997_ _2998_ _0866_ net575 VGND VGND VPWR VPWR _0447_ sky130_fd_sc_hd__a32o_1
Xhold359 u_pe_array.g_pe_row\[1\].g_pe_col\[1\].u_pe.psum_out\[12\] VGND VGND VPWR
+ VPWR net435 sky130_fd_sc_hd__dlygate4sd3_1
XFILLER_0_68_53 VGND VGND VPWR VPWR sky130_fd_sc_hd__decap_4
XFILLER_0_7_78 VGND VGND VPWR VPWR sky130_fd_sc_hd__fill_1
Xhold348 u_pe_array.g_pe_row\[3\].g_pe_col\[3\].u_pe.psum_out\[11\] VGND VGND VPWR
+ VPWR net424 sky130_fd_sc_hd__dlygate4sd3_1
Xhold337 u_pe_array.g_pe_row\[2\].g_pe_col\[2\].u_pe.move_reg\[12\] VGND VGND VPWR
+ VPWR net413 sky130_fd_sc_hd__dlygate4sd3_1
X_7182_ clknet_leaf_62_clk _0249_ net73 VGND VGND VPWR VPWR u_pe_array.g_pe_row\[1\].g_pe_col\[2\].u_pe.act_val\[1\]
+ sky130_fd_sc_hd__dfrtp_1
X_4394_ _1485_ _1487_ _1492_ VGND VGND VPWR VPWR _1493_ sky130_fd_sc_hd__o21ai_1
XFILLER_0_110_187 VGND VGND VPWR VPWR sky130_fd_sc_hd__fill_1
X_6133_ _2932_ _2937_ _2940_ VGND VGND VPWR VPWR _2941_ sky130_fd_sc_hd__o21ai_1
XTAP_620 VGND VPWR sky130_fd_sc_hd__tapvpwrvgnd_1
XTAP_631 VGND VPWR sky130_fd_sc_hd__tapvpwrvgnd_1
XTAP_642 VGND VPWR sky130_fd_sc_hd__tapvpwrvgnd_1
X_6064_ u_pe_array.g_pe_row\[0\].g_pe_col\[1\].u_pe.psum_out\[1\] _2876_ VGND VGND
+ VPWR VPWR _2878_ sky130_fd_sc_hd__nand2_1
XTAP_653 VGND VPWR sky130_fd_sc_hd__tapvpwrvgnd_1
XTAP_664 VGND VPWR sky130_fd_sc_hd__tapvpwrvgnd_1
XTAP_675 VGND VPWR sky130_fd_sc_hd__tapvpwrvgnd_1
XTAP_686 VGND VPWR sky130_fd_sc_hd__tapvpwrvgnd_1
XANTENNA__6038__S _0756_ VGND VGND VPWR VPWR sky130_fd_sc_hd__diode_2
X_5015_ u_pe_array.u_fifo2.buffer\[3\]\[4\] _1969_ _1970_ u_pe_array.u_fifo2.buffer\[2\]\[4\]
+ _2006_ VGND VGND VPWR VPWR _2007_ sky130_fd_sc_hd__a221o_1
XTAP_697 VGND VPWR sky130_fd_sc_hd__tapvpwrvgnd_1
X_6966_ clknet_leaf_12_clk _0047_ net818 VGND VGND VPWR VPWR u_pe_array.g_pe_row\[3\].g_pe_col\[1\].u_pe.move_reg\[8\]
+ sky130_fd_sc_hd__dfrtp_1
XFILLER_0_76_642 VGND VGND VPWR VPWR sky130_fd_sc_hd__fill_2
XFILLER_0_76_631 VGND VGND VPWR VPWR sky130_fd_sc_hd__decap_3
X_5917_ _2756_ _2757_ VGND VGND VPWR VPWR _2758_ sky130_fd_sc_hd__xor2_1
XANTENNA__6281__B _2992_ VGND VGND VPWR VPWR sky130_fd_sc_hd__diode_2
X_6897_ _3432_ VGND VGND VPWR VPWR _0708_ sky130_fd_sc_hd__clkbuf_1
XANTENNA__4082__A _1145_ VGND VGND VPWR VPWR sky130_fd_sc_hd__diode_2
X_5848_ _2611_ u_pe_array.g_pe_row\[0\].g_pe_col\[3\].u_pe.psum_out\[9\] _2708_ VGND
+ VGND VPWR VPWR _2709_ sky130_fd_sc_hd__and3_1
XFILLER_0_90_133 VGND VGND VPWR VPWR sky130_fd_sc_hd__fill_2
XFILLER_0_16_241 VGND VGND VPWR VPWR sky130_fd_sc_hd__decap_6
X_5779_ _2643_ _2644_ u_pe_array.g_pe_row\[0\].g_pe_col\[3\].u_pe.psum_out\[4\] VGND
+ VGND VPWR VPWR _2646_ sky130_fd_sc_hd__a21o_1
XFILLER_0_106_449 VGND VGND VPWR VPWR sky130_fd_sc_hd__decap_3
XFILLER_0_44_561 VGND VGND VPWR VPWR sky130_fd_sc_hd__fill_1
XFILLER_0_31_200 VGND VGND VPWR VPWR sky130_fd_sc_hd__fill_2
X_7518_ clknet_leaf_3_clk _0567_ VGND VGND VPWR VPWR u_pe_array.u_fifo2.buffer\[6\]\[5\]
+ sky130_fd_sc_hd__dfxtp_1
X_7449_ clknet_leaf_1_clk _0498_ VGND VGND VPWR VPWR u_pe_array.u_fifo2.buffer\[1\]\[1\]
+ sky130_fd_sc_hd__dfxtp_1
XFILLER_0_31_299 VGND VGND VPWR VPWR sky130_fd_sc_hd__fill_2
XFILLER_0_101_198 VGND VGND VPWR VPWR sky130_fd_sc_hd__fill_1
XFILLER_0_98_299 VGND VGND VPWR VPWR sky130_fd_sc_hd__decap_3
XANTENNA__4225__A1 _1275_ VGND VGND VPWR VPWR sky130_fd_sc_hd__diode_2
XFILLER_0_58_119 VPWR VGND VPWR VGND sky130_ef_sc_hd__decap_12
XFILLER_0_39_300 VGND VGND VPWR VPWR sky130_fd_sc_hd__fill_1
XFILLER_0_109_221 VGND VGND VPWR VPWR sky130_fd_sc_hd__decap_3
XFILLER_0_109_210 VGND VGND VPWR VPWR sky130_fd_sc_hd__decap_4
XFILLER_0_82_601 VGND VGND VPWR VPWR sky130_fd_sc_hd__fill_2
XFILLER_0_66_141 VGND VGND VPWR VPWR sky130_fd_sc_hd__decap_6
XFILLER_0_94_494 VGND VGND VPWR VPWR sky130_fd_sc_hd__fill_1
XFILLER_0_82_645 VGND VGND VPWR VPWR sky130_fd_sc_hd__decap_4
XFILLER_0_82_656 VGND VGND VPWR VPWR sky130_fd_sc_hd__fill_2
XFILLER_0_81_133 VGND VGND VPWR VPWR sky130_fd_sc_hd__decap_8
XFILLER_0_54_358 VGND VGND VPWR VPWR sky130_fd_sc_hd__fill_1
XANTENNA__5725__B2 _2336_ VGND VGND VPWR VPWR sky130_fd_sc_hd__diode_2
XFILLER_0_35_561 VGND VGND VPWR VPWR sky130_fd_sc_hd__fill_2
XFILLER_0_35_583 VGND VGND VPWR VPWR sky130_fd_sc_hd__fill_2
XFILLER_0_50_520 VGND VGND VPWR VPWR sky130_fd_sc_hd__fill_2
XFILLER_0_1_105 VGND VGND VPWR VPWR sky130_fd_sc_hd__decap_6
XANTENNA__5027__S _0756_ VGND VGND VPWR VPWR sky130_fd_sc_hd__diode_2
XFILLER_0_1_127 VGND VGND VPWR VPWR sky130_fd_sc_hd__fill_2
XANTENNA__6150__B2 _0875_ VGND VGND VPWR VPWR sky130_fd_sc_hd__diode_2
XFILLER_0_10_439 VGND VGND VPWR VPWR sky130_fd_sc_hd__decap_8
XFILLER_0_38_56 VGND VGND VPWR VPWR sky130_fd_sc_hd__fill_1
X_6820_ net259 _3126_ _3382_ VGND VGND VPWR VPWR _3391_ sky130_fd_sc_hd__mux2_1
XANTENNA__4216__A1 _1273_ VGND VGND VPWR VPWR sky130_fd_sc_hd__diode_2
XFILLER_0_77_428 VGND VGND VPWR VPWR sky130_fd_sc_hd__fill_2
XFILLER_0_77_417 VGND VGND VPWR VPWR sky130_fd_sc_hd__fill_2
XANTENNA__4736__A_N _1672_ VGND VGND VPWR VPWR sky130_fd_sc_hd__diode_2
X_3963_ u_pe_array.g_pe_row\[2\].g_pe_col\[0\].u_pe.move_reg\[6\] u_pe_array.g_pe_row\[2\].g_pe_col\[0\].u_pe.psum_out\[6\]
+ _0755_ VGND VGND VPWR VPWR _1134_ sky130_fd_sc_hd__mux2_1
X_6751_ _3354_ VGND VGND VPWR VPWR _0640_ sky130_fd_sc_hd__clkbuf_1
X_5702_ _2587_ _2588_ VGND VGND VPWR VPWR _2589_ sky130_fd_sc_hd__xnor2_1
XFILLER_0_73_645 VGND VGND VPWR VPWR sky130_fd_sc_hd__decap_3
XFILLER_0_70_65 VGND VGND VPWR VPWR sky130_fd_sc_hd__fill_1
X_6682_ net673 _3313_ _3316_ VGND VGND VPWR VPWR _0609_ sky130_fd_sc_hd__o21a_1
XFILLER_0_45_314 VGND VGND VPWR VPWR sky130_fd_sc_hd__fill_1
X_3894_ _1078_ VGND VGND VPWR VPWR _1079_ sky130_fd_sc_hd__inv_2
XFILLER_0_70_98 VGND VGND VPWR VPWR sky130_fd_sc_hd__decap_6
X_5633_ _2511_ _2512_ _2525_ VGND VGND VPWR VPWR _2527_ sky130_fd_sc_hd__nor3_1
XANTENNA__3945__S _0755_ VGND VGND VPWR VPWR sky130_fd_sc_hd__diode_2
X_5564_ _0729_ VGND VGND VPWR VPWR _2469_ sky130_fd_sc_hd__clkbuf_16
XFILLER_0_60_328 VGND VGND VPWR VPWR sky130_fd_sc_hd__fill_1
XFILLER_0_13_200 VGND VGND VPWR VPWR sky130_fd_sc_hd__fill_1
XFILLER_0_79_63 VGND VGND VPWR VPWR sky130_fd_sc_hd__fill_1
XANTENNA__5192__A2 _2144_ VGND VGND VPWR VPWR sky130_fd_sc_hd__diode_2
Xhold101 _0285_ VGND VGND VPWR VPWR net177 sky130_fd_sc_hd__dlygate4sd3_1
X_4515_ u_pe_array.g_pe_row\[2\].g_pe_col\[2\].u_pe.psum_out\[5\] _1580_ _1588_ VGND
+ VGND VPWR VPWR _1589_ sky130_fd_sc_hd__a21o_1
X_7303_ clknet_leaf_62_clk _0362_ net814 VGND VGND VPWR VPWR u_pe_array.g_pe_row\[0\].g_pe_col\[2\].u_pe.act_val\[2\]
+ sky130_fd_sc_hd__dfrtp_2
Xhold123 u_pe_array.u_fifo1.buffer\[5\]\[9\] VGND VGND VPWR VPWR net199 sky130_fd_sc_hd__dlygate4sd3_1
X_5495_ _2405_ _2410_ _2413_ VGND VGND VPWR VPWR _2415_ sky130_fd_sc_hd__or3_1
Xhold134 u_pe_array.u_fifo1.rd_ptr\[3\] VGND VGND VPWR VPWR net210 sky130_fd_sc_hd__dlygate4sd3_1
Xhold112 _0131_ VGND VGND VPWR VPWR net188 sky130_fd_sc_hd__dlygate4sd3_1
Xhold156 u_pe_array.u_fifo1.buffer\[7\]\[12\] VGND VGND VPWR VPWR net232 sky130_fd_sc_hd__dlygate4sd3_1
XFILLER_0_110_93 VGND VGND VPWR VPWR sky130_fd_sc_hd__fill_2
X_4446_ net193 _1524_ _1528_ _1399_ VGND VGND VPWR VPWR _0161_ sky130_fd_sc_hd__a22o_1
X_7234_ clknet_leaf_64_clk _0297_ net73 VGND VGND VPWR VPWR u_pe_array.g_pe_row\[1\].g_pe_col\[2\].u_pe.psum_out\[8\]
+ sky130_fd_sc_hd__dfrtp_2
Xhold145 u_pe_array.u_fifo2.buffer\[7\]\[12\] VGND VGND VPWR VPWR net221 sky130_fd_sc_hd__dlygate4sd3_1
XFILLER_0_1_661 VGND VGND VPWR VPWR sky130_fd_sc_hd__decap_3
Xhold167 u_pe_array.u_fifo2.buffer\[6\]\[8\] VGND VGND VPWR VPWR net243 sky130_fd_sc_hd__dlygate4sd3_1
XFILLER_0_111_485 VPWR VGND VPWR VGND sky130_ef_sc_hd__decap_12
X_7165_ clknet_leaf_32_clk net93 net817 VGND VGND VPWR VPWR u_pe_array.g_pe_row\[2\].g_pe_col\[0\].u_pe.w_reg\[1\]
+ sky130_fd_sc_hd__dfrtp_1
Xhold189 u_pe_array.g_pe_row\[1\].g_pe_col\[2\].u_pe.move_reg\[9\] VGND VGND VPWR
+ VPWR net265 sky130_fd_sc_hd__dlygate4sd3_1
Xhold178 u_pe_array.u_fifo2.buffer\[7\]\[6\] VGND VGND VPWR VPWR net254 sky130_fd_sc_hd__dlygate4sd3_1
XANTENNA__4776__S _1796_ VGND VGND VPWR VPWR sky130_fd_sc_hd__diode_2
X_4377_ _1431_ _1444_ _1445_ _1476_ VGND VGND VPWR VPWR _1477_ sky130_fd_sc_hd__or4_1
X_6116_ u_pe_array.g_pe_row\[0\].g_pe_col\[1\].u_pe.w_reg\[0\] u_pe_array.g_pe_row\[0\].g_pe_col\[1\].u_pe.act_val\[5\]
+ _2915_ VGND VGND VPWR VPWR _2925_ sky130_fd_sc_hd__and3_1
XFILLER_0_0_193 VGND VGND VPWR VPWR sky130_fd_sc_hd__decap_3
XTAP_450 VGND VPWR sky130_fd_sc_hd__tapvpwrvgnd_1
X_7096_ clknet_leaf_91_clk _0167_ net819 VGND VGND VPWR VPWR u_pe_array.g_pe_row\[2\].g_pe_col\[2\].u_pe.psum_out\[3\]
+ sky130_fd_sc_hd__dfrtp_1
XTAP_461 VGND VPWR sky130_fd_sc_hd__tapvpwrvgnd_1
XTAP_483 VGND VPWR sky130_fd_sc_hd__tapvpwrvgnd_1
XTAP_472 VGND VPWR sky130_fd_sc_hd__tapvpwrvgnd_1
XTAP_494 VGND VPWR sky130_fd_sc_hd__tapvpwrvgnd_1
X_6047_ net416 _2738_ _2865_ _0722_ VGND VGND VPWR VPWR _0425_ sky130_fd_sc_hd__a22o_1
XANTENNA__4455__A1 _1273_ VGND VGND VPWR VPWR sky130_fd_sc_hd__diode_2
XTAP_1605 VGND VPWR sky130_fd_sc_hd__tapvpwrvgnd_1
XTAP_1627 VGND VPWR sky130_fd_sc_hd__tapvpwrvgnd_1
XTAP_1616 VGND VPWR sky130_fd_sc_hd__tapvpwrvgnd_1
XFILLER_0_95_258 VGND VGND VPWR VPWR sky130_fd_sc_hd__fill_1
X_6949_ clknet_leaf_78_clk _0030_ net815 VGND VGND VPWR VPWR u_pe_array.g_pe_row\[3\].g_pe_col\[3\].u_pe.psum_out\[6\]
+ sky130_fd_sc_hd__dfrtp_1
XANTENNA__7396__RESET_B net817 VGND VGND VPWR VPWR sky130_fd_sc_hd__diode_2
XFILLER_0_64_634 VGND VGND VPWR VPWR sky130_fd_sc_hd__decap_3
XFILLER_0_63_111 VGND VGND VPWR VPWR sky130_fd_sc_hd__fill_1
XFILLER_0_64_656 VGND VGND VPWR VPWR sky130_fd_sc_hd__fill_1
XFILLER_0_63_155 VGND VGND VPWR VPWR sky130_fd_sc_hd__fill_2
XFILLER_0_63_133 VGND VGND VPWR VPWR sky130_fd_sc_hd__fill_2
XANTENNA__7325__RESET_B net13 VGND VGND VPWR VPWR sky130_fd_sc_hd__diode_2
XFILLER_0_63_177 VGND VGND VPWR VPWR sky130_fd_sc_hd__fill_2
XFILLER_0_17_561 VPWR VGND VPWR VGND sky130_ef_sc_hd__decap_12
XANTENNA__4540__A _1536_ VGND VGND VPWR VPWR sky130_fd_sc_hd__diode_2
XFILLER_0_32_531 VGND VGND VPWR VPWR sky130_fd_sc_hd__fill_1
XFILLER_0_32_575 VGND VGND VPWR VPWR sky130_fd_sc_hd__decap_6
Xhold690 u_pe_array.g_pe_row\[1\].g_pe_col\[3\].u_pe.act_val\[1\] VGND VGND VPWR VPWR
+ net766 sky130_fd_sc_hd__dlygate4sd3_1
XANTENNA__4694__A1 _1725_ VGND VGND VPWR VPWR sky130_fd_sc_hd__diode_2
XANTENNA__6960__RESET_B net816 VGND VGND VPWR VPWR sky130_fd_sc_hd__diode_2
XFILLER_0_99_531 VGND VGND VPWR VPWR sky130_fd_sc_hd__fill_1
XANTENNA__4446__B2 _1399_ VGND VGND VPWR VPWR sky130_fd_sc_hd__diode_2
XFILLER_0_99_586 VGND VGND VPWR VPWR sky130_fd_sc_hd__decap_6
XANTENNA__4715__A _1672_ VGND VGND VPWR VPWR sky130_fd_sc_hd__diode_2
XFILLER_0_39_141 VGND VGND VPWR VPWR sky130_fd_sc_hd__fill_1
XFILLER_0_39_163 VGND VGND VPWR VPWR sky130_fd_sc_hd__decap_3
XANTENNA__7066__RESET_B net819 VGND VGND VPWR VPWR sky130_fd_sc_hd__diode_2
XFILLER_0_27_347 VGND VGND VPWR VPWR sky130_fd_sc_hd__fill_1
Xload_slew2 net75 VGND VGND VPWR VPWR net813 sky130_fd_sc_hd__buf_12
XFILLER_0_82_497 VGND VGND VPWR VPWR sky130_fd_sc_hd__fill_2
XFILLER_0_42_317 VGND VGND VPWR VPWR sky130_fd_sc_hd__fill_2
XFILLER_0_70_659 VGND VGND VPWR VPWR sky130_fd_sc_hd__decap_3
XFILLER_0_35_391 VGND VGND VPWR VPWR sky130_fd_sc_hd__fill_1
XFILLER_0_23_553 VGND VGND VPWR VPWR sky130_fd_sc_hd__fill_2
X_5280_ _2223_ _2221_ _2227_ VGND VGND VPWR VPWR _2228_ sky130_fd_sc_hd__o21ai_1
X_4300_ u_pe_array.g_pe_row\[2\].g_pe_col\[3\].u_pe.w_reg\[1\] VGND VGND VPWR VPWR
+ _1407_ sky130_fd_sc_hd__buf_6
XFILLER_0_2_469 VGND VGND VPWR VPWR sky130_fd_sc_hd__decap_6
X_4231_ _1356_ _1358_ net739 _0916_ VGND VGND VPWR VPWR _0116_ sky130_fd_sc_hd__a2bb2o_1
X_4162_ u_pe_array.g_pe_row\[3\].g_pe_col\[0\].u_pe.act_val\[2\] u_pe_array.g_pe_row\[3\].g_pe_col\[0\].u_pe.act_val\[3\]
+ u_pe_array.g_pe_row\[3\].g_pe_col\[0\].u_pe.w_reg\[0\] _1275_ VGND VGND VPWR VPWR
+ _1295_ sky130_fd_sc_hd__and4b_1
X_4093_ _1245_ _1236_ VGND VGND VPWR VPWR _1246_ sky130_fd_sc_hd__and2b_1
XANTENNA__4437__B2 _1399_ VGND VGND VPWR VPWR sky130_fd_sc_hd__diode_2
XFILLER_0_77_269 VGND VGND VPWR VPWR sky130_fd_sc_hd__decap_8
X_6803_ _3381_ VGND VGND VPWR VPWR _3382_ sky130_fd_sc_hd__buf_4
X_4995_ u_pe_array.u_fifo2.buffer\[4\]\[2\] _1965_ _1966_ u_pe_array.u_fifo2.buffer\[7\]\[2\]
+ VGND VGND VPWR VPWR _1989_ sky130_fd_sc_hd__a22o_1
X_6734_ _3345_ VGND VGND VPWR VPWR _0632_ sky130_fd_sc_hd__clkbuf_1
X_3946_ net15 _1122_ _0819_ VGND VGND VPWR VPWR _1123_ sky130_fd_sc_hd__mux2_1
XFILLER_0_46_623 VGND VGND VPWR VPWR sky130_fd_sc_hd__decap_4
XFILLER_0_45_111 VGND VGND VPWR VPWR sky130_fd_sc_hd__fill_1
XFILLER_0_18_325 VGND VGND VPWR VPWR sky130_fd_sc_hd__fill_2
XFILLER_0_73_453 VGND VGND VPWR VPWR sky130_fd_sc_hd__fill_2
XFILLER_0_46_656 VGND VGND VPWR VPWR sky130_fd_sc_hd__fill_1
XFILLER_0_45_122 VGND VGND VPWR VPWR sky130_fd_sc_hd__decap_4
XFILLER_0_90_3 VPWR VGND VPWR VGND sky130_ef_sc_hd__decap_12
XFILLER_0_73_497 VGND VGND VPWR VPWR sky130_fd_sc_hd__decap_6
X_6665_ net178 _3302_ _3108_ VGND VGND VPWR VPWR _3305_ sky130_fd_sc_hd__o21ai_1
XFILLER_0_61_626 VGND VGND VPWR VPWR sky130_fd_sc_hd__fill_2
X_3877_ u_pe_array.g_pe_row\[3\].g_pe_col\[2\].u_pe.act_val\[5\] VGND VGND VPWR VPWR
+ _1063_ sky130_fd_sc_hd__inv_2
X_5616_ _2509_ u_pe_array.g_pe_row\[1\].g_pe_col\[0\].u_pe.psum_out\[4\] _2478_ VGND
+ VGND VPWR VPWR _2511_ sky130_fd_sc_hd__and3_1
XFILLER_0_60_136 VGND VGND VPWR VPWR sky130_fd_sc_hd__decap_4
X_6596_ _3266_ VGND VGND VPWR VPWR _0573_ sky130_fd_sc_hd__clkbuf_1
XANTENNA__4360__A _1407_ VGND VGND VPWR VPWR sky130_fd_sc_hd__diode_2
X_5547_ u_pe_array.g_pe_row\[0\].g_pe_col\[0\].u_pe.w_buffer\[1\] u_pe_array.g_pe_row\[1\].g_pe_col\[0\].u_pe.w_buffer\[1\]
+ _0828_ VGND VGND VPWR VPWR _2460_ sky130_fd_sc_hd__mux2_1
XANTENNA__5890__S _2469_ VGND VGND VPWR VPWR sky130_fd_sc_hd__diode_2
XFILLER_0_5_274 VGND VGND VPWR VPWR sky130_fd_sc_hd__decap_6
XFILLER_0_14_564 VGND VGND VPWR VPWR sky130_fd_sc_hd__fill_2
X_5478_ u_pe_array.g_pe_row\[1\].g_pe_col\[1\].u_pe.psum_out\[5\] _2390_ _2398_ VGND
+ VGND VPWR VPWR _2399_ sky130_fd_sc_hd__a21o_1
X_4429_ net702 _1392_ _1258_ _1519_ VGND VGND VPWR VPWR _0153_ sky130_fd_sc_hd__a22o_1
X_7217_ clknet_leaf_53_clk net382 net812 VGND VGND VPWR VPWR u_pe_array.g_pe_row\[1\].g_pe_col\[1\].u_pe.move_reg\[6\]
+ sky130_fd_sc_hd__dfrtp_1
XFILLER_0_111_293 VPWR VGND VPWR VGND sky130_ef_sc_hd__decap_12
XANTENNA__3479__A2 _0745_ VGND VGND VPWR VPWR sky130_fd_sc_hd__diode_2
XANTENNA__5873__B1 _2592_ VGND VGND VPWR VPWR sky130_fd_sc_hd__diode_2
X_7148_ clknet_leaf_8_clk _0217_ VGND VGND VPWR VPWR u_pe_array.u_fifo2.buffer\[8\]\[12\]
+ sky130_fd_sc_hd__dfxtp_1
X_7079_ clknet_leaf_14_clk _0152_ net816 VGND VGND VPWR VPWR u_pe_array.g_pe_row\[2\].g_pe_col\[1\].u_pe.act_val\[1\]
+ sky130_fd_sc_hd__dfrtp_1
XTAP_291 VGND VPWR sky130_fd_sc_hd__tapvpwrvgnd_1
XTAP_280 VGND VPWR sky130_fd_sc_hd__tapvpwrvgnd_1
XANTENNA__7258__CLK clknet_3_7__leaf_clk VGND VGND VPWR VPWR sky130_fd_sc_hd__diode_2
XFILLER_0_96_523 VGND VGND VPWR VPWR sky130_fd_sc_hd__fill_1
XFILLER_0_96_512 VGND VGND VPWR VPWR sky130_fd_sc_hd__decap_3
XTAP_1424 VGND VPWR sky130_fd_sc_hd__tapvpwrvgnd_1
XTAP_1413 VGND VPWR sky130_fd_sc_hd__tapvpwrvgnd_1
XFILLER_0_96_556 VGND VGND VPWR VPWR sky130_fd_sc_hd__fill_2
XTAP_1402 VGND VPWR sky130_fd_sc_hd__tapvpwrvgnd_1
XTAP_1457 VGND VPWR sky130_fd_sc_hd__tapvpwrvgnd_1
XTAP_1435 VGND VPWR sky130_fd_sc_hd__tapvpwrvgnd_1
XTAP_1446 VGND VPWR sky130_fd_sc_hd__tapvpwrvgnd_1
XFILLER_0_96_589 VPWR VGND VPWR VGND sky130_ef_sc_hd__decap_12
XFILLER_0_68_258 VGND VGND VPWR VPWR sky130_fd_sc_hd__fill_2
XTAP_1479 VGND VPWR sky130_fd_sc_hd__tapvpwrvgnd_1
XTAP_1468 VGND VPWR sky130_fd_sc_hd__tapvpwrvgnd_1
XANTENNA__4600__B2 _1399_ VGND VGND VPWR VPWR sky130_fd_sc_hd__diode_2
Xfanout73 net818 VGND VGND VPWR VPWR net73 sky130_fd_sc_hd__buf_8
XFILLER_0_51_125 VGND VGND VPWR VPWR sky130_fd_sc_hd__decap_6
XFILLER_0_10_27 VGND VGND VPWR VPWR sky130_fd_sc_hd__fill_1
XANTENNA__6896__S _3427_ VGND VGND VPWR VPWR sky130_fd_sc_hd__diode_2
XFILLER_0_20_545 VGND VGND VPWR VPWR sky130_fd_sc_hd__decap_6
XFILLER_0_87_512 VGND VGND VPWR VPWR sky130_fd_sc_hd__decap_3
XANTENNA_output38_A net38 VGND VGND VPWR VPWR sky130_fd_sc_hd__diode_2
XFILLER_0_87_523 VGND VGND VPWR VPWR sky130_fd_sc_hd__fill_1
XFILLER_0_59_225 VGND VGND VPWR VPWR sky130_fd_sc_hd__decap_3
XANTENNA__5040__S _1661_ VGND VGND VPWR VPWR sky130_fd_sc_hd__diode_2
XANTENNA__7247__RESET_B net75 VGND VGND VPWR VPWR sky130_fd_sc_hd__diode_2
X_4780_ _1811_ VGND VGND VPWR VPWR _0212_ sky130_fd_sc_hd__clkbuf_1
XFILLER_0_27_111 VGND VGND VPWR VPWR sky130_fd_sc_hd__fill_1
X_3800_ u_pe_array.g_pe_row\[3\].g_pe_col\[2\].u_pe.psum_out\[6\] u_pe_array.g_pe_row\[3\].g_pe_col\[2\].u_pe.move_reg\[6\]
+ _0745_ VGND VGND VPWR VPWR _0999_ sky130_fd_sc_hd__mux2_1
XANTENNA__5395__A2 _2273_ VGND VGND VPWR VPWR sky130_fd_sc_hd__diode_2
XFILLER_0_7_517 VPWR VGND VPWR VGND sky130_ef_sc_hd__decap_12
X_3731_ _0939_ _0937_ _0943_ VGND VGND VPWR VPWR _0944_ sky130_fd_sc_hd__o21ai_1
XFILLER_0_28_645 VGND VGND VPWR VPWR sky130_fd_sc_hd__fill_2
XANTENNA__3495__S _0756_ VGND VGND VPWR VPWR sky130_fd_sc_hd__diode_2
XFILLER_0_55_464 VGND VGND VPWR VPWR sky130_fd_sc_hd__fill_1
XFILLER_0_27_177 VGND VGND VPWR VPWR sky130_fd_sc_hd__decap_4
XFILLER_0_42_103 VGND VGND VPWR VPWR sky130_fd_sc_hd__decap_6
XFILLER_0_113_503 VGND VGND VPWR VPWR sky130_fd_sc_hd__fill_1
XFILLER_0_43_637 VGND VGND VPWR VPWR sky130_fd_sc_hd__decap_4
X_3662_ u_pe_array.g_pe_row\[3\].g_pe_col\[3\].u_pe.act_val\[1\] _0869_ VGND VGND
+ VPWR VPWR _0880_ sky130_fd_sc_hd__and2b_1
XFILLER_0_15_328 VGND VGND VPWR VPWR sky130_fd_sc_hd__fill_2
X_6450_ net288 _1812_ net68 VGND VGND VPWR VPWR _3189_ sky130_fd_sc_hd__mux2_1
X_3593_ _0827_ VGND VGND VPWR VPWR _0828_ sky130_fd_sc_hd__buf_12
X_5401_ u_pe_array.g_pe_row\[0\].g_pe_col\[0\].u_pe.psum_out\[7\] u_pe_array.g_pe_row\[0\].g_pe_col\[0\].u_pe.move_reg\[7\]
+ _1661_ VGND VGND VPWR VPWR _2334_ sky130_fd_sc_hd__mux2_1
X_6381_ u_pe_array.u_fifo2.rd_ptr\[1\] u_pe_array.u_fifo2.rd_ptr\[0\] _3146_ VGND
+ VGND VPWR VPWR _3148_ sky130_fd_sc_hd__and3_1
XFILLER_0_30_309 VGND VGND VPWR VPWR sky130_fd_sc_hd__decap_3
X_5332_ u_pe_array.u_fifo1.rd_ptr\[1\] u_pe_array.u_fifo1.rd_ptr\[0\] u_pe_array.u_fifo1.rd_ptr\[2\]
+ VGND VGND VPWR VPWR _2272_ sky130_fd_sc_hd__or3_2
XFILLER_0_2_233 VPWR VGND VPWR VGND sky130_ef_sc_hd__decap_12
X_5263_ _2211_ u_pe_array.g_pe_row\[1\].g_pe_col\[2\].u_pe.psum_out\[6\] _2158_ VGND
+ VGND VPWR VPWR _2212_ sky130_fd_sc_hd__and3_1
XFILLER_0_11_589 VPWR VGND VPWR VGND sky130_ef_sc_hd__decap_12
X_4214_ _1334_ _1339_ _1342_ VGND VGND VPWR VPWR _1343_ sky130_fd_sc_hd__o21ai_1
X_7002_ clknet_leaf_38_clk net81 net813 VGND VGND VPWR VPWR u_pe_array.g_pe_row\[3\].g_pe_col\[1\].u_pe.w_reg\[1\]
+ sky130_fd_sc_hd__dfrtp_1
X_5194_ net203 _2144_ _2151_ _1665_ VGND VGND VPWR VPWR _0286_ sky130_fd_sc_hd__a22o_1
X_4145_ u_pe_array.g_pe_row\[3\].g_pe_col\[0\].u_pe.psum_out\[1\] _1278_ VGND VGND
+ VPWR VPWR _1280_ sky130_fd_sc_hd__nand2_1
XFILLER_0_92_52 VGND VGND VPWR VPWR sky130_fd_sc_hd__fill_2
X_4076_ u_pe_array.g_pe_row\[3\].g_pe_col\[1\].u_pe.psum_out\[8\] _1228_ _1230_ _1221_
+ VGND VGND VPWR VPWR _1231_ sky130_fd_sc_hd__a22o_1
XFILLER_0_92_85 VGND VGND VPWR VPWR sky130_fd_sc_hd__decap_4
XANTENNA__6046__S _2469_ VGND VGND VPWR VPWR sky130_fd_sc_hd__diode_2
XFILLER_0_78_589 VPWR VGND VPWR VGND sky130_ef_sc_hd__decap_12
XFILLER_0_93_559 VGND VGND VPWR VPWR sky130_fd_sc_hd__fill_1
XANTENNA__5386__A2 _2273_ VGND VGND VPWR VPWR sky130_fd_sc_hd__diode_2
XFILLER_0_46_442 VGND VGND VPWR VPWR sky130_fd_sc_hd__fill_1
XANTENNA__6583__A1 _1806_ VGND VGND VPWR VPWR sky130_fd_sc_hd__diode_2
X_4978_ u_pe_array.u_fifo2.buffer\[5\]\[0\] _1971_ _1972_ u_pe_array.u_fifo2.buffer\[1\]\[0\]
+ _1973_ VGND VGND VPWR VPWR _1974_ sky130_fd_sc_hd__a221o_1
X_6717_ _3336_ VGND VGND VPWR VPWR _0624_ sky130_fd_sc_hd__clkbuf_1
XFILLER_0_73_272 VGND VGND VPWR VPWR sky130_fd_sc_hd__decap_3
XFILLER_0_46_464 VGND VGND VPWR VPWR sky130_fd_sc_hd__fill_1
XFILLER_0_34_604 VGND VGND VPWR VPWR sky130_fd_sc_hd__decap_8
X_3929_ u_pe_array.g_pe_row\[3\].g_pe_col\[2\].u_pe.psum_out\[10\] _1096_ _1103_ _1107_
+ VGND VGND VPWR VPWR _1110_ sky130_fd_sc_hd__a2bb2o_1
XANTENNA__5617__C u_pe_array.g_pe_row\[1\].g_pe_col\[0\].u_pe.act_val\[4\] VGND VGND
+ VPWR VPWR sky130_fd_sc_hd__diode_2
X_6648_ _3293_ VGND VGND VPWR VPWR _0598_ sky130_fd_sc_hd__clkbuf_1
XFILLER_0_33_136 VGND VGND VPWR VPWR sky130_fd_sc_hd__fill_2
X_6579_ net475 _1802_ _3254_ VGND VGND VPWR VPWR _3258_ sky130_fd_sc_hd__mux2_1
XFILLER_0_41_191 VGND VGND VPWR VPWR sky130_fd_sc_hd__fill_2
XANTENNA__6638__A2 _0833_ VGND VGND VPWR VPWR sky130_fd_sc_hd__diode_2
XFILLER_0_88_309 VGND VGND VPWR VPWR sky130_fd_sc_hd__decap_4
XANTENNA__3624__A2 _0834_ VGND VGND VPWR VPWR sky130_fd_sc_hd__diode_2
XFILLER_0_84_504 VGND VGND VPWR VPWR sky130_fd_sc_hd__fill_2
XTAP_1232 VGND VPWR sky130_fd_sc_hd__tapvpwrvgnd_1
XTAP_1221 VGND VPWR sky130_fd_sc_hd__tapvpwrvgnd_1
XTAP_1210 VGND VPWR sky130_fd_sc_hd__tapvpwrvgnd_1
XANTENNA__7340__RESET_B net812 VGND VGND VPWR VPWR sky130_fd_sc_hd__diode_2
XFILLER_0_69_578 VGND VGND VPWR VPWR sky130_fd_sc_hd__decap_3
XFILLER_0_69_567 VGND VGND VPWR VPWR sky130_fd_sc_hd__fill_2
XTAP_1265 VGND VPWR sky130_fd_sc_hd__tapvpwrvgnd_1
XFILLER_0_84_537 VGND VGND VPWR VPWR sky130_fd_sc_hd__fill_2
XFILLER_0_84_526 VGND VGND VPWR VPWR sky130_fd_sc_hd__fill_2
XTAP_1254 VGND VPWR sky130_fd_sc_hd__tapvpwrvgnd_1
XTAP_1243 VGND VPWR sky130_fd_sc_hd__tapvpwrvgnd_1
XANTENNA__6023__B1 _2174_ VGND VGND VPWR VPWR sky130_fd_sc_hd__diode_2
XTAP_1298 VGND VPWR sky130_fd_sc_hd__tapvpwrvgnd_1
XTAP_1287 VGND VPWR sky130_fd_sc_hd__tapvpwrvgnd_1
XTAP_1276 VGND VPWR sky130_fd_sc_hd__tapvpwrvgnd_1
XANTENNA__5377__A2 _2273_ VGND VGND VPWR VPWR sky130_fd_sc_hd__diode_2
XFILLER_0_21_15 VGND VGND VPWR VPWR sky130_fd_sc_hd__decap_4
XANTENNA__4947__A_N _1847_ VGND VGND VPWR VPWR sky130_fd_sc_hd__diode_2
XFILLER_0_37_497 VGND VGND VPWR VPWR sky130_fd_sc_hd__decap_6
XANTENNA__5824__A _2611_ VGND VGND VPWR VPWR sky130_fd_sc_hd__diode_2
XANTENNA__6639__B _0833_ VGND VGND VPWR VPWR sky130_fd_sc_hd__diode_2
XFILLER_0_32_191 VGND VGND VPWR VPWR sky130_fd_sc_hd__decap_3
XANTENNA__7428__RESET_B net74 VGND VGND VPWR VPWR sky130_fd_sc_hd__diode_2
X_5950_ u_pe_array.g_pe_row\[0\].g_pe_col\[2\].u_pe.act_val\[4\] _2743_ VGND VGND
+ VPWR VPWR _2788_ sky130_fd_sc_hd__and2b_1
X_4901_ _1884_ _1894_ _1895_ VGND VGND VPWR VPWR _1906_ sky130_fd_sc_hd__o21a_1
XANTENNA__7081__RESET_B net816 VGND VGND VPWR VPWR sky130_fd_sc_hd__diode_2
XFILLER_0_1_69 VPWR VGND VPWR VGND sky130_ef_sc_hd__decap_12
X_7620_ clknet_leaf_22_clk _0669_ VGND VGND VPWR VPWR u_pe_array.u_fifo1.buffer\[4\]\[4\]
+ sky130_fd_sc_hd__dfxtp_1
X_5881_ net790 _2600_ _2592_ _2731_ VGND VGND VPWR VPWR _0393_ sky130_fd_sc_hd__a22o_1
XFILLER_0_62_77 VGND VGND VPWR VPWR sky130_fd_sc_hd__decap_6
XANTENNA__7010__RESET_B net74 VGND VGND VPWR VPWR sky130_fd_sc_hd__diode_2
X_4832_ u_pe_array.g_pe_row\[2\].g_pe_col\[0\].u_pe.act_val\[0\] u_pe_array.g_pe_row\[2\].g_pe_col\[0\].u_pe.w_reg\[0\]
+ u_pe_array.g_pe_row\[2\].g_pe_col\[0\].u_pe.psum_out\[0\] VGND VGND VPWR VPWR _1843_
+ sky130_fd_sc_hd__a21o_1
XANTENNA__5368__A2 _2273_ VGND VGND VPWR VPWR sky130_fd_sc_hd__diode_2
XANTENNA__6565__A1 _1816_ VGND VGND VPWR VPWR sky130_fd_sc_hd__diode_2
XFILLER_0_90_518 VGND VGND VPWR VPWR sky130_fd_sc_hd__fill_2
XANTENNA__4622__B _1672_ VGND VGND VPWR VPWR sky130_fd_sc_hd__diode_2
XANTENNA__4040__A2 _1152_ VGND VGND VPWR VPWR sky130_fd_sc_hd__diode_2
XFILLER_0_7_347 VGND VGND VPWR VPWR sky130_fd_sc_hd__decap_3
XFILLER_0_28_475 VGND VGND VPWR VPWR sky130_fd_sc_hd__fill_1
XANTENNA__4576__B1 _1534_ VGND VGND VPWR VPWR sky130_fd_sc_hd__diode_2
X_4763_ _1787_ _0842_ _0990_ _0747_ VGND VGND VPWR VPWR _1800_ sky130_fd_sc_hd__a22o_2
X_7551_ clknet_leaf_80_clk _0600_ net74 VGND VGND VPWR VPWR u_pe_array.g_pe_row\[3\].g_pe_col\[3\].u_pe.move_reg\[12\]
+ sky130_fd_sc_hd__dfrtp_1
X_4694_ _1725_ _1737_ _1739_ _1534_ net386 VGND VGND VPWR VPWR _0198_ sky130_fd_sc_hd__a32o_1
XFILLER_0_55_272 VGND VGND VPWR VPWR sky130_fd_sc_hd__fill_2
X_6502_ net218 _1810_ _3208_ VGND VGND VPWR VPWR _3216_ sky130_fd_sc_hd__mux2_1
XFILLER_0_43_445 VGND VGND VPWR VPWR sky130_fd_sc_hd__decap_3
XANTENNA__4114__S _0769_ VGND VGND VPWR VPWR sky130_fd_sc_hd__diode_2
X_7482_ clknet_leaf_0_clk _0531_ VGND VGND VPWR VPWR u_pe_array.u_fifo2.buffer\[3\]\[8\]
+ sky130_fd_sc_hd__dfxtp_1
XFILLER_0_16_637 VGND VGND VPWR VPWR sky130_fd_sc_hd__fill_2
X_3714_ _0927_ u_pe_array.g_pe_row\[3\].g_pe_col\[3\].u_pe.psum_out\[6\] _0869_ VGND
+ VGND VPWR VPWR _0928_ sky130_fd_sc_hd__and3_1
XFILLER_0_28_497 VGND VGND VPWR VPWR sky130_fd_sc_hd__decap_4
XFILLER_0_70_264 VGND VGND VPWR VPWR sky130_fd_sc_hd__fill_2
XFILLER_0_70_253 VGND VGND VPWR VPWR sky130_fd_sc_hd__fill_2
X_6433_ u_pe_array.u_fifo2.wr_ptr\[1\] _3165_ _1792_ VGND VGND VPWR VPWR _3180_ sky130_fd_sc_hd__nor3b_1
XFILLER_0_43_467 VGND VGND VPWR VPWR sky130_fd_sc_hd__fill_1
X_3645_ _0861_ VGND VGND VPWR VPWR _0865_ sky130_fd_sc_hd__inv_2
XFILLER_0_3_553 VGND VGND VPWR VPWR sky130_fd_sc_hd__decap_6
X_6364_ _0788_ _1790_ VGND VGND VPWR VPWR _3136_ sky130_fd_sc_hd__and2_1
X_3576_ _0814_ _0815_ u_fsm.h_cnt\[0\] VGND VGND VPWR VPWR _0816_ sky130_fd_sc_hd__o21a_1
XFILLER_0_3_597 VPWR VGND VPWR VGND sky130_ef_sc_hd__decap_12
X_6295_ _3074_ _3077_ _3082_ VGND VGND VPWR VPWR _3084_ sky130_fd_sc_hd__or3_1
X_5315_ u_pe_array.g_pe_row\[1\].g_pe_col\[2\].u_pe.psum_out\[11\] _2158_ VGND VGND
+ VPWR VPWR _2259_ sky130_fd_sc_hd__and2b_1
X_5246_ _2193_ _2194_ _2195_ VGND VGND VPWR VPWR _2197_ sky130_fd_sc_hd__a21oi_1
XFILLER_0_53_3 VPWR VGND VPWR VGND sky130_ef_sc_hd__decap_12
Xhold38 u_pe_array.g_pe_row\[3\].g_pe_col\[0\].u_pe.move_reg\[12\] VGND VGND VPWR
+ VPWR net114 sky130_fd_sc_hd__dlygate4sd3_1
Xhold16 u_pe_array.g_pe_row\[1\].g_pe_col\[2\].u_pe.w_buffer\[0\] VGND VGND VPWR VPWR
+ net92 sky130_fd_sc_hd__dlygate4sd3_1
Xhold27 u_pe_array.g_pe_row\[2\].g_pe_col\[2\].u_pe.w_buffer\[0\] VGND VGND VPWR VPWR
+ net103 sky130_fd_sc_hd__dlygate4sd3_1
Xhold49 u_pe_array.g_pe_row\[3\].g_pe_col\[0\].u_pe.move_reg\[11\] VGND VGND VPWR
+ VPWR net125 sky130_fd_sc_hd__dlygate4sd3_1
X_5177_ net618 _1666_ _1655_ _2142_ VGND VGND VPWR VPWR _0278_ sky130_fd_sc_hd__a22o_1
XANTENNA__7169__RESET_B net817 VGND VGND VPWR VPWR sky130_fd_sc_hd__diode_2
X_4128_ u_pe_array.g_pe_row\[3\].g_pe_col\[3\].u_pe.psum_out\[10\] u_pe_array.g_pe_row\[3\].g_pe_col\[3\].u_pe.move_reg\[10\]
+ _0855_ VGND VGND VPWR VPWR _1267_ sky130_fd_sc_hd__mux2_1
X_4059_ _1192_ _1193_ _1206_ _1212_ VGND VGND VPWR VPWR _1215_ sky130_fd_sc_hd__or4b_1
XFILLER_0_38_228 VGND VGND VPWR VPWR sky130_fd_sc_hd__decap_3
XFILLER_0_109_617 VPWR VGND VPWR VGND sky130_ef_sc_hd__decap_12
XANTENNA__5359__A2 _2273_ VGND VGND VPWR VPWR sky130_fd_sc_hd__diode_2
XANTENNA__6504__S _3208_ VGND VGND VPWR VPWR sky130_fd_sc_hd__diode_2
XFILLER_0_19_442 VGND VGND VPWR VPWR sky130_fd_sc_hd__fill_2
XFILLER_0_93_389 VGND VGND VPWR VPWR sky130_fd_sc_hd__decap_3
XANTENNA__5628__B u_pe_array.g_pe_row\[1\].g_pe_col\[0\].u_pe.w_reg\[0\] VGND VGND
+ VPWR VPWR sky130_fd_sc_hd__diode_2
XFILLER_0_6_380 VGND VGND VPWR VPWR sky130_fd_sc_hd__decap_6
XFILLER_0_61_275 VGND VGND VPWR VPWR sky130_fd_sc_hd__fill_2
XFILLER_0_100_594 VGND VGND VPWR VPWR sky130_fd_sc_hd__fill_1
XFILLER_0_107_39 VPWR VGND VPWR VGND sky130_ef_sc_hd__decap_12
XANTENNA__6795__A1 _3130_ VGND VGND VPWR VPWR sky130_fd_sc_hd__diode_2
XFILLER_0_97_640 VGND VGND VPWR VPWR sky130_fd_sc_hd__fill_2
XFILLER_0_97_673 VGND VGND VPWR VPWR sky130_fd_sc_hd__decap_4
XFILLER_0_69_375 VGND VGND VPWR VPWR sky130_fd_sc_hd__decap_4
XTAP_1040 VGND VPWR sky130_fd_sc_hd__tapvpwrvgnd_1
XFILLER_0_57_526 VGND VGND VPWR VPWR sky130_fd_sc_hd__decap_4
XANTENNA__4270__A2 _1138_ VGND VGND VPWR VPWR sky130_fd_sc_hd__diode_2
XTAP_1073 VGND VPWR sky130_fd_sc_hd__tapvpwrvgnd_1
XTAP_1062 VGND VPWR sky130_fd_sc_hd__tapvpwrvgnd_1
XTAP_1051 VGND VPWR sky130_fd_sc_hd__tapvpwrvgnd_1
XTAP_1095 VGND VPWR sky130_fd_sc_hd__tapvpwrvgnd_1
XTAP_1084 VGND VPWR sky130_fd_sc_hd__tapvpwrvgnd_1
XFILLER_0_65_570 VGND VGND VPWR VPWR sky130_fd_sc_hd__fill_1
XFILLER_0_32_58 VGND VGND VPWR VPWR sky130_fd_sc_hd__decap_6
XFILLER_0_25_412 VGND VGND VPWR VPWR sky130_fd_sc_hd__fill_1
XFILLER_0_13_607 VGND VGND VPWR VPWR sky130_fd_sc_hd__fill_2
XFILLER_0_25_467 VGND VGND VPWR VPWR sky130_fd_sc_hd__fill_1
Xhold508 u_pe_array.g_pe_row\[2\].g_pe_col\[0\].u_pe.psum_out\[6\] VGND VGND VPWR
+ VPWR net584 sky130_fd_sc_hd__dlygate4sd3_1
XFILLER_0_40_415 VGND VGND VPWR VPWR sky130_fd_sc_hd__fill_2
XFILLER_0_21_640 VGND VGND VPWR VPWR sky130_fd_sc_hd__decap_4
Xhold519 u_pe_array.g_pe_row\[3\].g_pe_col\[3\].u_pe.move_reg\[10\] VGND VGND VPWR
+ VPWR net595 sky130_fd_sc_hd__dlygate4sd3_1
XFILLER_0_20_150 VGND VGND VPWR VPWR sky130_fd_sc_hd__fill_2
XFILLER_0_21_662 VGND VGND VPWR VPWR sky130_fd_sc_hd__fill_1
XFILLER_0_21_673 VGND VGND VPWR VPWR sky130_fd_sc_hd__fill_2
X_6080_ _2873_ _2891_ u_pe_array.g_pe_row\[0\].g_pe_col\[1\].u_pe.act_val\[3\] u_pe_array.g_pe_row\[0\].g_pe_col\[1\].u_pe.w_reg\[0\]
+ VGND VGND VPWR VPWR _2892_ sky130_fd_sc_hd__a22o_1
XTAP_835 VGND VPWR sky130_fd_sc_hd__tapvpwrvgnd_1
XTAP_824 VGND VPWR sky130_fd_sc_hd__tapvpwrvgnd_1
XTAP_802 VGND VPWR sky130_fd_sc_hd__tapvpwrvgnd_1
XTAP_813 VGND VPWR sky130_fd_sc_hd__tapvpwrvgnd_1
XFILLER_0_0_589 VPWR VGND VPWR VGND sky130_ef_sc_hd__decap_12
XFILLER_0_20_161 VGND VGND VPWR VPWR sky130_fd_sc_hd__decap_4
X_5100_ _2076_ _2077_ VGND VGND VPWR VPWR _2078_ sky130_fd_sc_hd__nor2_1
XFILLER_0_57_55 VGND VGND VPWR VPWR sky130_fd_sc_hd__fill_1
X_5031_ net201 _1666_ _2020_ _1665_ VGND VGND VPWR VPWR _0254_ sky130_fd_sc_hd__a22o_1
XTAP_868 VGND VPWR sky130_fd_sc_hd__tapvpwrvgnd_1
XTAP_857 VGND VPWR sky130_fd_sc_hd__tapvpwrvgnd_1
XTAP_846 VGND VPWR sky130_fd_sc_hd__tapvpwrvgnd_1
XTAP_879 VGND VPWR sky130_fd_sc_hd__tapvpwrvgnd_1
XANTENNA__7262__RESET_B net812 VGND VGND VPWR VPWR sky130_fd_sc_hd__diode_2
XFILLER_0_79_106 VGND VGND VPWR VPWR sky130_fd_sc_hd__fill_2
XANTENNA__3521__B _0770_ VGND VGND VPWR VPWR sky130_fd_sc_hd__diode_2
XFILLER_0_79_117 VPWR VGND VPWR VGND sky130_ef_sc_hd__decap_12
XANTENNA__4109__S _0769_ VGND VGND VPWR VPWR sky130_fd_sc_hd__diode_2
X_6982_ clknet_leaf_86_clk _0061_ net74 VGND VGND VPWR VPWR u_pe_array.g_pe_row\[3\].g_pe_col\[2\].u_pe.psum_out\[9\]
+ sky130_fd_sc_hd__dfrtp_1
XANTENNA__3948__S _0755_ VGND VGND VPWR VPWR sky130_fd_sc_hd__diode_2
XFILLER_0_94_109 VGND VGND VPWR VPWR sky130_fd_sc_hd__fill_2
X_5933_ _2769_ _2771_ _2760_ VGND VGND VPWR VPWR _2773_ sky130_fd_sc_hd__o21ai_1
XFILLER_0_8_601 VPWR VGND VPWR VGND sky130_ef_sc_hd__decap_12
X_5864_ _2721_ _2722_ VGND VGND VPWR VPWR _2723_ sky130_fd_sc_hd__xnor2_1
X_7603_ clknet_leaf_20_clk _0652_ VGND VGND VPWR VPWR u_pe_array.u_fifo1.buffer\[3\]\[0\]
+ sky130_fd_sc_hd__dfxtp_1
X_4815_ u_pe_array.g_pe_row\[1\].g_pe_col\[2\].u_pe.act_val\[5\] u_pe_array.g_pe_row\[1\].g_pe_col\[2\].u_pe.psum_out\[5\]
+ _0756_ VGND VGND VPWR VPWR _1834_ sky130_fd_sc_hd__mux2_1
XFILLER_0_8_645 VPWR VGND VPWR VGND sky130_ef_sc_hd__decap_12
XFILLER_0_28_250 VGND VGND VPWR VPWR sky130_fd_sc_hd__fill_2
XANTENNA__5210__A1 _1725_ VGND VGND VPWR VPWR sky130_fd_sc_hd__diode_2
X_7534_ clknet_leaf_0_clk _0583_ VGND VGND VPWR VPWR u_pe_array.u_fifo2.buffer\[7\]\[8\]
+ sky130_fd_sc_hd__dfxtp_1
X_5795_ _2648_ _2651_ _2660_ VGND VGND VPWR VPWR _2661_ sky130_fd_sc_hd__o21ai_1
XFILLER_0_113_93 VPWR VGND VPWR VGND sky130_ef_sc_hd__decap_12
X_4746_ _1784_ _1785_ VGND VGND VPWR VPWR _1786_ sky130_fd_sc_hd__xnor2_1
XFILLER_0_43_231 VGND VGND VPWR VPWR sky130_fd_sc_hd__decap_3
XFILLER_0_7_188 VGND VGND VPWR VPWR sky130_fd_sc_hd__decap_4
XFILLER_0_7_177 VGND VGND VPWR VPWR sky130_fd_sc_hd__fill_2
XFILLER_0_16_445 VGND VGND VPWR VPWR sky130_fd_sc_hd__fill_2
XFILLER_0_22_80 VGND VGND VPWR VPWR sky130_fd_sc_hd__fill_2
X_4677_ _1709_ _1712_ _1722_ _0885_ VGND VGND VPWR VPWR _1724_ sky130_fd_sc_hd__o31a_1
XANTENNA__4779__S _1796_ VGND VGND VPWR VPWR sky130_fd_sc_hd__diode_2
X_7465_ clknet_leaf_1_clk _0514_ VGND VGND VPWR VPWR u_pe_array.u_fifo2.buffer\[2\]\[4\]
+ sky130_fd_sc_hd__dfxtp_1
XANTENNA__6710__A1 _3126_ VGND VGND VPWR VPWR sky130_fd_sc_hd__diode_2
XFILLER_0_101_314 VGND VGND VPWR VPWR sky130_fd_sc_hd__fill_2
X_7396_ clknet_leaf_41_clk _0446_ net817 VGND VGND VPWR VPWR u_pe_array.g_pe_row\[0\].g_pe_col\[0\].u_pe.psum_out\[0\]
+ sky130_fd_sc_hd__dfrtp_1
X_6416_ _3171_ VGND VGND VPWR VPWR _0488_ sky130_fd_sc_hd__clkbuf_1
X_3628_ net186 _0834_ _0852_ u_fsm.psum_shift_en VGND VGND VPWR VPWR _0019_ sky130_fd_sc_hd__a22o_1
Xoutput39 net39 VGND VGND VPWR VPWR psum_out0[12] sky130_fd_sc_hd__clkbuf_4
X_6347_ _3124_ net349 _3110_ VGND VGND VPWR VPWR _3125_ sky130_fd_sc_hd__mux2_1
XANTENNA__4721__B1 _1534_ VGND VGND VPWR VPWR sky130_fd_sc_hd__diode_2
X_3559_ _0787_ _0792_ _0803_ _0785_ _0790_ VGND VGND VPWR VPWR _0804_ sky130_fd_sc_hd__a221o_1
X_6278_ _3028_ _3029_ _3040_ VGND VGND VPWR VPWR _3068_ sky130_fd_sc_hd__a21oi_1
XFILLER_0_11_194 VGND VGND VPWR VPWR sky130_fd_sc_hd__fill_2
XANTENNA__5403__S _1661_ VGND VGND VPWR VPWR sky130_fd_sc_hd__diode_2
X_5229_ _2178_ _2180_ VGND VGND VPWR VPWR _2181_ sky130_fd_sc_hd__nand2_1
XANTENNA__5029__A1 _0836_ VGND VGND VPWR VPWR sky130_fd_sc_hd__diode_2
XANTENNA__4788__A0 _1816_ VGND VGND VPWR VPWR sky130_fd_sc_hd__diode_2
XFILLER_0_85_109 VGND VGND VPWR VPWR sky130_fd_sc_hd__decap_3
XFILLER_0_79_673 VGND VGND VPWR VPWR sky130_fd_sc_hd__fill_2
XANTENNA__6985__RESET_B net818 VGND VGND VPWR VPWR sky130_fd_sc_hd__diode_2
XFILLER_0_39_526 VGND VGND VPWR VPWR sky130_fd_sc_hd__decap_3
XFILLER_0_94_643 VGND VGND VPWR VPWR sky130_fd_sc_hd__fill_1
XFILLER_0_93_120 VGND VGND VPWR VPWR sky130_fd_sc_hd__decap_4
XANTENNA__6914__RESET_B net813 VGND VGND VPWR VPWR sky130_fd_sc_hd__diode_2
XPHY_134 VGND VGND VPWR VPWR sky130_fd_sc_hd__decap_3
XPHY_123 VGND VGND VPWR VPWR sky130_fd_sc_hd__decap_3
XPHY_112 VGND VGND VPWR VPWR sky130_fd_sc_hd__decap_3
XPHY_101 VGND VGND VPWR VPWR sky130_fd_sc_hd__decap_3
XANTENNA__6529__A1 _1808_ VGND VGND VPWR VPWR sky130_fd_sc_hd__diode_2
XFILLER_0_109_447 VGND VGND VPWR VPWR sky130_fd_sc_hd__fill_1
XFILLER_0_94_665 VPWR VGND VPWR VGND sky130_ef_sc_hd__decap_12
XPHY_167 VGND VGND VPWR VPWR sky130_fd_sc_hd__decap_3
XPHY_156 VGND VGND VPWR VPWR sky130_fd_sc_hd__decap_3
XPHY_145 VGND VGND VPWR VPWR sky130_fd_sc_hd__decap_3
XPHY_189 VGND VGND VPWR VPWR sky130_fd_sc_hd__decap_3
XPHY_178 VGND VGND VPWR VPWR sky130_fd_sc_hd__decap_3
XFILLER_0_81_326 VGND VGND VPWR VPWR sky130_fd_sc_hd__decap_4
XFILLER_0_62_540 VGND VGND VPWR VPWR sky130_fd_sc_hd__fill_2
XFILLER_0_105_653 VPWR VGND VPWR VGND sky130_ef_sc_hd__decap_12
XFILLER_0_104_141 VGND VGND VPWR VPWR sky130_fd_sc_hd__fill_1
XFILLER_0_100_380 VGND VGND VPWR VPWR sky130_fd_sc_hd__fill_2
XANTENNA__6768__A1 _3130_ VGND VGND VPWR VPWR sky130_fd_sc_hd__diode_2
XANTENNA__4779__A0 _1810_ VGND VGND VPWR VPWR sky130_fd_sc_hd__diode_2
XANTENNA__5440__A1 _2345_ VGND VGND VPWR VPWR sky130_fd_sc_hd__diode_2
XFILLER_0_69_150 VGND VGND VPWR VPWR sky130_fd_sc_hd__fill_1
XPHY_3 VGND VGND VPWR VPWR sky130_fd_sc_hd__decap_3
Xmax_cap70 _3166_ VGND VGND VPWR VPWR net70 sky130_fd_sc_hd__buf_2
XANTENNA__5440__B2 u_pe_array.g_pe_row\[1\].g_pe_col\[1\].u_pe.w_reg\[0\] VGND VGND
+ VPWR VPWR sky130_fd_sc_hd__diode_2
XFILLER_0_43_79 VGND VGND VPWR VPWR sky130_fd_sc_hd__fill_2
XFILLER_0_84_197 VGND VGND VPWR VPWR sky130_fd_sc_hd__fill_2
X_4600_ net631 _1524_ _1658_ _1399_ VGND VGND VPWR VPWR _0185_ sky130_fd_sc_hd__a22o_1
XFILLER_0_111_3 VPWR VGND VPWR VGND sky130_ef_sc_hd__decap_12
X_5580_ u_pe_array.g_pe_row\[1\].g_pe_col\[0\].u_pe.w_reg\[1\] VGND VGND VPWR VPWR
+ _2478_ sky130_fd_sc_hd__clkbuf_8
XFILLER_0_5_615 VGND VGND VPWR VPWR sky130_fd_sc_hd__fill_1
XANTENNA__4599__S _0855_ VGND VGND VPWR VPWR sky130_fd_sc_hd__diode_2
X_4531_ _1595_ _1600_ _1603_ VGND VGND VPWR VPWR _1604_ sky130_fd_sc_hd__o21ai_1
X_7250_ clknet_leaf_40_clk net113 net75 VGND VGND VPWR VPWR u_pe_array.g_pe_row\[1\].g_pe_col\[0\].u_pe.move_reg\[9\]
+ sky130_fd_sc_hd__dfrtp_1
Xhold305 u_pe_array.g_pe_row\[1\].g_pe_col\[1\].u_pe.move_reg\[6\] VGND VGND VPWR
+ VPWR net381 sky130_fd_sc_hd__dlygate4sd3_1
Xhold316 u_pe_array.g_pe_row\[0\].g_pe_col\[2\].u_pe.psum_out\[0\] VGND VGND VPWR
+ VPWR net392 sky130_fd_sc_hd__dlygate4sd3_1
XFILLER_0_13_437 VGND VGND VPWR VPWR sky130_fd_sc_hd__fill_1
XFILLER_0_13_459 VPWR VGND VPWR VGND sky130_ef_sc_hd__decap_12
X_4462_ u_pe_array.g_pe_row\[2\].g_pe_col\[2\].u_pe.psum_out\[1\] _1539_ VGND VGND
+ VPWR VPWR _1541_ sky130_fd_sc_hd__nand2_1
X_6201_ u_pe_array.g_pe_row\[0\].g_pe_col\[0\].u_pe.act_val\[1\] u_pe_array.g_pe_row\[0\].g_pe_col\[0\].u_pe.w_reg\[0\]
+ _2995_ _2996_ VGND VGND VPWR VPWR _2998_ sky130_fd_sc_hd__nand4_1
Xhold338 u_pe_array.u_fifo1.buffer\[0\]\[2\] VGND VGND VPWR VPWR net414 sky130_fd_sc_hd__dlygate4sd3_1
Xhold349 u_pe_array.g_pe_row\[1\].g_pe_col\[2\].u_pe.psum_out\[11\] VGND VGND VPWR
+ VPWR net425 sky130_fd_sc_hd__dlygate4sd3_1
XFILLER_0_7_57 VGND VGND VPWR VPWR sky130_fd_sc_hd__fill_2
Xhold327 u_pe_array.g_pe_row\[2\].g_pe_col\[2\].u_pe.psum_out\[0\] VGND VGND VPWR
+ VPWR net403 sky130_fd_sc_hd__dlygate4sd3_1
XFILLER_0_40_256 VGND VGND VPWR VPWR sky130_fd_sc_hd__fill_1
X_7181_ clknet_leaf_61_clk _0248_ net73 VGND VGND VPWR VPWR u_pe_array.g_pe_row\[1\].g_pe_col\[2\].u_pe.act_val\[0\]
+ sky130_fd_sc_hd__dfrtp_2
X_4393_ u_pe_array.g_pe_row\[2\].g_pe_col\[3\].u_pe.psum_out\[8\] _1489_ _1491_ _1482_
+ VGND VGND VPWR VPWR _1492_ sky130_fd_sc_hd__a22o_1
X_6132_ _2939_ u_pe_array.g_pe_row\[0\].g_pe_col\[1\].u_pe.psum_out\[7\] _2928_ VGND
+ VGND VPWR VPWR _2940_ sky130_fd_sc_hd__mux2_1
XTAP_610 VGND VPWR sky130_fd_sc_hd__tapvpwrvgnd_1
XTAP_621 VGND VPWR sky130_fd_sc_hd__tapvpwrvgnd_1
XTAP_632 VGND VPWR sky130_fd_sc_hd__tapvpwrvgnd_1
XTAP_643 VGND VPWR sky130_fd_sc_hd__tapvpwrvgnd_1
X_6063_ u_pe_array.g_pe_row\[0\].g_pe_col\[1\].u_pe.psum_out\[1\] _2876_ VGND VGND
+ VPWR VPWR _2877_ sky130_fd_sc_hd__or2_1
XTAP_654 VGND VPWR sky130_fd_sc_hd__tapvpwrvgnd_1
XTAP_665 VGND VPWR sky130_fd_sc_hd__tapvpwrvgnd_1
XTAP_676 VGND VPWR sky130_fd_sc_hd__tapvpwrvgnd_1
X_5014_ u_pe_array.u_fifo2.buffer\[5\]\[4\] _1971_ _1972_ u_pe_array.u_fifo2.buffer\[1\]\[4\]
+ _1973_ VGND VGND VPWR VPWR _2006_ sky130_fd_sc_hd__a221o_1
XTAP_687 VGND VPWR sky130_fd_sc_hd__tapvpwrvgnd_1
XTAP_698 VGND VPWR sky130_fd_sc_hd__tapvpwrvgnd_1
XANTENNA__6208__B1 _2992_ VGND VGND VPWR VPWR sky130_fd_sc_hd__diode_2
XANTENNA__4347__B _1407_ VGND VGND VPWR VPWR sky130_fd_sc_hd__diode_2
XFILLER_0_108_82 VGND VGND VPWR VPWR sky130_fd_sc_hd__fill_2
XFILLER_0_16_3 VGND VGND VPWR VPWR sky130_fd_sc_hd__decap_3
X_6965_ clknet_leaf_12_clk _0046_ net818 VGND VGND VPWR VPWR u_pe_array.g_pe_row\[3\].g_pe_col\[1\].u_pe.move_reg\[7\]
+ sky130_fd_sc_hd__dfrtp_1
X_5916_ _2746_ _2749_ VGND VGND VPWR VPWR _2757_ sky130_fd_sc_hd__and2_1
X_6896_ net562 _3118_ _3427_ VGND VGND VPWR VPWR _3432_ sky130_fd_sc_hd__mux2_1
XFILLER_0_76_676 VGND VGND VPWR VPWR sky130_fd_sc_hd__fill_1
XFILLER_0_75_164 VGND VGND VPWR VPWR sky130_fd_sc_hd__fill_2
XFILLER_0_63_304 VGND VGND VPWR VPWR sky130_fd_sc_hd__fill_2
XFILLER_0_63_337 VGND VGND VPWR VPWR sky130_fd_sc_hd__decap_3
X_5847_ net646 VGND VGND VPWR VPWR _2708_ sky130_fd_sc_hd__inv_2
XFILLER_0_106_417 VGND VGND VPWR VPWR sky130_fd_sc_hd__decap_3
XFILLER_0_63_348 VGND VGND VPWR VPWR sky130_fd_sc_hd__fill_2
X_5778_ u_pe_array.g_pe_row\[0\].g_pe_col\[3\].u_pe.psum_out\[4\] _2643_ _2644_ VGND
+ VGND VPWR VPWR _2645_ sky130_fd_sc_hd__nand3_1
X_4729_ net724 VGND VGND VPWR VPWR _1771_ sky130_fd_sc_hd__inv_2
XFILLER_0_16_253 VGND VGND VPWR VPWR sky130_fd_sc_hd__fill_2
X_7517_ clknet_leaf_2_clk _0566_ VGND VGND VPWR VPWR u_pe_array.u_fifo2.buffer\[6\]\[4\]
+ sky130_fd_sc_hd__dfxtp_1
XFILLER_0_114_461 VGND VGND VPWR VPWR sky130_fd_sc_hd__fill_2
XFILLER_0_102_612 VPWR VGND VPWR VGND sky130_ef_sc_hd__decap_12
XFILLER_0_16_286 VGND VGND VPWR VPWR sky130_fd_sc_hd__fill_2
X_7448_ clknet_leaf_4_clk _0497_ VGND VGND VPWR VPWR u_pe_array.u_fifo2.buffer\[1\]\[0\]
+ sky130_fd_sc_hd__dfxtp_1
XFILLER_0_102_645 VPWR VGND VPWR VGND sky130_ef_sc_hd__decap_12
X_7379_ clknet_leaf_46_clk _0432_ net812 VGND VGND VPWR VPWR u_pe_array.g_pe_row\[0\].g_pe_col\[1\].u_pe.psum_out\[3\]
+ sky130_fd_sc_hd__dfrtp_2
XANTENNA__7184__RESET_B net73 VGND VGND VPWR VPWR sky130_fd_sc_hd__diode_2
XANTENNA__7113__RESET_B net76 VGND VGND VPWR VPWR sky130_fd_sc_hd__diode_2
XFILLER_0_98_267 VGND VGND VPWR VPWR sky130_fd_sc_hd__decap_4
XFILLER_0_67_610 VGND VGND VPWR VPWR sky130_fd_sc_hd__fill_2
XFILLER_0_79_481 VGND VGND VPWR VPWR sky130_fd_sc_hd__fill_2
XFILLER_0_66_120 VGND VGND VPWR VPWR sky130_fd_sc_hd__decap_8
XANTENNA__4273__A _0832_ VGND VGND VPWR VPWR sky130_fd_sc_hd__diode_2
XFILLER_0_39_312 VGND VGND VPWR VPWR sky130_fd_sc_hd__fill_2
XFILLER_0_104_29 VPWR VGND VPWR VGND sky130_ef_sc_hd__decap_12
XFILLER_0_94_440 VGND VGND VPWR VPWR sky130_fd_sc_hd__decap_3
XFILLER_0_94_473 VGND VGND VPWR VPWR sky130_fd_sc_hd__decap_3
XANTENNA__5725__A2 _2600_ VGND VGND VPWR VPWR sky130_fd_sc_hd__diode_2
XFILLER_0_62_370 VGND VGND VPWR VPWR sky130_fd_sc_hd__decap_4
XFILLER_0_22_201 VGND VGND VPWR VPWR sky130_fd_sc_hd__decap_4
XFILLER_0_50_587 VGND VGND VPWR VPWR sky130_fd_sc_hd__fill_1
XANTENNA__4161__B2 u_pe_array.g_pe_row\[3\].g_pe_col\[0\].u_pe.w_reg\[0\] VGND VGND
+ VPWR VPWR sky130_fd_sc_hd__diode_2
XANTENNA__4161__A1 _1275_ VGND VGND VPWR VPWR sky130_fd_sc_hd__diode_2
XANTENNA__6647__B _0833_ VGND VGND VPWR VPWR sky130_fd_sc_hd__diode_2
XFILLER_0_89_212 VGND VGND VPWR VPWR sky130_fd_sc_hd__fill_1
X_6750_ net437 _3112_ net63 VGND VGND VPWR VPWR _3354_ sky130_fd_sc_hd__mux2_1
XANTENNA__5413__B2 _2336_ VGND VGND VPWR VPWR sky130_fd_sc_hd__diode_2
XANTENNA__3498__S _0756_ VGND VGND VPWR VPWR sky130_fd_sc_hd__diode_2
X_3962_ net768 _0996_ _0837_ _1133_ VGND VGND VPWR VPWR _0072_ sky130_fd_sc_hd__a22o_1
X_5701_ u_pe_array.g_pe_row\[1\].g_pe_col\[0\].u_pe.psum_out\[12\] _2581_ VGND VGND
+ VPWR VPWR _2588_ sky130_fd_sc_hd__xnor2_1
XFILLER_0_58_654 VGND VGND VPWR VPWR sky130_fd_sc_hd__decap_3
XFILLER_0_18_507 VGND VGND VPWR VPWR sky130_fd_sc_hd__decap_4
XANTENNA__3975__B2 _1004_ VGND VGND VPWR VPWR sky130_fd_sc_hd__diode_2
XFILLER_0_72_112 VGND VGND VPWR VPWR sky130_fd_sc_hd__fill_2
X_6681_ u_pe_array.u_fifo1.count\[0\] _3315_ VGND VGND VPWR VPWR _3316_ sky130_fd_sc_hd__nand2_1
X_3893_ _1076_ _1077_ VGND VGND VPWR VPWR _1078_ sky130_fd_sc_hd__and2_1
XANTENNA__5177__B1 _1655_ VGND VGND VPWR VPWR sky130_fd_sc_hd__diode_2
XFILLER_0_72_134 VGND VGND VPWR VPWR sky130_fd_sc_hd__decap_6
X_5632_ _2511_ _2512_ _2525_ VGND VGND VPWR VPWR _2526_ sky130_fd_sc_hd__o21a_1
XFILLER_0_5_401 VGND VGND VPWR VPWR sky130_fd_sc_hd__decap_3
XANTENNA__5716__A2 _2463_ VGND VGND VPWR VPWR sky130_fd_sc_hd__diode_2
XFILLER_0_60_318 VGND VGND VPWR VPWR sky130_fd_sc_hd__decap_4
XFILLER_0_5_445 VGND VGND VPWR VPWR sky130_fd_sc_hd__decap_3
X_5563_ net133 _2463_ _2468_ _2336_ VGND VGND VPWR VPWR _0338_ sky130_fd_sc_hd__a22o_1
XFILLER_0_13_212 VGND VGND VPWR VPWR sky130_fd_sc_hd__decap_4
XFILLER_0_13_223 VGND VGND VPWR VPWR sky130_fd_sc_hd__fill_1
X_4514_ u_pe_array.g_pe_row\[2\].g_pe_col\[2\].u_pe.w_reg\[0\] u_pe_array.g_pe_row\[2\].g_pe_col\[2\].u_pe.act_val\[5\]
+ _1578_ VGND VGND VPWR VPWR _1588_ sky130_fd_sc_hd__and3_1
XFILLER_0_13_234 VPWR VGND VPWR VGND sky130_ef_sc_hd__decap_12
XANTENNA__4122__S _0855_ VGND VGND VPWR VPWR sky130_fd_sc_hd__diode_2
X_7302_ clknet_leaf_62_clk _0361_ net814 VGND VGND VPWR VPWR u_pe_array.g_pe_row\[0\].g_pe_col\[2\].u_pe.act_val\[1\]
+ sky130_fd_sc_hd__dfrtp_2
X_5494_ _2405_ _2410_ _2413_ VGND VGND VPWR VPWR _2414_ sky130_fd_sc_hd__o21ai_1
Xhold102 u_pe_array.u_fifo1.wr_ptr\[3\] VGND VGND VPWR VPWR net178 sky130_fd_sc_hd__dlygate4sd3_1
Xhold124 u_pe_array.u_fifo2.wr_ptr\[3\] VGND VGND VPWR VPWR net200 sky130_fd_sc_hd__dlygate4sd3_1
Xhold135 u_pe_array.u_fifo2.rd_ptr\[3\] VGND VGND VPWR VPWR net211 sky130_fd_sc_hd__dlygate4sd3_1
Xhold113 u_pe_array.g_pe_row\[2\].g_pe_col\[2\].u_pe.move_reg\[9\] VGND VGND VPWR
+ VPWR net189 sky130_fd_sc_hd__dlygate4sd3_1
XFILLER_0_41_554 VGND VGND VPWR VPWR sky130_fd_sc_hd__fill_2
XFILLER_0_41_565 VGND VGND VPWR VPWR sky130_fd_sc_hd__decap_3
XANTENNA__3961__S _0819_ VGND VGND VPWR VPWR sky130_fd_sc_hd__diode_2
X_7233_ clknet_leaf_53_clk _0296_ net75 VGND VGND VPWR VPWR u_pe_array.g_pe_row\[1\].g_pe_col\[2\].u_pe.psum_out\[7\]
+ sky130_fd_sc_hd__dfrtp_4
Xhold146 u_pe_array.u_fifo2.buffer\[7\]\[7\] VGND VGND VPWR VPWR net222 sky130_fd_sc_hd__dlygate4sd3_1
X_4445_ u_pe_array.g_pe_row\[3\].g_pe_col\[1\].u_pe.psum_out\[10\] u_pe_array.g_pe_row\[3\].g_pe_col\[1\].u_pe.move_reg\[10\]
+ _0855_ VGND VGND VPWR VPWR _1528_ sky130_fd_sc_hd__mux2_1
Xhold168 u_pe_array.g_pe_row\[0\].g_pe_col\[2\].u_pe.move_reg\[9\] VGND VGND VPWR
+ VPWR net244 sky130_fd_sc_hd__dlygate4sd3_1
Xhold157 u_pe_array.g_pe_row\[2\].g_pe_col\[3\].u_pe.move_reg\[8\] VGND VGND VPWR
+ VPWR net233 sky130_fd_sc_hd__dlygate4sd3_1
XFILLER_0_111_497 VGND VGND VPWR VPWR sky130_fd_sc_hd__decap_6
Xhold179 u_pe_array.u_fifo1.buffer\[5\]\[6\] VGND VGND VPWR VPWR net255 sky130_fd_sc_hd__dlygate4sd3_1
X_7164_ clknet_leaf_31_clk net95 net817 VGND VGND VPWR VPWR u_pe_array.g_pe_row\[2\].g_pe_col\[0\].u_pe.w_reg\[0\]
+ sky130_fd_sc_hd__dfrtp_4
X_4376_ _1453_ _1454_ _1467_ _1473_ VGND VGND VPWR VPWR _1476_ sky130_fd_sc_hd__or4b_1
XFILLER_0_0_161 VGND VGND VPWR VPWR sky130_fd_sc_hd__fill_1
XFILLER_0_1_673 VGND VGND VPWR VPWR sky130_fd_sc_hd__decap_4
X_6115_ net761 _0867_ _2923_ _2924_ VGND VGND VPWR VPWR _0434_ sky130_fd_sc_hd__a22o_1
XTAP_440 VGND VPWR sky130_fd_sc_hd__tapvpwrvgnd_1
XTAP_451 VGND VPWR sky130_fd_sc_hd__tapvpwrvgnd_1
X_7095_ clknet_leaf_93_clk _0166_ net819 VGND VGND VPWR VPWR u_pe_array.g_pe_row\[2\].g_pe_col\[2\].u_pe.psum_out\[2\]
+ sky130_fd_sc_hd__dfrtp_1
XTAP_462 VGND VPWR sky130_fd_sc_hd__tapvpwrvgnd_1
XTAP_484 VGND VPWR sky130_fd_sc_hd__tapvpwrvgnd_1
XTAP_473 VGND VPWR sky130_fd_sc_hd__tapvpwrvgnd_1
X_6046_ u_pe_array.g_pe_row\[0\].g_pe_col\[1\].u_pe.psum_out\[9\] u_pe_array.g_pe_row\[0\].g_pe_col\[1\].u_pe.move_reg\[9\]
+ _2469_ VGND VGND VPWR VPWR _2865_ sky130_fd_sc_hd__mux2_1
XANTENNA__5888__S _2469_ VGND VGND VPWR VPWR sky130_fd_sc_hd__diode_2
XTAP_495 VGND VPWR sky130_fd_sc_hd__tapvpwrvgnd_1
XTAP_1606 VGND VPWR sky130_fd_sc_hd__tapvpwrvgnd_1
XTAP_1628 VGND VPWR sky130_fd_sc_hd__tapvpwrvgnd_1
XTAP_1617 VGND VPWR sky130_fd_sc_hd__tapvpwrvgnd_1
XANTENNA_clkbuf_leaf_54_clk_A clknet_3_7__leaf_clk VGND VGND VPWR VPWR sky130_fd_sc_hd__diode_2
X_6948_ clknet_leaf_75_clk _0029_ net815 VGND VGND VPWR VPWR u_pe_array.g_pe_row\[3\].g_pe_col\[3\].u_pe.psum_out\[5\]
+ sky130_fd_sc_hd__dfrtp_1
X_6879_ _3422_ VGND VGND VPWR VPWR _0700_ sky130_fd_sc_hd__clkbuf_1
XANTENNA__3966__B2 _1004_ VGND VGND VPWR VPWR sky130_fd_sc_hd__diode_2
XFILLER_0_64_613 VGND VGND VPWR VPWR sky130_fd_sc_hd__fill_2
XANTENNA__6904__A1 _3126_ VGND VGND VPWR VPWR sky130_fd_sc_hd__diode_2
XANTENNA__6512__S _3208_ VGND VGND VPWR VPWR sky130_fd_sc_hd__diode_2
XFILLER_0_48_197 VGND VGND VPWR VPWR sky130_fd_sc_hd__fill_1
XANTENNA_clkbuf_leaf_69_clk_A clknet_3_5__leaf_clk VGND VGND VPWR VPWR sky130_fd_sc_hd__diode_2
XFILLER_0_8_283 VPWR VGND VPWR VGND sky130_ef_sc_hd__decap_12
XFILLER_0_17_573 VPWR VGND VPWR VGND sky130_ef_sc_hd__decap_12
XFILLER_0_32_521 VGND VGND VPWR VPWR sky130_fd_sc_hd__fill_2
XANTENNA__7365__RESET_B net812 VGND VGND VPWR VPWR sky130_fd_sc_hd__diode_2
XFILLER_0_32_598 VGND VGND VPWR VPWR sky130_fd_sc_hd__fill_1
Xhold680 u_pe_array.g_pe_row\[2\].g_pe_col\[2\].u_pe.psum_out\[2\] VGND VGND VPWR
+ VPWR net756 sky130_fd_sc_hd__dlygate4sd3_1
XFILLER_0_5_3 VPWR VGND VPWR VGND sky130_ef_sc_hd__decap_12
Xhold691 u_pe_array.g_pe_row\[0\].g_pe_col\[0\].u_pe.psum_out\[11\] VGND VGND VPWR
+ VPWR net767 sky130_fd_sc_hd__dlygate4sd3_1
XANTENNA__5891__B2 _0722_ VGND VGND VPWR VPWR sky130_fd_sc_hd__diode_2
XANTENNA__5643__A1 u_pe_array.g_pe_row\[1\].g_pe_col\[0\].u_pe.act_val\[4\] VGND VGND
+ VPWR VPWR sky130_fd_sc_hd__diode_2
XANTENNA__4446__A2 _1524_ VGND VGND VPWR VPWR sky130_fd_sc_hd__diode_2
XFILLER_0_24_26 VGND VGND VPWR VPWR sky130_fd_sc_hd__fill_2
XFILLER_0_39_120 VGND VGND VPWR VPWR sky130_fd_sc_hd__fill_1
XFILLER_0_55_657 VGND VGND VPWR VPWR sky130_fd_sc_hd__fill_2
XFILLER_0_54_145 VPWR VGND VPWR VGND sky130_ef_sc_hd__decap_12
XFILLER_0_39_197 VGND VGND VPWR VPWR sky130_fd_sc_hd__decap_3
XANTENNA__4906__B1 _1534_ VGND VGND VPWR VPWR sky130_fd_sc_hd__diode_2
Xload_slew3 net815 VGND VGND VPWR VPWR net814 sky130_fd_sc_hd__buf_12
XANTENNA__5038__S _1661_ VGND VGND VPWR VPWR sky130_fd_sc_hd__diode_2
XANTENNA__7035__RESET_B net816 VGND VGND VPWR VPWR sky130_fd_sc_hd__diode_2
XANTENNA__3781__S _0745_ VGND VGND VPWR VPWR sky130_fd_sc_hd__diode_2
X_4230_ net72 _1357_ VGND VGND VPWR VPWR _1358_ sky130_fd_sc_hd__or2_1
XANTENNA__4134__A1 u_pe_array.g_pe_row\[3\].g_pe_col\[0\].u_pe.w_reg\[0\] VGND VGND
+ VPWR VPWR sky130_fd_sc_hd__diode_2
X_4161_ _1275_ _1293_ u_pe_array.g_pe_row\[3\].g_pe_col\[0\].u_pe.act_val\[3\] u_pe_array.g_pe_row\[3\].g_pe_col\[0\].u_pe.w_reg\[0\]
+ VGND VGND VPWR VPWR _1294_ sky130_fd_sc_hd__a22o_1
XFILLER_0_65_55 VGND VGND VPWR VPWR sky130_fd_sc_hd__fill_1
XANTENNA__4437__A2 _1392_ VGND VGND VPWR VPWR sky130_fd_sc_hd__diode_2
X_4092_ _1243_ _1244_ VGND VGND VPWR VPWR _1245_ sky130_fd_sc_hd__or2_1
XFILLER_0_77_204 VGND VGND VPWR VPWR sky130_fd_sc_hd__decap_3
X_6802_ _3107_ _3380_ VGND VGND VPWR VPWR _3381_ sky130_fd_sc_hd__and2_1
XANTENNA__5398__B1 _0833_ VGND VGND VPWR VPWR sky130_fd_sc_hd__diode_2
X_4994_ u_pe_array.u_fifo2.buffer\[0\]\[2\] _1962_ VGND VGND VPWR VPWR _1988_ sky130_fd_sc_hd__or2_1
X_3945_ u_pe_array.g_pe_row\[2\].g_pe_col\[0\].u_pe.act_val\[0\] u_pe_array.g_pe_row\[2\].g_pe_col\[0\].u_pe.psum_out\[0\]
+ _0755_ VGND VGND VPWR VPWR _1122_ sky130_fd_sc_hd__mux2_1
X_6733_ net323 _3122_ net64 VGND VGND VPWR VPWR _3345_ sky130_fd_sc_hd__mux2_1
XFILLER_0_85_270 VGND VGND VPWR VPWR sky130_fd_sc_hd__decap_4
XANTENNA__6332__S _3110_ VGND VGND VPWR VPWR sky130_fd_sc_hd__diode_2
X_6664_ _3304_ VGND VGND VPWR VPWR _0603_ sky130_fd_sc_hd__clkbuf_1
X_5615_ _2509_ _2478_ u_pe_array.g_pe_row\[1\].g_pe_col\[0\].u_pe.psum_out\[4\] VGND
+ VGND VPWR VPWR _2510_ sky130_fd_sc_hd__a21oi_1
X_3876_ net682 _0875_ _1061_ _1062_ VGND VGND VPWR VPWR _0057_ sky130_fd_sc_hd__a22o_1
XFILLER_0_83_3 VPWR VGND VPWR VGND sky130_ef_sc_hd__decap_12
XFILLER_0_14_521 VGND VGND VPWR VPWR sky130_fd_sc_hd__decap_8
X_6595_ net325 _1818_ _3254_ VGND VGND VPWR VPWR _3266_ sky130_fd_sc_hd__mux2_1
X_5546_ _2459_ VGND VGND VPWR VPWR _0330_ sky130_fd_sc_hd__clkbuf_1
X_5477_ u_pe_array.g_pe_row\[1\].g_pe_col\[1\].u_pe.w_reg\[0\] u_pe_array.g_pe_row\[1\].g_pe_col\[1\].u_pe.act_val\[5\]
+ _2388_ VGND VGND VPWR VPWR _2398_ sky130_fd_sc_hd__and3_1
XFILLER_0_14_598 VGND VGND VPWR VPWR sky130_fd_sc_hd__fill_1
X_4428_ u_pe_array.g_pe_row\[3\].g_pe_col\[1\].u_pe.psum_out\[2\] u_pe_array.g_pe_row\[3\].g_pe_col\[1\].u_pe.act_val\[2\]
+ _0769_ VGND VGND VPWR VPWR _1519_ sky130_fd_sc_hd__mux2_1
XANTENNA__5322__B1 _2158_ VGND VGND VPWR VPWR sky130_fd_sc_hd__diode_2
X_7216_ clknet_leaf_53_clk _0281_ net75 VGND VGND VPWR VPWR u_pe_array.g_pe_row\[1\].g_pe_col\[1\].u_pe.act_val\[5\]
+ sky130_fd_sc_hd__dfrtp_2
XANTENNA__4125__B2 _1004_ VGND VGND VPWR VPWR sky130_fd_sc_hd__diode_2
XANTENNA__5903__C _2743_ VGND VGND VPWR VPWR sky130_fd_sc_hd__diode_2
X_7147_ clknet_leaf_93_clk _0216_ VGND VGND VPWR VPWR u_pe_array.u_fifo2.buffer\[8\]\[11\]
+ sky130_fd_sc_hd__dfxtp_1
X_4359_ u_pe_array.g_pe_row\[2\].g_pe_col\[3\].u_pe.act_val\[5\] VGND VGND VPWR VPWR
+ _1461_ sky130_fd_sc_hd__inv_2
X_7078_ clknet_leaf_15_clk _0151_ net816 VGND VGND VPWR VPWR u_pe_array.g_pe_row\[2\].g_pe_col\[1\].u_pe.act_val\[0\]
+ sky130_fd_sc_hd__dfrtp_2
XTAP_292 VGND VPWR sky130_fd_sc_hd__tapvpwrvgnd_1
XTAP_270 VGND VPWR sky130_fd_sc_hd__tapvpwrvgnd_1
XTAP_281 VGND VPWR sky130_fd_sc_hd__tapvpwrvgnd_1
X_6029_ net741 _2738_ _2592_ _2856_ VGND VGND VPWR VPWR _0416_ sky130_fd_sc_hd__a22o_1
XTAP_1414 VGND VPWR sky130_fd_sc_hd__tapvpwrvgnd_1
XTAP_1403 VGND VPWR sky130_fd_sc_hd__tapvpwrvgnd_1
XFILLER_0_68_226 VGND VGND VPWR VPWR sky130_fd_sc_hd__fill_2
XTAP_1436 VGND VPWR sky130_fd_sc_hd__tapvpwrvgnd_1
XTAP_1447 VGND VPWR sky130_fd_sc_hd__tapvpwrvgnd_1
XTAP_1425 VGND VPWR sky130_fd_sc_hd__tapvpwrvgnd_1
XANTENNA__5389__B1 _0833_ VGND VGND VPWR VPWR sky130_fd_sc_hd__diode_2
XTAP_1469 VGND VPWR sky130_fd_sc_hd__tapvpwrvgnd_1
XTAP_1458 VGND VPWR sky130_fd_sc_hd__tapvpwrvgnd_1
XFILLER_0_107_512 VGND VGND VPWR VPWR sky130_fd_sc_hd__fill_2
XFILLER_0_76_292 VGND VGND VPWR VPWR sky130_fd_sc_hd__decap_3
XFILLER_0_64_421 VGND VGND VPWR VPWR sky130_fd_sc_hd__decap_6
XANTENNA__4600__A2 _1524_ VGND VGND VPWR VPWR sky130_fd_sc_hd__diode_2
Xfanout74 net13 VGND VGND VPWR VPWR net74 sky130_fd_sc_hd__buf_12
XFILLER_0_51_104 VGND VGND VPWR VPWR sky130_fd_sc_hd__fill_2
XANTENNA__7546__RESET_B net815 VGND VGND VPWR VPWR sky130_fd_sc_hd__diode_2
XFILLER_0_24_307 VGND VGND VPWR VPWR sky130_fd_sc_hd__fill_1
XFILLER_0_36_178 VGND VGND VPWR VPWR sky130_fd_sc_hd__fill_2
XANTENNA__5085__C _2029_ VGND VGND VPWR VPWR sky130_fd_sc_hd__diode_2
XANTENNA__5561__B1 _1655_ VGND VGND VPWR VPWR sky130_fd_sc_hd__diode_2
XFILLER_0_32_351 VGND VGND VPWR VPWR sky130_fd_sc_hd__fill_2
XFILLER_0_20_524 VGND VGND VPWR VPWR sky130_fd_sc_hd__decap_3
XFILLER_0_20_568 VGND VGND VPWR VPWR sky130_fd_sc_hd__fill_1
XFILLER_0_19_48 VGND VGND VPWR VPWR sky130_fd_sc_hd__fill_1
XANTENNA__3875__B1 _0885_ VGND VGND VPWR VPWR sky130_fd_sc_hd__diode_2
XANTENNA__4726__A _1672_ VGND VGND VPWR VPWR sky130_fd_sc_hd__diode_2
XANTENNA__4419__A2 _1152_ VGND VGND VPWR VPWR sky130_fd_sc_hd__diode_2
XANTENNA__6041__B2 _0722_ VGND VGND VPWR VPWR sky130_fd_sc_hd__diode_2
XFILLER_0_67_281 VPWR VGND VPWR VGND sky130_ef_sc_hd__decap_12
XFILLER_0_51_57 VGND VGND VPWR VPWR sky130_fd_sc_hd__fill_2
XFILLER_0_7_529 VPWR VGND VPWR VGND sky130_ef_sc_hd__decap_12
X_3730_ _0942_ u_pe_array.g_pe_row\[3\].g_pe_col\[3\].u_pe.psum_out\[7\] _0928_ VGND
+ VGND VPWR VPWR _0943_ sky130_fd_sc_hd__mux2_1
XANTENNA__7287__RESET_B net813 VGND VGND VPWR VPWR sky130_fd_sc_hd__diode_2
XANTENNA__5276__B _2158_ VGND VGND VPWR VPWR sky130_fd_sc_hd__diode_2
XANTENNA__7216__RESET_B net75 VGND VGND VPWR VPWR sky130_fd_sc_hd__diode_2
XFILLER_0_55_498 VGND VGND VPWR VPWR sky130_fd_sc_hd__fill_2
X_3661_ u_pe_array.g_pe_row\[3\].g_pe_col\[3\].u_pe.act_val\[2\] u_pe_array.g_pe_row\[3\].g_pe_col\[3\].u_pe.w_reg\[0\]
+ VGND VGND VPWR VPWR _0879_ sky130_fd_sc_hd__nand2_1
XFILLER_0_27_189 VGND VGND VPWR VPWR sky130_fd_sc_hd__fill_2
X_5400_ net121 _2144_ _2333_ _1665_ VGND VGND VPWR VPWR _0310_ sky130_fd_sc_hd__a22o_1
X_3592_ _0783_ _0778_ _0791_ _0802_ VGND VGND VPWR VPWR _0827_ sky130_fd_sc_hd__a31o_4
X_6380_ u_pe_array.u_fifo2.rd_ptr\[0\] _3146_ _3147_ VGND VGND VPWR VPWR _0476_ sky130_fd_sc_hd__o21a_1
XANTENNA__5552__B1 _1655_ VGND VGND VPWR VPWR sky130_fd_sc_hd__diode_2
XFILLER_0_113_559 VGND VGND VPWR VPWR sky130_fd_sc_hd__fill_1
X_5331_ u_pe_array.u_fifo1.rd_ptr\[3\] VGND VGND VPWR VPWR _2271_ sky130_fd_sc_hd__inv_2
XFILLER_0_11_502 VGND VGND VPWR VPWR sky130_fd_sc_hd__fill_2
XFILLER_0_2_245 VGND VGND VPWR VPWR sky130_fd_sc_hd__decap_6
XANTENNA__5304__B1 _2158_ VGND VGND VPWR VPWR sky130_fd_sc_hd__diode_2
XFILLER_0_11_557 VGND VGND VPWR VPWR sky130_fd_sc_hd__fill_1
XFILLER_0_76_21 VGND VGND VPWR VPWR sky130_fd_sc_hd__decap_3
X_7001_ clknet_leaf_15_clk net79 net816 VGND VGND VPWR VPWR u_pe_array.g_pe_row\[3\].g_pe_col\[1\].u_pe.w_reg\[0\]
+ sky130_fd_sc_hd__dfrtp_4
X_5262_ u_pe_array.g_pe_row\[1\].g_pe_col\[2\].u_pe.act_val\[5\] VGND VGND VPWR VPWR
+ _2211_ sky130_fd_sc_hd__inv_2
XFILLER_0_11_568 VPWR VGND VPWR VGND sky130_ef_sc_hd__decap_12
X_4213_ _1341_ u_pe_array.g_pe_row\[3\].g_pe_col\[0\].u_pe.psum_out\[7\] _1330_ VGND
+ VGND VPWR VPWR _1342_ sky130_fd_sc_hd__mux2_1
X_5193_ u_pe_array.g_pe_row\[1\].g_pe_col\[2\].u_pe.psum_out\[10\] u_pe_array.g_pe_row\[1\].g_pe_col\[2\].u_pe.move_reg\[10\]
+ _1661_ VGND VGND VPWR VPWR _2151_ sky130_fd_sc_hd__mux2_1
X_4144_ u_pe_array.g_pe_row\[3\].g_pe_col\[0\].u_pe.psum_out\[1\] _1278_ VGND VGND
+ VPWR VPWR _1279_ sky130_fd_sc_hd__or2_1
XANTENNA__3618__A0 net25 VGND VGND VPWR VPWR sky130_fd_sc_hd__diode_2
X_4075_ _1228_ _1229_ VGND VGND VPWR VPWR _1230_ sky130_fd_sc_hd__nor2_1
XFILLER_0_93_505 VGND VGND VPWR VPWR sky130_fd_sc_hd__decap_3
XFILLER_0_78_568 VGND VGND VPWR VPWR sky130_fd_sc_hd__decap_4
XFILLER_0_78_557 VGND VGND VPWR VPWR sky130_fd_sc_hd__fill_2
Xclkbuf_leaf_90_clk clknet_3_1__leaf_clk VGND VGND VPWR VPWR clknet_leaf_90_clk sky130_fd_sc_hd__clkbuf_16
XFILLER_0_19_613 VGND VGND VPWR VPWR sky130_fd_sc_hd__decap_3
XFILLER_0_19_624 VGND VGND VPWR VPWR sky130_fd_sc_hd__fill_2
XFILLER_0_108_309 VPWR VGND VPWR VGND sky130_ef_sc_hd__decap_12
X_6716_ net292 _3132_ net66 VGND VGND VPWR VPWR _3336_ sky130_fd_sc_hd__mux2_1
XFILLER_0_93_549 VGND VGND VPWR VPWR sky130_fd_sc_hd__fill_2
XANTENNA__5467__A u_pe_array.g_pe_row\[1\].g_pe_col\[1\].u_pe.w_reg\[0\] VGND VGND
+ VPWR VPWR sky130_fd_sc_hd__diode_2
XANTENNA__4371__A _1407_ VGND VGND VPWR VPWR sky130_fd_sc_hd__diode_2
XFILLER_0_19_635 VGND VGND VPWR VPWR sky130_fd_sc_hd__fill_2
XFILLER_0_19_657 VGND VGND VPWR VPWR sky130_fd_sc_hd__fill_2
X_4977_ _1960_ _1961_ VGND VGND VPWR VPWR _1973_ sky130_fd_sc_hd__nor2_2
X_3928_ _0864_ _1108_ _1109_ _0867_ net685 VGND VGND VPWR VPWR _0062_ sky130_fd_sc_hd__a32o_1
XFILLER_0_104_504 VGND VGND VPWR VPWR sky130_fd_sc_hd__decap_3
XANTENNA__5617__D u_pe_array.g_pe_row\[1\].g_pe_col\[0\].u_pe.w_reg\[0\] VGND VGND
+ VPWR VPWR sky130_fd_sc_hd__diode_2
XANTENNA__4090__B _1145_ VGND VGND VPWR VPWR sky130_fd_sc_hd__diode_2
X_3859_ _1045_ _1046_ VGND VGND VPWR VPWR _1047_ sky130_fd_sc_hd__nand2_1
X_6647_ net595 _0833_ VGND VGND VPWR VPWR _3293_ sky130_fd_sc_hd__and2_1
XFILLER_0_104_515 VGND VGND VPWR VPWR sky130_fd_sc_hd__fill_2
X_6578_ _3257_ VGND VGND VPWR VPWR _0564_ sky130_fd_sc_hd__clkbuf_1
X_5529_ _2437_ _2439_ _2445_ VGND VGND VPWR VPWR _2446_ sky130_fd_sc_hd__and3_1
XFILLER_0_14_384 VGND VGND VPWR VPWR sky130_fd_sc_hd__decap_4
XANTENNA__5406__S _1661_ VGND VGND VPWR VPWR sky130_fd_sc_hd__diode_2
XANTENNA__6939__RESET_B net74 VGND VGND VPWR VPWR sky130_fd_sc_hd__diode_2
XFILLER_0_112_581 VGND VGND VPWR VPWR sky130_fd_sc_hd__decap_6
XANTENNA__3609__A0 net22 VGND VGND VPWR VPWR sky130_fd_sc_hd__diode_2
XFILLER_0_96_321 VPWR VGND VPWR VGND sky130_ef_sc_hd__decap_12
XTAP_1222 VGND VPWR sky130_fd_sc_hd__tapvpwrvgnd_1
XTAP_1200 VGND VPWR sky130_fd_sc_hd__tapvpwrvgnd_1
XTAP_1211 VGND VPWR sky130_fd_sc_hd__tapvpwrvgnd_1
XFILLER_0_69_557 VGND VGND VPWR VPWR sky130_fd_sc_hd__decap_3
XFILLER_0_96_376 VGND VGND VPWR VPWR sky130_fd_sc_hd__decap_4
XTAP_1266 VGND VPWR sky130_fd_sc_hd__tapvpwrvgnd_1
XTAP_1255 VGND VPWR sky130_fd_sc_hd__tapvpwrvgnd_1
XTAP_1244 VGND VPWR sky130_fd_sc_hd__tapvpwrvgnd_1
XTAP_1233 VGND VPWR sky130_fd_sc_hd__tapvpwrvgnd_1
Xclkbuf_leaf_81_clk clknet_3_4__leaf_clk VGND VGND VPWR VPWR clknet_leaf_81_clk sky130_fd_sc_hd__clkbuf_16
XTAP_1299 VGND VPWR sky130_fd_sc_hd__tapvpwrvgnd_1
XTAP_1288 VGND VPWR sky130_fd_sc_hd__tapvpwrvgnd_1
XTAP_1277 VGND VPWR sky130_fd_sc_hd__tapvpwrvgnd_1
XANTENNA__3596__S _0828_ VGND VGND VPWR VPWR sky130_fd_sc_hd__diode_2
XFILLER_0_112_29 VPWR VGND VPWR VGND sky130_ef_sc_hd__decap_12
XANTENNA__7380__RESET_B net812 VGND VGND VPWR VPWR sky130_fd_sc_hd__diode_2
XFILLER_0_92_560 VGND VGND VPWR VPWR sky130_fd_sc_hd__fill_1
XFILLER_0_64_251 VGND VGND VPWR VPWR sky130_fd_sc_hd__fill_1
XFILLER_0_92_593 VGND VGND VPWR VPWR sky130_fd_sc_hd__fill_2
XFILLER_0_21_49 VGND VGND VPWR VPWR sky130_fd_sc_hd__fill_2
XFILLER_0_110_507 VPWR VGND VPWR VGND sky130_ef_sc_hd__decap_12
XFILLER_0_20_398 VGND VGND VPWR VPWR sky130_fd_sc_hd__fill_2
XANTENNA_output50_A net50 VGND VGND VPWR VPWR sky130_fd_sc_hd__diode_2
XFILLER_0_1_15 VPWR VGND VPWR VGND sky130_ef_sc_hd__decap_12
X_4900_ _1902_ _1904_ VGND VGND VPWR VPWR _1905_ sky130_fd_sc_hd__xnor2_1
XFILLER_0_99_192 VGND VGND VPWR VPWR sky130_fd_sc_hd__fill_2
X_5880_ u_pe_array.g_pe_row\[1\].g_pe_col\[1\].u_pe.act_val\[5\] u_pe_array.g_pe_row\[1\].g_pe_col\[1\].u_pe.psum_out\[5\]
+ _0770_ VGND VGND VPWR VPWR _2731_ sky130_fd_sc_hd__mux2_1
XFILLER_0_75_505 VGND VGND VPWR VPWR sky130_fd_sc_hd__fill_2
Xclkbuf_leaf_72_clk clknet_3_5__leaf_clk VGND VGND VPWR VPWR clknet_leaf_72_clk sky130_fd_sc_hd__clkbuf_16
X_4831_ _1842_ VGND VGND VPWR VPWR _0232_ sky130_fd_sc_hd__clkbuf_1
XFILLER_0_28_421 VGND VGND VPWR VPWR sky130_fd_sc_hd__fill_1
X_4762_ _1799_ VGND VGND VPWR VPWR _0206_ sky130_fd_sc_hd__clkbuf_1
XANTENNA__4576__A1 _1273_ VGND VGND VPWR VPWR sky130_fd_sc_hd__diode_2
X_7550_ clknet_leaf_80_clk _0599_ net74 VGND VGND VPWR VPWR u_pe_array.g_pe_row\[3\].g_pe_col\[3\].u_pe.move_reg\[11\]
+ sky130_fd_sc_hd__dfrtp_1
XANTENNA__5773__B1 _2174_ VGND VGND VPWR VPWR sky130_fd_sc_hd__diode_2
XANTENNA__6317__A2 _0867_ VGND VGND VPWR VPWR sky130_fd_sc_hd__diode_2
XANTENNA__3519__B _0770_ VGND VGND VPWR VPWR sky130_fd_sc_hd__diode_2
X_4693_ _1738_ VGND VGND VPWR VPWR _1739_ sky130_fd_sc_hd__inv_2
X_7481_ clknet_leaf_6_clk _0530_ VGND VGND VPWR VPWR u_pe_array.u_fifo2.buffer\[3\]\[7\]
+ sky130_fd_sc_hd__dfxtp_1
XFILLER_0_7_359 VGND VGND VPWR VPWR sky130_fd_sc_hd__fill_2
XANTENNA__7050__RESET_B net819 VGND VGND VPWR VPWR sky130_fd_sc_hd__diode_2
X_6501_ _3215_ VGND VGND VPWR VPWR _0529_ sky130_fd_sc_hd__clkbuf_1
X_3713_ u_pe_array.g_pe_row\[3\].g_pe_col\[3\].u_pe.act_val\[5\] VGND VGND VPWR VPWR
+ _0927_ sky130_fd_sc_hd__inv_2
X_3644_ _0863_ VGND VGND VPWR VPWR _0864_ sky130_fd_sc_hd__buf_8
X_6432_ _3179_ VGND VGND VPWR VPWR _0496_ sky130_fd_sc_hd__clkbuf_1
XFILLER_0_43_457 VGND VGND VPWR VPWR sky130_fd_sc_hd__fill_2
XFILLER_0_15_148 VGND VGND VPWR VPWR sky130_fd_sc_hd__fill_2
X_6363_ _3135_ VGND VGND VPWR VPWR _0471_ sky130_fd_sc_hd__clkbuf_1
X_3575_ _0717_ _0719_ VGND VGND VPWR VPWR _0815_ sky130_fd_sc_hd__nor2_1
XFILLER_0_23_181 VGND VGND VPWR VPWR sky130_fd_sc_hd__decap_4
X_6294_ _3074_ _3077_ _3082_ VGND VGND VPWR VPWR _3083_ sky130_fd_sc_hd__o21ai_1
X_5314_ _0863_ VGND VGND VPWR VPWR _2258_ sky130_fd_sc_hd__buf_8
XANTENNA__4130__S _0855_ VGND VGND VPWR VPWR sky130_fd_sc_hd__diode_2
X_5245_ _2193_ _2194_ _2195_ VGND VGND VPWR VPWR _2196_ sky130_fd_sc_hd__and3_1
XFILLER_0_11_387 VGND VGND VPWR VPWR sky130_fd_sc_hd__decap_4
Xhold17 u_pe_array.g_pe_row\[2\].g_pe_col\[0\].u_pe.w_buffer\[1\] VGND VGND VPWR VPWR
+ net93 sky130_fd_sc_hd__dlygate4sd3_1
XFILLER_0_46_3 VGND VGND VPWR VPWR sky130_fd_sc_hd__decap_3
Xhold28 u_pe_array.g_pe_row\[0\].g_pe_col\[3\].u_pe.w_buffer\[1\] VGND VGND VPWR VPWR
+ net104 sky130_fd_sc_hd__dlygate4sd3_1
X_5176_ _0761_ _1828_ _0747_ VGND VGND VPWR VPWR _2142_ sky130_fd_sc_hd__mux2_1
Xhold39 u_pe_array.g_pe_row\[1\].g_pe_col\[0\].u_pe.move_reg\[11\] VGND VGND VPWR
+ VPWR net115 sky130_fd_sc_hd__dlygate4sd3_1
X_4127_ net227 _1138_ _1266_ _1004_ VGND VGND VPWR VPWR _0104_ sky130_fd_sc_hd__a22o_1
XANTENNA__4264__B1 _0887_ VGND VGND VPWR VPWR sky130_fd_sc_hd__diode_2
X_4058_ _0864_ _1213_ _1214_ _1144_ net785 VGND VGND VPWR VPWR _0087_ sky130_fd_sc_hd__a32o_1
XFILLER_0_66_505 VGND VGND VPWR VPWR sky130_fd_sc_hd__fill_2
Xclkbuf_leaf_63_clk clknet_3_5__leaf_clk VGND VGND VPWR VPWR clknet_leaf_63_clk sky130_fd_sc_hd__clkbuf_16
XFILLER_0_109_629 VPWR VGND VPWR VGND sky130_ef_sc_hd__decap_12
XFILLER_0_93_346 VGND VGND VPWR VPWR sky130_fd_sc_hd__decap_6
XFILLER_0_93_368 VGND VGND VPWR VPWR sky130_fd_sc_hd__decap_4
XFILLER_0_74_560 VGND VGND VPWR VPWR sky130_fd_sc_hd__fill_2
XFILLER_0_74_593 VGND VGND VPWR VPWR sky130_fd_sc_hd__fill_2
XFILLER_0_74_571 VGND VGND VPWR VPWR sky130_fd_sc_hd__fill_2
XFILLER_0_19_498 VGND VGND VPWR VPWR sky130_fd_sc_hd__fill_2
XFILLER_0_104_301 VGND VGND VPWR VPWR sky130_fd_sc_hd__fill_2
XFILLER_0_61_232 VGND VGND VPWR VPWR sky130_fd_sc_hd__decap_4
XFILLER_0_14_192 VGND VGND VPWR VPWR sky130_fd_sc_hd__fill_2
XFILLER_0_30_630 VGND VGND VPWR VPWR sky130_fd_sc_hd__decap_3
XFILLER_0_30_641 VGND VGND VPWR VPWR sky130_fd_sc_hd__decap_3
XFILLER_0_100_540 VGND VGND VPWR VPWR sky130_fd_sc_hd__fill_2
XFILLER_0_84_313 VGND VGND VPWR VPWR sky130_fd_sc_hd__fill_1
Xclkbuf_leaf_54_clk clknet_3_7__leaf_clk VGND VGND VPWR VPWR clknet_leaf_54_clk sky130_fd_sc_hd__clkbuf_16
XTAP_1030 VGND VPWR sky130_fd_sc_hd__tapvpwrvgnd_1
XANTENNA__7561__RESET_B net816 VGND VGND VPWR VPWR sky130_fd_sc_hd__diode_2
XFILLER_0_57_505 VGND VGND VPWR VPWR sky130_fd_sc_hd__decap_8
XFILLER_0_96_184 VGND VGND VPWR VPWR sky130_fd_sc_hd__fill_2
XFILLER_0_84_346 VGND VGND VPWR VPWR sky130_fd_sc_hd__fill_2
XFILLER_0_84_324 VGND VGND VPWR VPWR sky130_fd_sc_hd__fill_2
XTAP_1074 VGND VPWR sky130_fd_sc_hd__tapvpwrvgnd_1
XTAP_1063 VGND VPWR sky130_fd_sc_hd__tapvpwrvgnd_1
XTAP_1041 VGND VPWR sky130_fd_sc_hd__tapvpwrvgnd_1
XTAP_1052 VGND VPWR sky130_fd_sc_hd__tapvpwrvgnd_1
XTAP_1096 VGND VPWR sky130_fd_sc_hd__tapvpwrvgnd_1
XTAP_1085 VGND VPWR sky130_fd_sc_hd__tapvpwrvgnd_1
XFILLER_0_52_232 VGND VGND VPWR VPWR sky130_fd_sc_hd__fill_2
XANTENNA__3518__C1 _0754_ VGND VGND VPWR VPWR sky130_fd_sc_hd__diode_2
Xhold509 u_pe_array.g_pe_row\[3\].g_pe_col\[1\].u_pe.psum_out\[9\] VGND VGND VPWR
+ VPWR net585 sky130_fd_sc_hd__dlygate4sd3_1
XFILLER_0_110_304 VGND VGND VPWR VPWR sky130_fd_sc_hd__decap_4
XFILLER_0_40_449 VGND VGND VPWR VPWR sky130_fd_sc_hd__fill_2
XTAP_825 VGND VPWR sky130_fd_sc_hd__tapvpwrvgnd_1
XTAP_803 VGND VPWR sky130_fd_sc_hd__tapvpwrvgnd_1
XTAP_814 VGND VPWR sky130_fd_sc_hd__tapvpwrvgnd_1
XFILLER_0_20_184 VGND VGND VPWR VPWR sky130_fd_sc_hd__decap_3
XTAP_858 VGND VPWR sky130_fd_sc_hd__tapvpwrvgnd_1
XTAP_847 VGND VPWR sky130_fd_sc_hd__tapvpwrvgnd_1
XTAP_836 VGND VPWR sky130_fd_sc_hd__tapvpwrvgnd_1
X_5030_ u_pe_array.g_pe_row\[0\].g_pe_col\[2\].u_pe.psum_out\[6\] u_pe_array.g_pe_row\[0\].g_pe_col\[2\].u_pe.move_reg\[6\]
+ _1661_ VGND VGND VPWR VPWR _2020_ sky130_fd_sc_hd__mux2_1
XFILLER_0_20_195 VGND VGND VPWR VPWR sky130_fd_sc_hd__fill_1
XANTENNA__6483__A1 _1818_ VGND VGND VPWR VPWR sky130_fd_sc_hd__diode_2
XTAP_869 VGND VPWR sky130_fd_sc_hd__tapvpwrvgnd_1
XANTENNA__4186__A u_pe_array.g_pe_row\[3\].g_pe_col\[0\].u_pe.w_reg\[0\] VGND VGND
+ VPWR VPWR sky130_fd_sc_hd__diode_2
XFILLER_0_79_129 VGND VGND VPWR VPWR sky130_fd_sc_hd__fill_2
X_6981_ clknet_leaf_10_clk _0060_ net74 VGND VGND VPWR VPWR u_pe_array.g_pe_row\[3\].g_pe_col\[2\].u_pe.psum_out\[8\]
+ sky130_fd_sc_hd__dfrtp_2
XFILLER_0_73_88 VGND VGND VPWR VPWR sky130_fd_sc_hd__decap_3
XFILLER_0_73_66 VGND VGND VPWR VPWR sky130_fd_sc_hd__decap_6
XFILLER_0_18_7 VGND VGND VPWR VPWR sky130_fd_sc_hd__decap_8
XANTENNA__6605__S _3269_ VGND VGND VPWR VPWR sky130_fd_sc_hd__diode_2
X_5932_ _2760_ _2769_ _2771_ VGND VGND VPWR VPWR _2772_ sky130_fd_sc_hd__or3_1
Xclkbuf_leaf_45_clk clknet_3_7__leaf_clk VGND VGND VPWR VPWR clknet_leaf_45_clk sky130_fd_sc_hd__clkbuf_16
XANTENNA__5994__B1 _0913_ VGND VGND VPWR VPWR sky130_fd_sc_hd__diode_2
XFILLER_0_75_335 VGND VGND VPWR VPWR sky130_fd_sc_hd__fill_1
XANTENNA__7231__RESET_B net73 VGND VGND VPWR VPWR sky130_fd_sc_hd__diode_2
XFILLER_0_8_613 VPWR VGND VPWR VGND sky130_ef_sc_hd__decap_12
X_5863_ u_pe_array.g_pe_row\[0\].g_pe_col\[3\].u_pe.psum_out\[12\] _2713_ VGND VGND
+ VPWR VPWR _2722_ sky130_fd_sc_hd__xor2_1
X_7602_ clknet_leaf_27_clk _0651_ VGND VGND VPWR VPWR u_pe_array.u_fifo1.buffer\[2\]\[12\]
+ sky130_fd_sc_hd__dfxtp_1
X_4814_ net597 _1666_ _1655_ _1833_ VGND VGND VPWR VPWR _0224_ sky130_fd_sc_hd__a22o_1
X_5794_ _2658_ _2659_ VGND VGND VPWR VPWR _2660_ sky130_fd_sc_hd__and2b_1
X_4745_ u_pe_array.g_pe_row\[2\].g_pe_col\[1\].u_pe.psum_out\[12\] _1776_ VGND VGND
+ VPWR VPWR _1785_ sky130_fd_sc_hd__xor2_1
X_7533_ clknet_leaf_6_clk _0582_ VGND VGND VPWR VPWR u_pe_array.u_fifo2.buffer\[7\]\[7\]
+ sky130_fd_sc_hd__dfxtp_1
XFILLER_0_8_657 VPWR VGND VPWR VGND sky130_ef_sc_hd__decap_12
XFILLER_0_90_349 VGND VGND VPWR VPWR sky130_fd_sc_hd__fill_2
XFILLER_0_83_390 VGND VGND VPWR VPWR sky130_fd_sc_hd__fill_2
XFILLER_0_71_552 VGND VGND VPWR VPWR sky130_fd_sc_hd__fill_2
XFILLER_0_7_167 VGND VGND VPWR VPWR sky130_fd_sc_hd__fill_1
XFILLER_0_114_654 VPWR VGND VPWR VGND sky130_ef_sc_hd__decap_12
XFILLER_0_98_41 VGND VGND VPWR VPWR sky130_fd_sc_hd__decap_6
X_4676_ _1709_ _1712_ _1722_ VGND VGND VPWR VPWR _1723_ sky130_fd_sc_hd__o21ai_1
X_7464_ clknet_leaf_5_clk _0513_ VGND VGND VPWR VPWR u_pe_array.u_fifo2.buffer\[2\]\[3\]
+ sky130_fd_sc_hd__dfxtp_1
XFILLER_0_31_405 VGND VGND VPWR VPWR sky130_fd_sc_hd__fill_2
XFILLER_0_113_164 VGND VGND VPWR VPWR sky130_fd_sc_hd__fill_1
X_7395_ clknet_leaf_43_clk net102 net817 VGND VGND VPWR VPWR u_pe_array.g_pe_row\[0\].g_pe_col\[0\].u_pe.w_reg\[1\]
+ sky130_fd_sc_hd__dfrtp_1
XFILLER_0_101_304 VGND VGND VPWR VPWR sky130_fd_sc_hd__fill_1
X_3627_ u_pe_array.g_pe_row\[2\].g_pe_col\[2\].u_pe.psum_out\[8\] u_pe_array.g_pe_row\[2\].g_pe_col\[2\].u_pe.move_reg\[8\]
+ _0734_ VGND VGND VPWR VPWR _0852_ sky130_fd_sc_hd__mux2_1
X_6415_ net431 _1804_ net70 VGND VGND VPWR VPWR _3171_ sky130_fd_sc_hd__mux2_1
XFILLER_0_31_449 VGND VGND VPWR VPWR sky130_fd_sc_hd__fill_2
X_6346_ _1787_ _1135_ net59 VGND VGND VPWR VPWR _3124_ sky130_fd_sc_hd__a21o_2
XANTENNA__3524__A2 _0769_ VGND VGND VPWR VPWR sky130_fd_sc_hd__diode_2
XANTENNA__4721__A1 _1725_ VGND VGND VPWR VPWR sky130_fd_sc_hd__diode_2
X_3558_ _0795_ _0796_ VGND VGND VPWR VPWR _0803_ sky130_fd_sc_hd__or2b_1
XFILLER_0_3_384 VGND VGND VPWR VPWR sky130_fd_sc_hd__fill_2
X_6277_ _3032_ _3033_ _3066_ VGND VGND VPWR VPWR _3067_ sky130_fd_sc_hd__or3_1
X_3489_ u_pe_array.g_pe_row\[3\].g_pe_col\[0\].u_pe.psum_out\[11\] _0745_ _0752_ _0728_
+ VGND VGND VPWR VPWR net51 sky130_fd_sc_hd__o211a_2
XANTENNA__5480__A _2345_ VGND VGND VPWR VPWR sky130_fd_sc_hd__diode_2
X_5228_ _2179_ VGND VGND VPWR VPWR _2180_ sky130_fd_sc_hd__inv_2
X_5159_ u_pe_array.g_pe_row\[1\].g_pe_col\[3\].u_pe.psum_out\[10\] _2127_ _2130_ VGND
+ VGND VPWR VPWR _2131_ sky130_fd_sc_hd__a21oi_1
XANTENNA__5029__A2 _2017_ VGND VGND VPWR VPWR sky130_fd_sc_hd__diode_2
XANTENNA__7319__RESET_B net814 VGND VGND VPWR VPWR sky130_fd_sc_hd__diode_2
Xclkbuf_leaf_36_clk clknet_3_3__leaf_clk VGND VGND VPWR VPWR clknet_leaf_36_clk sky130_fd_sc_hd__clkbuf_16
XPHY_124 VGND VGND VPWR VPWR sky130_fd_sc_hd__decap_3
XPHY_113 VGND VGND VPWR VPWR sky130_fd_sc_hd__decap_3
XPHY_102 VGND VGND VPWR VPWR sky130_fd_sc_hd__decap_3
XPHY_157 VGND VGND VPWR VPWR sky130_fd_sc_hd__decap_3
XPHY_146 VGND VGND VPWR VPWR sky130_fd_sc_hd__decap_3
XPHY_135 VGND VGND VPWR VPWR sky130_fd_sc_hd__decap_3
XPHY_179 VGND VGND VPWR VPWR sky130_fd_sc_hd__decap_3
XPHY_168 VGND VGND VPWR VPWR sky130_fd_sc_hd__decap_3
XFILLER_0_47_582 VGND VGND VPWR VPWR sky130_fd_sc_hd__decap_6
XFILLER_0_34_210 VGND VGND VPWR VPWR sky130_fd_sc_hd__fill_2
XANTENNA__6954__RESET_B net815 VGND VGND VPWR VPWR sky130_fd_sc_hd__diode_2
XFILLER_0_105_665 VGND VGND VPWR VPWR sky130_fd_sc_hd__decap_6
XFILLER_0_22_449 VGND VGND VPWR VPWR sky130_fd_sc_hd__fill_2
XFILLER_0_30_482 VGND VGND VPWR VPWR sky130_fd_sc_hd__fill_1
XFILLER_0_30_493 VGND VGND VPWR VPWR sky130_fd_sc_hd__fill_2
XFILLER_0_100_392 VGND VGND VPWR VPWR sky130_fd_sc_hd__fill_1
XFILLER_0_89_449 VGND VGND VPWR VPWR sky130_fd_sc_hd__fill_2
Xclkbuf_leaf_27_clk clknet_3_2__leaf_clk VGND VGND VPWR VPWR clknet_leaf_27_clk sky130_fd_sc_hd__clkbuf_16
Xmax_cap71 _0913_ VGND VGND VPWR VPWR net71 sky130_fd_sc_hd__buf_4
XFILLER_0_43_36 VGND VGND VPWR VPWR sky130_fd_sc_hd__fill_2
XFILLER_0_97_493 VGND VGND VPWR VPWR sky130_fd_sc_hd__fill_1
XFILLER_0_85_644 VGND VGND VPWR VPWR sky130_fd_sc_hd__fill_2
XFILLER_0_85_633 VGND VGND VPWR VPWR sky130_fd_sc_hd__fill_2
XFILLER_0_43_69 VGND VGND VPWR VPWR sky130_fd_sc_hd__fill_1
XPHY_4 VGND VGND VPWR VPWR sky130_fd_sc_hd__decap_3
XANTENNA__3784__S _0745_ VGND VGND VPWR VPWR sky130_fd_sc_hd__diode_2
XFILLER_0_104_3 VPWR VGND VPWR VGND sky130_ef_sc_hd__decap_12
XFILLER_0_13_405 VGND VGND VPWR VPWR sky130_fd_sc_hd__fill_2
X_4530_ _1602_ u_pe_array.g_pe_row\[2\].g_pe_col\[2\].u_pe.psum_out\[7\] _1591_ VGND
+ VGND VPWR VPWR _1603_ sky130_fd_sc_hd__mux2_1
XANTENNA__3754__A2 _0875_ VGND VGND VPWR VPWR sky130_fd_sc_hd__diode_2
Xhold317 u_pe_array.g_pe_row\[1\].g_pe_col\[1\].u_pe.move_reg\[8\] VGND VGND VPWR
+ VPWR net393 sky130_fd_sc_hd__dlygate4sd3_1
Xhold306 _0282_ VGND VGND VPWR VPWR net382 sky130_fd_sc_hd__dlygate4sd3_1
X_4461_ u_pe_array.g_pe_row\[2\].g_pe_col\[2\].u_pe.psum_out\[1\] _1539_ VGND VGND
+ VPWR VPWR _1540_ sky130_fd_sc_hd__or2_1
XFILLER_0_13_449 VGND VGND VPWR VPWR sky130_fd_sc_hd__fill_2
XFILLER_0_25_298 VGND VGND VPWR VPWR sky130_fd_sc_hd__fill_2
XFILLER_0_110_101 VGND VGND VPWR VPWR sky130_fd_sc_hd__fill_2
X_6200_ u_pe_array.g_pe_row\[0\].g_pe_col\[0\].u_pe.act_val\[1\] u_pe_array.g_pe_row\[0\].g_pe_col\[0\].u_pe.w_reg\[0\]
+ _2995_ _2996_ VGND VGND VPWR VPWR _2997_ sky130_fd_sc_hd__a22o_1
X_7180_ clknet_leaf_75_clk _0247_ net815 VGND VGND VPWR VPWR u_pe_array.g_pe_row\[1\].g_pe_col\[3\].u_pe.w_buffer\[1\]
+ sky130_fd_sc_hd__dfrtp_1
Xhold328 u_pe_array.g_pe_row\[0\].g_pe_col\[3\].u_pe.psum_out\[0\] VGND VGND VPWR
+ VPWR net404 sky130_fd_sc_hd__dlygate4sd3_1
Xhold339 u_pe_array.u_fifo2.buffer\[0\]\[5\] VGND VGND VPWR VPWR net415 sky130_fd_sc_hd__dlygate4sd3_1
XFILLER_0_110_134 VGND VGND VPWR VPWR sky130_fd_sc_hd__decap_4
X_6131_ _2873_ u_pe_array.g_pe_row\[0\].g_pe_col\[1\].u_pe.psum_out\[7\] VGND VGND
+ VPWR VPWR _2939_ sky130_fd_sc_hd__xor2_1
XFILLER_0_0_343 VGND VGND VPWR VPWR sky130_fd_sc_hd__fill_1
X_4392_ _1489_ _1490_ VGND VGND VPWR VPWR _1491_ sky130_fd_sc_hd__nor2_1
XTAP_600 VGND VPWR sky130_fd_sc_hd__tapvpwrvgnd_1
XANTENNA__5900__B1 _2571_ VGND VGND VPWR VPWR sky130_fd_sc_hd__diode_2
XFILLER_0_0_365 VPWR VGND VPWR VGND sky130_ef_sc_hd__decap_12
XANTENNA__6456__A1 _1818_ VGND VGND VPWR VPWR sky130_fd_sc_hd__diode_2
XTAP_611 VGND VPWR sky130_fd_sc_hd__tapvpwrvgnd_1
XTAP_622 VGND VPWR sky130_fd_sc_hd__tapvpwrvgnd_1
XTAP_633 VGND VPWR sky130_fd_sc_hd__tapvpwrvgnd_1
X_6062_ _2871_ _2875_ VGND VGND VPWR VPWR _2876_ sky130_fd_sc_hd__xnor2_1
XTAP_655 VGND VPWR sky130_fd_sc_hd__tapvpwrvgnd_1
XTAP_644 VGND VPWR sky130_fd_sc_hd__tapvpwrvgnd_1
XTAP_666 VGND VPWR sky130_fd_sc_hd__tapvpwrvgnd_1
XTAP_677 VGND VPWR sky130_fd_sc_hd__tapvpwrvgnd_1
X_5013_ u_pe_array.u_fifo2.buffer\[4\]\[4\] _1965_ _1966_ u_pe_array.u_fifo2.buffer\[7\]\[4\]
+ VGND VGND VPWR VPWR _2005_ sky130_fd_sc_hd__a22o_1
XTAP_688 VGND VPWR sky130_fd_sc_hd__tapvpwrvgnd_1
XTAP_699 VGND VPWR sky130_fd_sc_hd__tapvpwrvgnd_1
XFILLER_0_88_471 VGND VGND VPWR VPWR sky130_fd_sc_hd__fill_2
XANTENNA__6335__S _3110_ VGND VGND VPWR VPWR sky130_fd_sc_hd__diode_2
XFILLER_0_76_611 VGND VGND VPWR VPWR sky130_fd_sc_hd__fill_1
Xclkbuf_leaf_18_clk clknet_3_2__leaf_clk VGND VGND VPWR VPWR clknet_leaf_18_clk sky130_fd_sc_hd__clkbuf_16
X_6964_ clknet_leaf_10_clk _0045_ net74 VGND VGND VPWR VPWR u_pe_array.g_pe_row\[3\].g_pe_col\[1\].u_pe.move_reg\[6\]
+ sky130_fd_sc_hd__dfrtp_1
X_6895_ _3431_ VGND VGND VPWR VPWR _0707_ sky130_fd_sc_hd__clkbuf_1
X_5915_ _2753_ _2755_ VGND VGND VPWR VPWR _2756_ sky130_fd_sc_hd__xnor2_1
XFILLER_0_76_655 VGND VGND VPWR VPWR sky130_fd_sc_hd__fill_1
XFILLER_0_8_421 VGND VGND VPWR VPWR sky130_fd_sc_hd__fill_2
X_5846_ _2705_ _2706_ _2695_ VGND VGND VPWR VPWR _2707_ sky130_fd_sc_hd__a21oi_1
X_5777_ u_pe_array.g_pe_row\[0\].g_pe_col\[3\].u_pe.w_reg\[0\] _2611_ _2642_ u_pe_array.g_pe_row\[0\].g_pe_col\[3\].u_pe.act_val\[4\]
+ VGND VGND VPWR VPWR _2644_ sky130_fd_sc_hd__nand4_1
X_4728_ _1768_ _1769_ _1758_ VGND VGND VPWR VPWR _1770_ sky130_fd_sc_hd__a21oi_1
X_7516_ clknet_leaf_5_clk _0565_ VGND VGND VPWR VPWR u_pe_array.u_fifo2.buffer\[6\]\[3\]
+ sky130_fd_sc_hd__dfxtp_1
X_4659_ _1704_ _1705_ u_pe_array.g_pe_row\[2\].g_pe_col\[1\].u_pe.psum_out\[4\] VGND
+ VGND VPWR VPWR _1707_ sky130_fd_sc_hd__a21o_1
XFILLER_0_71_393 VGND VGND VPWR VPWR sky130_fd_sc_hd__fill_2
X_7447_ clknet_leaf_8_clk _0496_ VGND VGND VPWR VPWR u_pe_array.u_fifo2.buffer\[0\]\[12\]
+ sky130_fd_sc_hd__dfxtp_1
XFILLER_0_16_298 VGND VGND VPWR VPWR sky130_fd_sc_hd__fill_2
XFILLER_0_102_624 VPWR VGND VPWR VGND sky130_ef_sc_hd__decap_12
XFILLER_0_3_181 VPWR VGND VPWR VGND sky130_ef_sc_hd__decap_12
X_7378_ clknet_leaf_46_clk _0431_ net812 VGND VGND VPWR VPWR u_pe_array.g_pe_row\[0\].g_pe_col\[1\].u_pe.psum_out\[2\]
+ sky130_fd_sc_hd__dfrtp_1
XFILLER_0_102_657 VPWR VGND VPWR VGND sky130_ef_sc_hd__decap_12
X_6329_ _3112_ net568 _3110_ VGND VGND VPWR VPWR _3113_ sky130_fd_sc_hd__mux2_1
XANTENNA__7153__RESET_B net814 VGND VGND VPWR VPWR sky130_fd_sc_hd__diode_2
XFILLER_0_79_460 VGND VGND VPWR VPWR sky130_fd_sc_hd__fill_2
XANTENNA__5958__B1 _0885_ VGND VGND VPWR VPWR sky130_fd_sc_hd__diode_2
XFILLER_0_39_335 VGND VGND VPWR VPWR sky130_fd_sc_hd__fill_1
XFILLER_0_66_132 VGND VGND VPWR VPWR sky130_fd_sc_hd__fill_2
XFILLER_0_13_17 VGND VGND VPWR VPWR sky130_fd_sc_hd__decap_3
XFILLER_0_94_485 VGND VGND VPWR VPWR sky130_fd_sc_hd__fill_2
XFILLER_0_82_636 VGND VGND VPWR VPWR sky130_fd_sc_hd__decap_4
XFILLER_0_109_267 VGND VGND VPWR VPWR sky130_fd_sc_hd__fill_2
XFILLER_0_82_669 VGND VGND VPWR VPWR sky130_fd_sc_hd__fill_2
XANTENNA__5186__B2 _1665_ VGND VGND VPWR VPWR sky130_fd_sc_hd__diode_2
XFILLER_0_105_462 VGND VGND VPWR VPWR sky130_fd_sc_hd__fill_2
XANTENNA__6135__B1 _2571_ VGND VGND VPWR VPWR sky130_fd_sc_hd__diode_2
XFILLER_0_50_533 VPWR VGND VPWR VGND sky130_ef_sc_hd__decap_12
XFILLER_0_50_577 VGND VGND VPWR VPWR sky130_fd_sc_hd__decap_4
XANTENNA__3633__A _0729_ VGND VGND VPWR VPWR sky130_fd_sc_hd__diode_2
XFILLER_0_89_246 VGND VGND VPWR VPWR sky130_fd_sc_hd__fill_2
XANTENNA__3779__S _0828_ VGND VGND VPWR VPWR sky130_fd_sc_hd__diode_2
XFILLER_0_89_279 VGND VGND VPWR VPWR sky130_fd_sc_hd__fill_1
X_3961_ net20 _1132_ _0819_ VGND VGND VPWR VPWR _1133_ sky130_fd_sc_hd__mux2_1
XANTENNA__5413__A2 _2144_ VGND VGND VPWR VPWR sky130_fd_sc_hd__diode_2
X_5700_ _2573_ _2577_ _2584_ _2586_ _2583_ VGND VGND VPWR VPWR _2587_ sky130_fd_sc_hd__a32o_1
XFILLER_0_57_143 VGND VGND VPWR VPWR sky130_fd_sc_hd__decap_3
XFILLER_0_9_229 VGND VGND VPWR VPWR sky130_fd_sc_hd__fill_1
XANTENNA__3975__A2 _1138_ VGND VGND VPWR VPWR sky130_fd_sc_hd__diode_2
X_6680_ _3313_ _3314_ VGND VGND VPWR VPWR _3315_ sky130_fd_sc_hd__or2_1
X_3892_ u_pe_array.g_pe_row\[3\].g_pe_col\[2\].u_pe.psum_out\[7\] _1009_ VGND VGND
+ VPWR VPWR _1077_ sky130_fd_sc_hd__or2_1
XFILLER_0_73_669 VGND VGND VPWR VPWR sky130_fd_sc_hd__decap_3
X_5631_ _2522_ _2524_ VGND VGND VPWR VPWR _2525_ sky130_fd_sc_hd__xor2_1
XFILLER_0_57_198 VGND VGND VPWR VPWR sky130_fd_sc_hd__fill_2
XFILLER_0_45_349 VGND VGND VPWR VPWR sky130_fd_sc_hd__fill_2
XFILLER_0_5_424 VGND VGND VPWR VPWR sky130_fd_sc_hd__fill_2
X_5562_ u_pe_array.g_pe_row\[1\].g_pe_col\[3\].u_pe.psum_out\[6\] u_pe_array.g_pe_row\[1\].g_pe_col\[3\].u_pe.move_reg\[6\]
+ _1661_ VGND VGND VPWR VPWR _2468_ sky130_fd_sc_hd__mux2_1
XANTENNA__3527__B _0770_ VGND VGND VPWR VPWR sky130_fd_sc_hd__diode_2
XFILLER_0_53_393 VGND VGND VPWR VPWR sky130_fd_sc_hd__fill_2
X_4513_ net684 _1152_ _1586_ _1587_ VGND VGND VPWR VPWR _0169_ sky130_fd_sc_hd__a22o_1
X_7301_ clknet_leaf_62_clk _0360_ net814 VGND VGND VPWR VPWR u_pe_array.g_pe_row\[0\].g_pe_col\[2\].u_pe.act_val\[0\]
+ sky130_fd_sc_hd__dfrtp_4
X_5493_ _2412_ u_pe_array.g_pe_row\[1\].g_pe_col\[1\].u_pe.psum_out\[7\] _2401_ VGND
+ VGND VPWR VPWR _2413_ sky130_fd_sc_hd__mux2_1
X_7232_ clknet_leaf_54_clk _0295_ net75 VGND VGND VPWR VPWR u_pe_array.g_pe_row\[1\].g_pe_col\[2\].u_pe.psum_out\[6\]
+ sky130_fd_sc_hd__dfrtp_1
Xhold125 u_pe_array.g_pe_row\[1\].g_pe_col\[2\].u_pe.move_reg\[6\] VGND VGND VPWR
+ VPWR net201 sky130_fd_sc_hd__dlygate4sd3_1
Xhold103 u_pe_array.g_pe_row\[3\].g_pe_col\[2\].u_pe.move_reg\[7\] VGND VGND VPWR
+ VPWR net179 sky130_fd_sc_hd__dlygate4sd3_1
XFILLER_0_13_246 VPWR VGND VPWR VGND sky130_ef_sc_hd__decap_12
Xhold114 _0132_ VGND VGND VPWR VPWR net190 sky130_fd_sc_hd__dlygate4sd3_1
Xhold158 u_pe_array.u_fifo1.buffer\[2\]\[12\] VGND VGND VPWR VPWR net234 sky130_fd_sc_hd__dlygate4sd3_1
Xhold136 u_pe_array.u_fifo1.buffer\[3\]\[11\] VGND VGND VPWR VPWR net212 sky130_fd_sc_hd__dlygate4sd3_1
X_4444_ net209 _1524_ _1527_ _1399_ VGND VGND VPWR VPWR _0160_ sky130_fd_sc_hd__a22o_1
Xclkbuf_leaf_7_clk clknet_3_0__leaf_clk VGND VGND VPWR VPWR clknet_leaf_7_clk sky130_fd_sc_hd__clkbuf_16
Xhold147 u_pe_array.u_fifo2.buffer\[3\]\[12\] VGND VGND VPWR VPWR net223 sky130_fd_sc_hd__dlygate4sd3_1
XFILLER_0_1_641 VPWR VGND VPWR VGND sky130_ef_sc_hd__decap_12
X_4375_ _1273_ _1474_ _1475_ _1144_ net787 VGND VGND VPWR VPWR _0143_ sky130_fd_sc_hd__a32o_1
X_7163_ clknet_leaf_71_clk _0232_ net814 VGND VGND VPWR VPWR u_pe_array.g_pe_row\[1\].g_pe_col\[3\].u_pe.move_reg\[12\]
+ sky130_fd_sc_hd__dfrtp_1
XANTENNA__5742__B _2611_ VGND VGND VPWR VPWR sky130_fd_sc_hd__diode_2
Xhold169 _0369_ VGND VGND VPWR VPWR net245 sky130_fd_sc_hd__dlygate4sd3_1
X_6114_ _2910_ _2913_ _2922_ _0885_ VGND VGND VPWR VPWR _2924_ sky130_fd_sc_hd__o31a_1
XTAP_430 VGND VPWR sky130_fd_sc_hd__tapvpwrvgnd_1
X_7094_ clknet_leaf_92_clk _0165_ net819 VGND VGND VPWR VPWR u_pe_array.g_pe_row\[2\].g_pe_col\[2\].u_pe.psum_out\[1\]
+ sky130_fd_sc_hd__dfrtp_1
XTAP_441 VGND VPWR sky130_fd_sc_hd__tapvpwrvgnd_1
XANTENNA__6429__A1 _1818_ VGND VGND VPWR VPWR sky130_fd_sc_hd__diode_2
X_6045_ net237 _2738_ _2864_ _0722_ VGND VGND VPWR VPWR _0424_ sky130_fd_sc_hd__a22o_1
XTAP_452 VGND VPWR sky130_fd_sc_hd__tapvpwrvgnd_1
XTAP_463 VGND VPWR sky130_fd_sc_hd__tapvpwrvgnd_1
XTAP_485 VGND VPWR sky130_fd_sc_hd__tapvpwrvgnd_1
XTAP_474 VGND VPWR sky130_fd_sc_hd__tapvpwrvgnd_1
XTAP_496 VGND VPWR sky130_fd_sc_hd__tapvpwrvgnd_1
XFILLER_0_28_80 VGND VGND VPWR VPWR sky130_fd_sc_hd__fill_1
XFILLER_0_68_408 VGND VGND VPWR VPWR sky130_fd_sc_hd__decap_6
XTAP_1629 VGND VPWR sky130_fd_sc_hd__tapvpwrvgnd_1
XTAP_1618 VGND VPWR sky130_fd_sc_hd__tapvpwrvgnd_1
XTAP_1607 VGND VPWR sky130_fd_sc_hd__tapvpwrvgnd_1
XANTENNA__6292__C _2992_ VGND VGND VPWR VPWR sky130_fd_sc_hd__diode_2
XFILLER_0_48_121 VGND VGND VPWR VPWR sky130_fd_sc_hd__fill_1
X_6947_ clknet_leaf_76_clk _0028_ net815 VGND VGND VPWR VPWR u_pe_array.g_pe_row\[3\].g_pe_col\[3\].u_pe.psum_out\[4\]
+ sky130_fd_sc_hd__dfrtp_1
X_6878_ net290 _3128_ _3412_ VGND VGND VPWR VPWR _3422_ sky130_fd_sc_hd__mux2_1
XANTENNA__3966__A2 _0996_ VGND VGND VPWR VPWR sky130_fd_sc_hd__diode_2
XFILLER_0_76_496 VGND VGND VPWR VPWR sky130_fd_sc_hd__decap_3
XFILLER_0_48_176 VGND VGND VPWR VPWR sky130_fd_sc_hd__fill_2
XFILLER_0_8_273 VGND VGND VPWR VPWR sky130_fd_sc_hd__fill_1
X_5829_ _2683_ _2686_ _2691_ VGND VGND VPWR VPWR _2692_ sky130_fd_sc_hd__and3_1
XFILLER_0_8_295 VGND VGND VPWR VPWR sky130_fd_sc_hd__decap_4
XFILLER_0_17_585 VGND VGND VPWR VPWR sky130_fd_sc_hd__decap_4
XFILLER_0_32_544 VGND VGND VPWR VPWR sky130_fd_sc_hd__fill_1
XFILLER_0_102_432 VGND VGND VPWR VPWR sky130_fd_sc_hd__fill_2
Xhold670 u_pe_array.g_pe_row\[0\].g_pe_col\[1\].u_pe.psum_out\[9\] VGND VGND VPWR
+ VPWR net746 sky130_fd_sc_hd__dlygate4sd3_1
Xhold681 u_pe_array.g_pe_row\[2\].g_pe_col\[1\].u_pe.psum_out\[4\] VGND VGND VPWR
+ VPWR net757 sky130_fd_sc_hd__dlygate4sd3_1
XANTENNA__4549__A _1536_ VGND VGND VPWR VPWR sky130_fd_sc_hd__diode_2
Xhold692 u_pe_array.g_pe_row\[3\].g_pe_col\[0\].u_pe.act_val\[5\] VGND VGND VPWR VPWR
+ net768 sky130_fd_sc_hd__dlygate4sd3_1
XANTENNA__5891__A2 _2600_ VGND VGND VPWR VPWR sky130_fd_sc_hd__diode_2
XANTENNA__7334__RESET_B net812 VGND VGND VPWR VPWR sky130_fd_sc_hd__diode_2
XANTENNA_input12_A h_in1[5] VGND VGND VPWR VPWR sky130_fd_sc_hd__diode_2
XFILLER_0_86_216 VGND VGND VPWR VPWR sky130_fd_sc_hd__decap_3
XANTENNA_clkbuf_3_7__f_clk_A clknet_0_clk VGND VGND VPWR VPWR sky130_fd_sc_hd__diode_2
XFILLER_0_27_316 VGND VGND VPWR VPWR sky130_fd_sc_hd__decap_8
XANTENNA__6356__A0 _3130_ VGND VGND VPWR VPWR sky130_fd_sc_hd__diode_2
XFILLER_0_94_293 VGND VGND VPWR VPWR sky130_fd_sc_hd__fill_2
XANTENNA__4906__A1 _1725_ VGND VGND VPWR VPWR sky130_fd_sc_hd__diode_2
XFILLER_0_82_477 VGND VGND VPWR VPWR sky130_fd_sc_hd__fill_2
XFILLER_0_54_157 VGND VGND VPWR VPWR sky130_fd_sc_hd__decap_3
Xload_slew4 net73 VGND VGND VPWR VPWR net815 sky130_fd_sc_hd__buf_12
XFILLER_0_23_500 VGND VGND VPWR VPWR sky130_fd_sc_hd__fill_2
XFILLER_0_23_533 VGND VGND VPWR VPWR sky130_fd_sc_hd__fill_2
XFILLER_0_35_393 VGND VGND VPWR VPWR sky130_fd_sc_hd__fill_2
XFILLER_0_105_281 VGND VGND VPWR VPWR sky130_fd_sc_hd__decap_4
XFILLER_0_50_363 VGND VGND VPWR VPWR sky130_fd_sc_hd__fill_1
X_4160_ u_pe_array.g_pe_row\[3\].g_pe_col\[0\].u_pe.act_val\[2\] VGND VGND VPWR VPWR
+ _1293_ sky130_fd_sc_hd__inv_2
XANTENNA__7075__RESET_B net74 VGND VGND VPWR VPWR sky130_fd_sc_hd__diode_2
XANTENNA__7004__RESET_B net816 VGND VGND VPWR VPWR sky130_fd_sc_hd__diode_2
X_4091_ _1145_ u_pe_array.g_pe_row\[3\].g_pe_col\[1\].u_pe.psum_out\[11\] VGND VGND
+ VPWR VPWR _1244_ sky130_fd_sc_hd__and2b_1
XFILLER_0_81_44 VGND VGND VPWR VPWR sky130_fd_sc_hd__fill_2
X_6801_ u_pe_array.u_fifo1.wr_ptr\[3\] net816 _3296_ u_pe_array.u_fifo1.wr_ptr\[2\]
+ VGND VGND VPWR VPWR _3380_ sky130_fd_sc_hd__and4b_1
XFILLER_0_105_51 VGND VGND VPWR VPWR sky130_fd_sc_hd__decap_4
XANTENNA__5398__A1 _0836_ VGND VGND VPWR VPWR sky130_fd_sc_hd__diode_2
XFILLER_0_58_441 VGND VGND VPWR VPWR sky130_fd_sc_hd__decap_4
X_4993_ _0836_ _1985_ _1987_ _0833_ net433 VGND VGND VPWR VPWR _0249_ sky130_fd_sc_hd__a32o_1
X_6732_ _3344_ VGND VGND VPWR VPWR _0631_ sky130_fd_sc_hd__clkbuf_1
X_3944_ _1121_ VGND VGND VPWR VPWR _0066_ sky130_fd_sc_hd__clkbuf_1
XANTENNA__6613__S _3269_ VGND VGND VPWR VPWR sky130_fd_sc_hd__diode_2
X_6663_ _3302_ _3303_ VGND VGND VPWR VPWR _3304_ sky130_fd_sc_hd__and2b_1
X_3875_ _1059_ _1060_ _0885_ VGND VGND VPWR VPWR _1062_ sky130_fd_sc_hd__o21a_1
XANTENNA__6898__A1 _3120_ VGND VGND VPWR VPWR sky130_fd_sc_hd__diode_2
XFILLER_0_73_477 VGND VGND VPWR VPWR sky130_fd_sc_hd__decap_8
XFILLER_0_73_466 VGND VGND VPWR VPWR sky130_fd_sc_hd__fill_1
X_5614_ u_pe_array.g_pe_row\[1\].g_pe_col\[0\].u_pe.act_val\[3\] VGND VGND VPWR VPWR
+ _2509_ sky130_fd_sc_hd__inv_2
XFILLER_0_61_606 VGND VGND VPWR VPWR sky130_fd_sc_hd__fill_2
XFILLER_0_5_221 VGND VGND VPWR VPWR sky130_fd_sc_hd__decap_3
XFILLER_0_14_511 VGND VGND VPWR VPWR sky130_fd_sc_hd__fill_2
XFILLER_0_14_533 VGND VGND VPWR VPWR sky130_fd_sc_hd__decap_6
X_6594_ _3265_ VGND VGND VPWR VPWR _0572_ sky130_fd_sc_hd__clkbuf_1
X_5545_ u_pe_array.g_pe_row\[0\].g_pe_col\[0\].u_pe.w_buffer\[0\] u_pe_array.g_pe_row\[1\].g_pe_col\[0\].u_pe.w_buffer\[0\]
+ _0828_ VGND VGND VPWR VPWR _2459_ sky130_fd_sc_hd__mux2_1
XANTENNA__3972__S _0755_ VGND VGND VPWR VPWR sky130_fd_sc_hd__diode_2
XFILLER_0_14_544 VGND VGND VPWR VPWR sky130_fd_sc_hd__fill_1
XANTENNA__5570__B2 _2336_ VGND VGND VPWR VPWR sky130_fd_sc_hd__diode_2
XFILLER_0_30_81 VGND VGND VPWR VPWR sky130_fd_sc_hd__fill_1
XFILLER_0_41_341 VGND VGND VPWR VPWR sky130_fd_sc_hd__decap_8
X_5476_ net632 _2387_ _2396_ _2397_ VGND VGND VPWR VPWR _0322_ sky130_fd_sc_hd__a22o_1
X_4427_ net622 _1392_ _1258_ _1518_ VGND VGND VPWR VPWR _0152_ sky130_fd_sc_hd__a22o_1
X_7215_ clknet_leaf_54_clk _0280_ net75 VGND VGND VPWR VPWR u_pe_array.g_pe_row\[1\].g_pe_col\[1\].u_pe.act_val\[4\]
+ sky130_fd_sc_hd__dfrtp_2
XANTENNA__4125__A2 _1138_ VGND VGND VPWR VPWR sky130_fd_sc_hd__diode_2
XFILLER_0_41_396 VGND VGND VPWR VPWR sky130_fd_sc_hd__fill_2
XANTENNA__5873__A2 _2600_ VGND VGND VPWR VPWR sky130_fd_sc_hd__diode_2
X_7146_ clknet_leaf_93_clk _0215_ VGND VGND VPWR VPWR u_pe_array.u_fifo2.buffer\[8\]\[10\]
+ sky130_fd_sc_hd__dfxtp_1
X_4358_ _1453_ _1457_ VGND VGND VPWR VPWR _1460_ sky130_fd_sc_hd__nor2_1
XTAP_260 VGND VPWR sky130_fd_sc_hd__tapvpwrvgnd_1
XANTENNA_input4_A h_in0[3] VGND VGND VPWR VPWR sky130_fd_sc_hd__diode_2
X_7077_ clknet_leaf_81_clk _0150_ net815 VGND VGND VPWR VPWR u_pe_array.g_pe_row\[2\].g_pe_col\[2\].u_pe.w_buffer\[1\]
+ sky130_fd_sc_hd__dfrtp_1
XTAP_293 VGND VPWR sky130_fd_sc_hd__tapvpwrvgnd_1
XTAP_282 VGND VPWR sky130_fd_sc_hd__tapvpwrvgnd_1
XTAP_271 VGND VPWR sky130_fd_sc_hd__tapvpwrvgnd_1
X_4289_ u_pe_array.g_pe_row\[2\].g_pe_col\[3\].u_pe.psum_out\[9\] u_pe_array.g_pe_row\[2\].g_pe_col\[3\].u_pe.move_reg\[9\]
+ _0855_ VGND VGND VPWR VPWR _1401_ sky130_fd_sc_hd__mux2_1
XANTENNA__6822__A1 _3128_ VGND VGND VPWR VPWR sky130_fd_sc_hd__diode_2
X_6028_ u_pe_array.g_pe_row\[0\].g_pe_col\[1\].u_pe.act_val\[0\] u_pe_array.g_pe_row\[0\].g_pe_col\[1\].u_pe.psum_out\[0\]
+ _0770_ VGND VGND VPWR VPWR _2856_ sky130_fd_sc_hd__mux2_1
XTAP_1415 VGND VPWR sky130_fd_sc_hd__tapvpwrvgnd_1
XTAP_1404 VGND VPWR sky130_fd_sc_hd__tapvpwrvgnd_1
XFILLER_0_68_238 VGND VGND VPWR VPWR sky130_fd_sc_hd__fill_1
XTAP_1437 VGND VPWR sky130_fd_sc_hd__tapvpwrvgnd_1
XTAP_1448 VGND VPWR sky130_fd_sc_hd__tapvpwrvgnd_1
XTAP_1426 VGND VPWR sky130_fd_sc_hd__tapvpwrvgnd_1
XANTENNA__5389__A1 _0836_ VGND VGND VPWR VPWR sky130_fd_sc_hd__diode_2
XTAP_1459 VGND VPWR sky130_fd_sc_hd__tapvpwrvgnd_1
XFILLER_0_36_102 VGND VGND VPWR VPWR sky130_fd_sc_hd__decap_8
XFILLER_0_37_603 VGND VGND VPWR VPWR sky130_fd_sc_hd__fill_2
XANTENNA__6523__S _3224_ VGND VGND VPWR VPWR sky130_fd_sc_hd__diode_2
XFILLER_0_107_502 VGND VGND VPWR VPWR sky130_fd_sc_hd__fill_2
XFILLER_0_36_124 VGND VGND VPWR VPWR sky130_fd_sc_hd__fill_2
Xfanout75 net817 VGND VGND VPWR VPWR net75 sky130_fd_sc_hd__buf_12
XFILLER_0_64_477 VGND VGND VPWR VPWR sky130_fd_sc_hd__fill_2
XFILLER_0_37_669 VGND VGND VPWR VPWR sky130_fd_sc_hd__decap_3
XFILLER_0_17_393 VGND VGND VPWR VPWR sky130_fd_sc_hd__fill_2
XFILLER_0_20_558 VGND VGND VPWR VPWR sky130_fd_sc_hd__fill_1
XANTENNA__6197__C _2992_ VGND VGND VPWR VPWR sky130_fd_sc_hd__diode_2
XANTENNA__5313__B2 _0916_ VGND VGND VPWR VPWR sky130_fd_sc_hd__diode_2
XFILLER_0_99_341 VPWR VGND VPWR VGND sky130_ef_sc_hd__decap_12
XFILLER_0_87_503 VGND VGND VPWR VPWR sky130_fd_sc_hd__fill_1
XFILLER_0_35_37 VGND VGND VPWR VPWR sky130_fd_sc_hd__fill_1
XFILLER_0_87_569 VGND VGND VPWR VPWR sky130_fd_sc_hd__decap_3
XFILLER_0_59_249 VGND VGND VPWR VPWR sky130_fd_sc_hd__fill_2
XANTENNA__6041__A2 _2738_ VGND VGND VPWR VPWR sky130_fd_sc_hd__diode_2
XFILLER_0_28_603 VGND VGND VPWR VPWR sky130_fd_sc_hd__decap_8
XFILLER_0_67_293 VGND VGND VPWR VPWR sky130_fd_sc_hd__fill_1
XFILLER_0_82_241 VGND VGND VPWR VPWR sky130_fd_sc_hd__fill_2
XFILLER_0_55_477 VGND VGND VPWR VPWR sky130_fd_sc_hd__fill_1
XFILLER_0_113_505 VPWR VGND VPWR VGND sky130_ef_sc_hd__decap_12
XFILLER_0_70_425 VPWR VGND VPWR VGND sky130_ef_sc_hd__decap_12
X_3660_ u_pe_array.g_pe_row\[3\].g_pe_col\[3\].u_pe.act_val\[0\] _0868_ _0869_ VGND
+ VGND VPWR VPWR _0878_ sky130_fd_sc_hd__a21bo_1
XFILLER_0_15_319 VGND VGND VPWR VPWR sky130_fd_sc_hd__decap_3
XFILLER_0_42_116 VPWR VGND VPWR VGND sky130_ef_sc_hd__decap_12
XFILLER_0_51_650 VGND VGND VPWR VPWR sky130_fd_sc_hd__fill_1
X_3591_ _0826_ VGND VGND VPWR VPWR _0008_ sky130_fd_sc_hd__clkbuf_1
XFILLER_0_23_341 VGND VGND VPWR VPWR sky130_fd_sc_hd__fill_2
X_5330_ _2270_ VGND VGND VPWR VPWR _0303_ sky130_fd_sc_hd__clkbuf_1
XANTENNA__7256__RESET_B net75 VGND VGND VPWR VPWR sky130_fd_sc_hd__diode_2
XANTENNA_clkbuf_leaf_53_clk_A clknet_3_7__leaf_clk VGND VGND VPWR VPWR sky130_fd_sc_hd__diode_2
X_5261_ net666 _1714_ _2209_ _2210_ VGND VGND VPWR VPWR _0294_ sky130_fd_sc_hd__a22o_1
XFILLER_0_23_385 VGND VGND VPWR VPWR sky130_fd_sc_hd__fill_2
X_4212_ _1275_ u_pe_array.g_pe_row\[3\].g_pe_col\[0\].u_pe.psum_out\[7\] VGND VGND
+ VPWR VPWR _1341_ sky130_fd_sc_hd__xor2_1
X_7000_ clknet_leaf_38_clk _0079_ net76 VGND VGND VPWR VPWR u_pe_array.g_pe_row\[3\].g_pe_col\[0\].u_pe.move_reg\[12\]
+ sky130_fd_sc_hd__dfrtp_1
X_5192_ net176 _2144_ _2150_ _1665_ VGND VGND VPWR VPWR _0285_ sky130_fd_sc_hd__a22o_1
X_4143_ _1272_ _1277_ VGND VGND VPWR VPWR _1278_ sky130_fd_sc_hd__xnor2_1
X_4074_ _1145_ u_pe_array.g_pe_row\[3\].g_pe_col\[1\].u_pe.psum_out\[9\] VGND VGND
+ VPWR VPWR _1229_ sky130_fd_sc_hd__nor2_1
XANTENNA_clkbuf_leaf_68_clk_A clknet_3_5__leaf_clk VGND VGND VPWR VPWR sky130_fd_sc_hd__diode_2
XFILLER_0_92_32 VGND VGND VPWR VPWR sky130_fd_sc_hd__decap_4
XANTENNA__4128__S _0855_ VGND VGND VPWR VPWR sky130_fd_sc_hd__diode_2
XFILLER_0_78_536 VGND VGND VPWR VPWR sky130_fd_sc_hd__fill_2
XANTENNA__3967__S _0755_ VGND VGND VPWR VPWR sky130_fd_sc_hd__diode_2
XFILLER_0_93_539 VGND VGND VPWR VPWR sky130_fd_sc_hd__fill_2
XFILLER_0_93_517 VGND VGND VPWR VPWR sky130_fd_sc_hd__fill_2
XFILLER_0_65_219 VGND VGND VPWR VPWR sky130_fd_sc_hd__decap_3
X_6715_ _3335_ VGND VGND VPWR VPWR _0623_ sky130_fd_sc_hd__clkbuf_1
XANTENNA__5240__B1 _2158_ VGND VGND VPWR VPWR sky130_fd_sc_hd__diode_2
X_4976_ u_pe_array.u_fifo2.rd_ptr\[1\] u_pe_array.u_fifo2.rd_ptr\[0\] _1968_ VGND
+ VGND VPWR VPWR _1972_ sky130_fd_sc_hd__and3b_2
XFILLER_0_46_477 VGND VGND VPWR VPWR sky130_fd_sc_hd__decap_3
X_3927_ _1103_ _1107_ VGND VGND VPWR VPWR _1109_ sky130_fd_sc_hd__nand2_1
XFILLER_0_18_157 VGND VGND VPWR VPWR sky130_fd_sc_hd__fill_2
XFILLER_0_19_669 VGND VGND VPWR VPWR sky130_fd_sc_hd__decap_3
XFILLER_0_73_285 VGND VGND VPWR VPWR sky130_fd_sc_hd__decap_8
XFILLER_0_61_425 VGND VGND VPWR VPWR sky130_fd_sc_hd__fill_2
XFILLER_0_46_488 VGND VGND VPWR VPWR sky130_fd_sc_hd__fill_2
X_6646_ _3292_ VGND VGND VPWR VPWR _0597_ sky130_fd_sc_hd__clkbuf_1
X_3858_ u_pe_array.g_pe_row\[3\].g_pe_col\[2\].u_pe.act_val\[3\] u_pe_array.g_pe_row\[3\].g_pe_col\[2\].u_pe.w_reg\[0\]
+ _1033_ _1032_ VGND VGND VPWR VPWR _1046_ sky130_fd_sc_hd__a31o_1
XANTENNA__4798__S _0828_ VGND VGND VPWR VPWR sky130_fd_sc_hd__diode_2
X_3789_ net825 _0834_ _0837_ _0991_ VGND VGND VPWR VPWR _0041_ sky130_fd_sc_hd__a22o_1
X_6577_ net538 _1800_ _3254_ VGND VGND VPWR VPWR _3257_ sky130_fd_sc_hd__mux2_1
XFILLER_0_104_549 VGND VGND VPWR VPWR sky130_fd_sc_hd__fill_1
X_5528_ _2442_ _2444_ VGND VGND VPWR VPWR _2445_ sky130_fd_sc_hd__or2_1
X_5459_ _2379_ _2380_ _2381_ VGND VGND VPWR VPWR _2382_ sky130_fd_sc_hd__and3_1
X_7129_ clknet_leaf_14_clk _0198_ net816 VGND VGND VPWR VPWR u_pe_array.g_pe_row\[2\].g_pe_col\[1\].u_pe.psum_out\[6\]
+ sky130_fd_sc_hd__dfrtp_1
XANTENNA__6979__RESET_B net819 VGND VGND VPWR VPWR sky130_fd_sc_hd__diode_2
XFILLER_0_96_333 VGND VGND VPWR VPWR sky130_fd_sc_hd__decap_4
XTAP_1223 VGND VPWR sky130_fd_sc_hd__tapvpwrvgnd_1
XTAP_1201 VGND VPWR sky130_fd_sc_hd__tapvpwrvgnd_1
XTAP_1212 VGND VPWR sky130_fd_sc_hd__tapvpwrvgnd_1
XTAP_1256 VGND VPWR sky130_fd_sc_hd__tapvpwrvgnd_1
XTAP_1245 VGND VPWR sky130_fd_sc_hd__tapvpwrvgnd_1
XTAP_1234 VGND VPWR sky130_fd_sc_hd__tapvpwrvgnd_1
XANTENNA__6023__A2 _2387_ VGND VGND VPWR VPWR sky130_fd_sc_hd__diode_2
XTAP_1289 VGND VPWR sky130_fd_sc_hd__tapvpwrvgnd_1
XTAP_1267 VGND VPWR sky130_fd_sc_hd__tapvpwrvgnd_1
XTAP_1278 VGND VPWR sky130_fd_sc_hd__tapvpwrvgnd_1
XFILLER_0_64_241 VGND VGND VPWR VPWR sky130_fd_sc_hd__fill_2
XFILLER_0_25_606 VGND VGND VPWR VPWR sky130_fd_sc_hd__fill_2
XFILLER_0_37_444 VGND VGND VPWR VPWR sky130_fd_sc_hd__fill_1
XFILLER_0_64_263 VGND VGND VPWR VPWR sky130_fd_sc_hd__decap_4
XFILLER_0_9_390 VGND VGND VPWR VPWR sky130_fd_sc_hd__fill_2
XANTENNA__4990__C1 _0819_ VGND VGND VPWR VPWR sky130_fd_sc_hd__diode_2
XFILLER_0_107_387 VGND VGND VPWR VPWR sky130_fd_sc_hd__decap_3
XFILLER_0_107_376 VGND VGND VPWR VPWR sky130_fd_sc_hd__fill_2
XFILLER_0_52_469 VGND VGND VPWR VPWR sky130_fd_sc_hd__fill_2
XFILLER_0_107_398 VGND VGND VPWR VPWR sky130_fd_sc_hd__fill_2
XFILLER_0_110_519 VPWR VGND VPWR VGND sky130_ef_sc_hd__decap_12
XFILLER_0_87_311 VGND VGND VPWR VPWR sky130_fd_sc_hd__fill_2
XFILLER_0_1_27 VPWR VGND VPWR VGND sky130_ef_sc_hd__decap_12
XANTENNA__3481__C1 _0747_ VGND VGND VPWR VPWR sky130_fd_sc_hd__diode_2
XFILLER_0_75_528 VGND VGND VPWR VPWR sky130_fd_sc_hd__fill_1
XFILLER_0_47_208 VGND VGND VPWR VPWR sky130_fd_sc_hd__decap_4
X_4830_ net654 _0833_ VGND VGND VPWR VPWR _1842_ sky130_fd_sc_hd__and2_1
XANTENNA__3787__S _0745_ VGND VGND VPWR VPWR sky130_fd_sc_hd__diode_2
XFILLER_0_7_305 VGND VGND VPWR VPWR sky130_fd_sc_hd__fill_2
XFILLER_0_83_561 VGND VGND VPWR VPWR sky130_fd_sc_hd__fill_2
X_4761_ _1798_ net607 _1796_ VGND VGND VPWR VPWR _1799_ sky130_fd_sc_hd__mux2_1
X_4692_ _1735_ _1736_ _1734_ VGND VGND VPWR VPWR _1738_ sky130_fd_sc_hd__o21a_1
XFILLER_0_43_414 VGND VGND VPWR VPWR sky130_fd_sc_hd__fill_2
X_6500_ net269 _1808_ _3208_ VGND VGND VPWR VPWR _3215_ sky130_fd_sc_hd__mux2_1
X_7480_ clknet_leaf_93_clk _0529_ VGND VGND VPWR VPWR u_pe_array.u_fifo2.buffer\[3\]\[6\]
+ sky130_fd_sc_hd__dfxtp_1
X_3712_ net704 _0875_ _0925_ _0926_ VGND VGND VPWR VPWR _0029_ sky130_fd_sc_hd__a22o_1
XANTENNA__4981__C1 _0819_ VGND VGND VPWR VPWR sky130_fd_sc_hd__diode_2
XFILLER_0_102_41 VPWR VGND VPWR VGND sky130_ef_sc_hd__decap_12
X_3643_ _0862_ VGND VGND VPWR VPWR _0863_ sky130_fd_sc_hd__buf_4
X_6431_ net296 _1820_ _3166_ VGND VGND VPWR VPWR _3179_ sky130_fd_sc_hd__mux2_1
XFILLER_0_113_335 VGND VGND VPWR VPWR sky130_fd_sc_hd__fill_1
X_6362_ _3134_ net326 _3110_ VGND VGND VPWR VPWR _3135_ sky130_fd_sc_hd__mux2_1
XFILLER_0_102_85 VGND VGND VPWR VPWR sky130_fd_sc_hd__decap_4
XFILLER_0_70_288 VGND VGND VPWR VPWR sky130_fd_sc_hd__fill_2
XFILLER_0_11_83 VGND VGND VPWR VPWR sky130_fd_sc_hd__fill_1
XFILLER_0_11_61 VGND VGND VPWR VPWR sky130_fd_sc_hd__fill_2
XFILLER_0_87_43 VGND VGND VPWR VPWR sky130_fd_sc_hd__fill_2
XFILLER_0_87_32 VGND VGND VPWR VPWR sky130_fd_sc_hd__fill_2
X_3574_ u_fsm.cnt\[1\] u_fsm.cnt\[0\] _0724_ _0791_ VGND VGND VPWR VPWR _0814_ sky130_fd_sc_hd__and4_1
X_5313_ _2256_ _2257_ net791 _0916_ VGND VGND VPWR VPWR _0299_ sky130_fd_sc_hd__a2bb2o_1
XANTENNA__7090__RESET_B net816 VGND VGND VPWR VPWR sky130_fd_sc_hd__diode_2
XFILLER_0_11_311 VGND VGND VPWR VPWR sky130_fd_sc_hd__decap_4
X_6293_ _3071_ _3079_ _3080_ _3081_ VGND VGND VPWR VPWR _3082_ sky130_fd_sc_hd__a31o_1
X_5244_ u_pe_array.g_pe_row\[1\].g_pe_col\[2\].u_pe.psum_out\[3\] _2178_ _2179_ VGND
+ VGND VPWR VPWR _2195_ sky130_fd_sc_hd__a21o_1
XFILLER_0_11_399 VGND VGND VPWR VPWR sky130_fd_sc_hd__fill_2
XANTENNA__6338__S _3110_ VGND VGND VPWR VPWR sky130_fd_sc_hd__diode_2
Xhold29 u_pe_array.g_pe_row\[0\].g_pe_col\[3\].u_pe.w_buffer\[0\] VGND VGND VPWR VPWR
+ net105 sky130_fd_sc_hd__buf_1
X_5175_ net482 _1666_ _1655_ _2141_ VGND VGND VPWR VPWR _0277_ sky130_fd_sc_hd__a22o_1
Xhold18 u_pe_array.g_pe_row\[0\].g_pe_col\[2\].u_pe.w_buffer\[0\] VGND VGND VPWR VPWR
+ net94 sky130_fd_sc_hd__dlygate4sd3_1
X_4126_ u_pe_array.g_pe_row\[3\].g_pe_col\[3\].u_pe.psum_out\[9\] u_pe_array.g_pe_row\[3\].g_pe_col\[3\].u_pe.move_reg\[9\]
+ _0855_ VGND VGND VPWR VPWR _1266_ sky130_fd_sc_hd__mux2_1
XFILLER_0_39_3 VPWR VGND VPWR VGND sky130_ef_sc_hd__decap_12
XANTENNA__6253__A2 _0867_ VGND VGND VPWR VPWR sky130_fd_sc_hd__diode_2
X_4057_ _1210_ _1208_ _1212_ VGND VGND VPWR VPWR _1214_ sky130_fd_sc_hd__o21ai_1
XFILLER_0_93_314 VGND VGND VPWR VPWR sky130_fd_sc_hd__fill_2
XFILLER_0_66_528 VGND VGND VPWR VPWR sky130_fd_sc_hd__fill_2
XANTENNA__4382__A _1407_ VGND VGND VPWR VPWR sky130_fd_sc_hd__diode_2
XFILLER_0_19_400 VGND VGND VPWR VPWR sky130_fd_sc_hd__decap_3
XANTENNA__4016__A1 _1145_ VGND VGND VPWR VPWR sky130_fd_sc_hd__diode_2
X_4959_ _1956_ VGND VGND VPWR VPWR _0246_ sky130_fd_sc_hd__clkbuf_1
XANTENNA__7178__RESET_B net813 VGND VGND VPWR VPWR sky130_fd_sc_hd__diode_2
XFILLER_0_74_583 VGND VGND VPWR VPWR sky130_fd_sc_hd__decap_3
X_6629_ _0988_ net8 _0747_ VGND VGND VPWR VPWR _3284_ sky130_fd_sc_hd__mux2_1
XFILLER_0_34_436 VGND VGND VPWR VPWR sky130_fd_sc_hd__fill_2
XANTENNA__7107__RESET_B net813 VGND VGND VPWR VPWR sky130_fd_sc_hd__diode_2
XFILLER_0_100_552 VPWR VGND VPWR VGND sky130_ef_sc_hd__decap_12
XFILLER_0_100_530 VGND VGND VPWR VPWR sky130_fd_sc_hd__fill_2
XFILLER_0_88_108 VGND VGND VPWR VPWR sky130_fd_sc_hd__fill_2
XANTENNA__4991__S _0756_ VGND VGND VPWR VPWR sky130_fd_sc_hd__diode_2
XANTENNA__5388__A _1787_ VGND VGND VPWR VPWR sky130_fd_sc_hd__diode_2
XTAP_1031 VGND VPWR sky130_fd_sc_hd__tapvpwrvgnd_1
XTAP_1020 VGND VPWR sky130_fd_sc_hd__tapvpwrvgnd_1
XTAP_1064 VGND VPWR sky130_fd_sc_hd__tapvpwrvgnd_1
XTAP_1042 VGND VPWR sky130_fd_sc_hd__tapvpwrvgnd_1
XTAP_1053 VGND VPWR sky130_fd_sc_hd__tapvpwrvgnd_1
XFILLER_0_32_27 VGND VGND VPWR VPWR sky130_fd_sc_hd__fill_1
XFILLER_0_84_358 VGND VGND VPWR VPWR sky130_fd_sc_hd__decap_4
XTAP_1097 VGND VPWR sky130_fd_sc_hd__tapvpwrvgnd_1
XTAP_1086 VGND VPWR sky130_fd_sc_hd__tapvpwrvgnd_1
XTAP_1075 VGND VPWR sky130_fd_sc_hd__tapvpwrvgnd_1
XFILLER_0_65_561 VGND VGND VPWR VPWR sky130_fd_sc_hd__fill_1
XFILLER_0_37_252 VGND VGND VPWR VPWR sky130_fd_sc_hd__fill_2
XFILLER_0_52_211 VGND VGND VPWR VPWR sky130_fd_sc_hd__fill_2
XFILLER_0_107_162 VGND VGND VPWR VPWR sky130_fd_sc_hd__decap_3
XFILLER_0_80_553 VGND VGND VPWR VPWR sky130_fd_sc_hd__decap_3
XFILLER_0_52_244 VGND VGND VPWR VPWR sky130_fd_sc_hd__decap_3
XFILLER_0_25_436 VGND VGND VPWR VPWR sky130_fd_sc_hd__fill_1
XFILLER_0_25_447 VGND VGND VPWR VPWR sky130_fd_sc_hd__fill_1
XANTENNA__5327__S _0828_ VGND VGND VPWR VPWR sky130_fd_sc_hd__diode_2
XFILLER_0_0_503 VGND VGND VPWR VPWR sky130_fd_sc_hd__fill_1
XTAP_826 VGND VPWR sky130_fd_sc_hd__tapvpwrvgnd_1
XTAP_804 VGND VPWR sky130_fd_sc_hd__tapvpwrvgnd_1
XTAP_815 VGND VPWR sky130_fd_sc_hd__tapvpwrvgnd_1
XFILLER_0_0_569 VGND VGND VPWR VPWR sky130_fd_sc_hd__fill_1
XFILLER_0_57_57 VGND VGND VPWR VPWR sky130_fd_sc_hd__decap_8
XTAP_859 VGND VPWR sky130_fd_sc_hd__tapvpwrvgnd_1
XTAP_848 VGND VPWR sky130_fd_sc_hd__tapvpwrvgnd_1
XTAP_837 VGND VPWR sky130_fd_sc_hd__tapvpwrvgnd_1
XANTENNA__5691__B1 _2571_ VGND VGND VPWR VPWR sky130_fd_sc_hd__diode_2
X_6980_ clknet_leaf_10_clk _0059_ net74 VGND VGND VPWR VPWR u_pe_array.g_pe_row\[3\].g_pe_col\[2\].u_pe.psum_out\[7\]
+ sky130_fd_sc_hd__dfrtp_2
X_5931_ _2770_ VGND VGND VPWR VPWR _2771_ sky130_fd_sc_hd__inv_2
XFILLER_0_87_163 VGND VGND VPWR VPWR sky130_fd_sc_hd__fill_2
XFILLER_0_48_528 VGND VGND VPWR VPWR sky130_fd_sc_hd__fill_1
X_5862_ _2712_ _2717_ _2720_ _2715_ VGND VGND VPWR VPWR _2721_ sky130_fd_sc_hd__a22oi_2
X_7601_ clknet_leaf_22_clk _0650_ VGND VGND VPWR VPWR u_pe_array.u_fifo1.buffer\[2\]\[11\]
+ sky130_fd_sc_hd__dfxtp_1
XFILLER_0_8_625 VPWR VGND VPWR VGND sky130_ef_sc_hd__decap_12
XFILLER_0_7_113 VPWR VGND VPWR VGND sky130_ef_sc_hd__decap_12
X_4813_ _1832_ net5 _0754_ VGND VGND VPWR VPWR _1833_ sky130_fd_sc_hd__mux2_1
X_5793_ _2656_ _2657_ VGND VGND VPWR VPWR _2659_ sky130_fd_sc_hd__nand2_1
XFILLER_0_113_51 VGND VGND VPWR VPWR sky130_fd_sc_hd__decap_4
X_4744_ _1775_ _1780_ _1783_ _1778_ VGND VGND VPWR VPWR _1784_ sky130_fd_sc_hd__a22oi_1
XFILLER_0_56_583 VGND VGND VPWR VPWR sky130_fd_sc_hd__decap_3
X_7532_ clknet_leaf_93_clk _0581_ VGND VGND VPWR VPWR u_pe_array.u_fifo2.buffer\[7\]\[6\]
+ sky130_fd_sc_hd__dfxtp_1
XFILLER_0_8_669 VGND VGND VPWR VPWR sky130_fd_sc_hd__decap_8
XANTENNA__6621__S _3269_ VGND VGND VPWR VPWR sky130_fd_sc_hd__diode_2
XANTENNA__7271__RESET_B net814 VGND VGND VPWR VPWR sky130_fd_sc_hd__diode_2
XFILLER_0_22_93 VGND VGND VPWR VPWR sky130_fd_sc_hd__fill_2
XFILLER_0_71_575 VGND VGND VPWR VPWR sky130_fd_sc_hd__fill_2
X_4675_ _1720_ _1721_ VGND VGND VPWR VPWR _1722_ sky130_fd_sc_hd__and2b_1
XANTENNA__7200__RESET_B net815 VGND VGND VPWR VPWR sky130_fd_sc_hd__diode_2
X_7463_ clknet_leaf_4_clk _0512_ VGND VGND VPWR VPWR u_pe_array.u_fifo2.buffer\[2\]\[2\]
+ sky130_fd_sc_hd__dfxtp_1
XFILLER_0_114_666 VGND VGND VPWR VPWR sky130_fd_sc_hd__decap_4
XFILLER_0_113_143 VGND VGND VPWR VPWR sky130_fd_sc_hd__fill_2
X_7394_ clknet_leaf_42_clk net97 net817 VGND VGND VPWR VPWR u_pe_array.g_pe_row\[0\].g_pe_col\[0\].u_pe.w_reg\[0\]
+ sky130_fd_sc_hd__dfrtp_4
X_3626_ net179 _0834_ _0851_ u_fsm.psum_shift_en VGND VGND VPWR VPWR _0018_ sky130_fd_sc_hd__a22o_1
X_6414_ _3170_ VGND VGND VPWR VPWR _0487_ sky130_fd_sc_hd__clkbuf_1
X_6345_ _3123_ VGND VGND VPWR VPWR _0465_ sky130_fd_sc_hd__clkbuf_1
X_3557_ _0718_ _0801_ VGND VGND VPWR VPWR _0802_ sky130_fd_sc_hd__nor2_1
XFILLER_0_3_396 VGND VGND VPWR VPWR sky130_fd_sc_hd__decap_3
XFILLER_0_12_642 VGND VGND VPWR VPWR sky130_fd_sc_hd__fill_2
X_6276_ _3040_ _3041_ _3053_ _3063_ VGND VGND VPWR VPWR _3066_ sky130_fd_sc_hd__or4_1
XFILLER_0_11_163 VGND VGND VPWR VPWR sky130_fd_sc_hd__decap_4
X_3488_ u_pe_array.g_pe_row\[3\].g_pe_col\[0\].u_pe.move_reg\[11\] _0730_ VGND VGND
+ VPWR VPWR _0752_ sky130_fd_sc_hd__or2_1
X_5227_ u_pe_array.g_pe_row\[1\].g_pe_col\[2\].u_pe.act_val\[2\] u_pe_array.g_pe_row\[1\].g_pe_col\[2\].u_pe.act_val\[3\]
+ u_pe_array.g_pe_row\[1\].g_pe_col\[2\].u_pe.w_reg\[0\] _2158_ VGND VGND VPWR VPWR
+ _2179_ sky130_fd_sc_hd__and4b_1
XANTENNA__5682__B1 _2571_ VGND VGND VPWR VPWR sky130_fd_sc_hd__diode_2
X_5158_ _2129_ _2120_ VGND VGND VPWR VPWR _2130_ sky130_fd_sc_hd__and2b_1
XFILLER_0_98_439 VGND VGND VPWR VPWR sky130_fd_sc_hd__fill_2
X_5089_ _2053_ _2067_ VGND VGND VPWR VPWR _2068_ sky130_fd_sc_hd__or2_1
X_4109_ u_pe_array.g_pe_row\[3\].g_pe_col\[3\].u_pe.psum_out\[1\] u_pe_array.g_pe_row\[3\].g_pe_col\[3\].u_pe.act_val\[1\]
+ _0769_ VGND VGND VPWR VPWR _1257_ sky130_fd_sc_hd__mux2_1
XANTENNA__4824__B _0833_ VGND VGND VPWR VPWR sky130_fd_sc_hd__diode_2
XANTENNA__7359__RESET_B net813 VGND VGND VPWR VPWR sky130_fd_sc_hd__diode_2
XFILLER_0_94_645 VGND VGND VPWR VPWR sky130_fd_sc_hd__fill_1
XFILLER_0_93_100 VGND VGND VPWR VPWR sky130_fd_sc_hd__fill_1
XANTENNA__3996__B1 _1145_ VGND VGND VPWR VPWR sky130_fd_sc_hd__diode_2
XPHY_125 VGND VGND VPWR VPWR sky130_fd_sc_hd__decap_3
XPHY_114 VGND VGND VPWR VPWR sky130_fd_sc_hd__decap_3
XPHY_103 VGND VGND VPWR VPWR sky130_fd_sc_hd__decap_3
XANTENNA__5001__A _1787_ VGND VGND VPWR VPWR sky130_fd_sc_hd__diode_2
XANTENNA__4543__C _1536_ VGND VGND VPWR VPWR sky130_fd_sc_hd__diode_2
XPHY_158 VGND VGND VPWR VPWR sky130_fd_sc_hd__decap_3
XPHY_147 VGND VGND VPWR VPWR sky130_fd_sc_hd__decap_3
XPHY_136 VGND VGND VPWR VPWR sky130_fd_sc_hd__decap_3
XFILLER_0_66_369 VGND VGND VPWR VPWR sky130_fd_sc_hd__decap_4
XFILLER_0_47_550 VGND VGND VPWR VPWR sky130_fd_sc_hd__fill_2
XFILLER_0_93_177 VGND VGND VPWR VPWR sky130_fd_sc_hd__fill_2
XPHY_169 VGND VGND VPWR VPWR sky130_fd_sc_hd__decap_3
XANTENNA__6531__S _3224_ VGND VGND VPWR VPWR sky130_fd_sc_hd__diode_2
XFILLER_0_47_561 VGND VGND VPWR VPWR sky130_fd_sc_hd__decap_4
XFILLER_0_74_391 VGND VGND VPWR VPWR sky130_fd_sc_hd__fill_2
XFILLER_0_62_531 VGND VGND VPWR VPWR sky130_fd_sc_hd__fill_1
XFILLER_0_22_417 VGND VGND VPWR VPWR sky130_fd_sc_hd__decap_3
XFILLER_0_104_176 VGND VGND VPWR VPWR sky130_fd_sc_hd__fill_2
XANTENNA__6994__RESET_B net817 VGND VGND VPWR VPWR sky130_fd_sc_hd__diode_2
XANTENNA__6923__RESET_B net813 VGND VGND VPWR VPWR sky130_fd_sc_hd__diode_2
XANTENNA__3920__B1 _1009_ VGND VGND VPWR VPWR sky130_fd_sc_hd__diode_2
XANTENNA__5673__B1 net71 VGND VGND VPWR VPWR sky130_fd_sc_hd__diode_2
XFILLER_0_89_428 VGND VGND VPWR VPWR sky130_fd_sc_hd__fill_2
XANTENNA__5425__B1 _2071_ VGND VGND VPWR VPWR sky130_fd_sc_hd__diode_2
XFILLER_0_85_612 VGND VGND VPWR VPWR sky130_fd_sc_hd__fill_2
Xmax_cap72 _0913_ VGND VGND VPWR VPWR net72 sky130_fd_sc_hd__buf_6
XPHY_5 VGND VGND VPWR VPWR sky130_fd_sc_hd__decap_3
XFILLER_0_85_656 VGND VGND VPWR VPWR sky130_fd_sc_hd__fill_1
XFILLER_0_84_133 VGND VGND VPWR VPWR sky130_fd_sc_hd__fill_1
XANTENNA__7029__RESET_B net815 VGND VGND VPWR VPWR sky130_fd_sc_hd__diode_2
XFILLER_0_72_306 VGND VGND VPWR VPWR sky130_fd_sc_hd__fill_2
XANTENNA__4750__A net816 VGND VGND VPWR VPWR sky130_fd_sc_hd__diode_2
XFILLER_0_38_561 VGND VGND VPWR VPWR sky130_fd_sc_hd__fill_2
XFILLER_0_53_520 VGND VGND VPWR VPWR sky130_fd_sc_hd__fill_2
XFILLER_0_5_617 VPWR VGND VPWR VGND sky130_ef_sc_hd__decap_12
XFILLER_0_80_361 VGND VGND VPWR VPWR sky130_fd_sc_hd__decap_3
XFILLER_0_53_553 VGND VGND VPWR VPWR sky130_fd_sc_hd__decap_6
XFILLER_0_25_266 VGND VGND VPWR VPWR sky130_fd_sc_hd__fill_2
XFILLER_0_25_277 VGND VGND VPWR VPWR sky130_fd_sc_hd__decap_3
Xhold307 u_pe_array.u_fifo2.buffer\[8\]\[12\] VGND VGND VPWR VPWR net383 sky130_fd_sc_hd__dlygate4sd3_1
XFILLER_0_7_15 VPWR VGND VPWR VGND sky130_ef_sc_hd__decap_12
X_4460_ _1533_ _1538_ VGND VGND VPWR VPWR _1539_ sky130_fd_sc_hd__xnor2_1
XFILLER_0_40_236 VGND VGND VPWR VPWR sky130_fd_sc_hd__fill_2
Xhold329 u_pe_array.g_pe_row\[1\].g_pe_col\[1\].u_pe.psum_out\[6\] VGND VGND VPWR
+ VPWR net405 sky130_fd_sc_hd__dlygate4sd3_1
Xhold318 _0284_ VGND VGND VPWR VPWR net394 sky130_fd_sc_hd__dlygate4sd3_1
X_4391_ _1407_ u_pe_array.g_pe_row\[2\].g_pe_col\[3\].u_pe.psum_out\[9\] VGND VGND
+ VPWR VPWR _1490_ sky130_fd_sc_hd__nor2_1
XANTENNA__5900__A1 _2740_ VGND VGND VPWR VPWR sky130_fd_sc_hd__diode_2
XFILLER_0_111_669 VGND VGND VPWR VPWR sky130_fd_sc_hd__fill_1
X_6130_ _2740_ _2936_ _2938_ _2571_ net385 VGND VGND VPWR VPWR _0435_ sky130_fd_sc_hd__a32o_1
XFILLER_0_21_483 VGND VGND VPWR VPWR sky130_fd_sc_hd__fill_1
XANTENNA__3911__B1 net72 VGND VGND VPWR VPWR sky130_fd_sc_hd__diode_2
XANTENNA__4909__B _1847_ VGND VGND VPWR VPWR sky130_fd_sc_hd__diode_2
XFILLER_0_0_377 VPWR VGND VPWR VGND sky130_ef_sc_hd__decap_12
XFILLER_0_21_494 VGND VGND VPWR VPWR sky130_fd_sc_hd__fill_2
XTAP_601 VGND VPWR sky130_fd_sc_hd__tapvpwrvgnd_1
XTAP_612 VGND VPWR sky130_fd_sc_hd__tapvpwrvgnd_1
XTAP_623 VGND VPWR sky130_fd_sc_hd__tapvpwrvgnd_1
XTAP_634 VGND VPWR sky130_fd_sc_hd__tapvpwrvgnd_1
X_6061_ _2872_ _2874_ VGND VGND VPWR VPWR _2875_ sky130_fd_sc_hd__xor2_1
XANTENNA__4197__A u_pe_array.g_pe_row\[3\].g_pe_col\[0\].u_pe.w_reg\[0\] VGND VGND
+ VPWR VPWR sky130_fd_sc_hd__diode_2
XTAP_656 VGND VPWR sky130_fd_sc_hd__tapvpwrvgnd_1
XTAP_645 VGND VPWR sky130_fd_sc_hd__tapvpwrvgnd_1
XTAP_667 VGND VPWR sky130_fd_sc_hd__tapvpwrvgnd_1
X_5012_ u_pe_array.u_fifo2.buffer\[0\]\[4\] _1962_ VGND VGND VPWR VPWR _2004_ sky130_fd_sc_hd__or2_1
XTAP_678 VGND VPWR sky130_fd_sc_hd__tapvpwrvgnd_1
XTAP_689 VGND VPWR sky130_fd_sc_hd__tapvpwrvgnd_1
XFILLER_0_88_461 VGND VGND VPWR VPWR sky130_fd_sc_hd__fill_2
X_6963_ clknet_leaf_11_clk _0044_ net74 VGND VGND VPWR VPWR u_pe_array.g_pe_row\[3\].g_pe_col\[1\].u_pe.act_val\[5\]
+ sky130_fd_sc_hd__dfrtp_2
X_6894_ net443 _3116_ _3427_ VGND VGND VPWR VPWR _3431_ sky130_fd_sc_hd__mux2_1
XFILLER_0_76_645 VGND VGND VPWR VPWR sky130_fd_sc_hd__fill_2
XFILLER_0_76_623 VGND VGND VPWR VPWR sky130_fd_sc_hd__fill_2
X_5914_ _2754_ u_pe_array.g_pe_row\[0\].g_pe_col\[2\].u_pe.psum_out\[1\] _2743_ VGND
+ VGND VPWR VPWR _2755_ sky130_fd_sc_hd__o21a_1
XFILLER_0_48_358 VGND VGND VPWR VPWR sky130_fd_sc_hd__fill_2
X_5845_ _2611_ u_pe_array.g_pe_row\[0\].g_pe_col\[3\].u_pe.psum_out\[10\] VGND VGND
+ VPWR VPWR _2706_ sky130_fd_sc_hd__or2_1
XFILLER_0_91_615 VGND VGND VPWR VPWR sky130_fd_sc_hd__fill_1
XFILLER_0_90_114 VGND VGND VPWR VPWR sky130_fd_sc_hd__fill_2
XFILLER_0_63_317 VGND VGND VPWR VPWR sky130_fd_sc_hd__fill_2
XFILLER_0_8_455 VGND VGND VPWR VPWR sky130_fd_sc_hd__fill_2
XFILLER_0_44_531 VGND VGND VPWR VPWR sky130_fd_sc_hd__fill_1
XFILLER_0_8_477 VPWR VGND VPWR VGND sky130_ef_sc_hd__decap_12
XFILLER_0_8_466 VGND VGND VPWR VPWR sky130_fd_sc_hd__fill_2
X_5776_ _2611_ _2642_ u_pe_array.g_pe_row\[0\].g_pe_col\[3\].u_pe.act_val\[4\] u_pe_array.g_pe_row\[0\].g_pe_col\[3\].u_pe.w_reg\[0\]
+ VGND VGND VPWR VPWR _2643_ sky130_fd_sc_hd__a22o_1
X_4727_ _1672_ u_pe_array.g_pe_row\[2\].g_pe_col\[1\].u_pe.psum_out\[10\] VGND VGND
+ VPWR VPWR _1769_ sky130_fd_sc_hd__or2_1
X_7515_ clknet_leaf_3_clk _0564_ VGND VGND VPWR VPWR u_pe_array.u_fifo2.buffer\[6\]\[2\]
+ sky130_fd_sc_hd__dfxtp_1
XANTENNA__6144__A1 _2873_ VGND VGND VPWR VPWR sky130_fd_sc_hd__diode_2
X_4658_ u_pe_array.g_pe_row\[2\].g_pe_col\[1\].u_pe.psum_out\[4\] _1704_ _1705_ VGND
+ VGND VPWR VPWR _1706_ sky130_fd_sc_hd__nand3_1
XANTENNA__4091__A_N _1145_ VGND VGND VPWR VPWR sky130_fd_sc_hd__diode_2
X_7446_ clknet_leaf_92_clk _0495_ VGND VGND VPWR VPWR u_pe_array.u_fifo2.buffer\[0\]\[11\]
+ sky130_fd_sc_hd__dfxtp_1
XFILLER_0_31_225 VGND VGND VPWR VPWR sky130_fd_sc_hd__decap_4
XFILLER_0_102_636 VGND VGND VPWR VPWR sky130_fd_sc_hd__decap_8
X_3609_ net22 _0840_ _0819_ VGND VGND VPWR VPWR _0841_ sky130_fd_sc_hd__mux2_1
XFILLER_0_102_669 VGND VGND VPWR VPWR sky130_fd_sc_hd__decap_8
XFILLER_0_101_124 VGND VGND VPWR VPWR sky130_fd_sc_hd__decap_8
X_7377_ clknet_leaf_45_clk _0430_ net812 VGND VGND VPWR VPWR u_pe_array.g_pe_row\[0\].g_pe_col\[1\].u_pe.psum_out\[1\]
+ sky130_fd_sc_hd__dfrtp_1
X_4589_ net707 _1524_ _1258_ _1652_ VGND VGND VPWR VPWR _0180_ sky130_fd_sc_hd__a22o_1
XFILLER_0_3_193 VGND VGND VPWR VPWR sky130_fd_sc_hd__decap_6
X_6328_ _1787_ _1124_ net53 VGND VGND VPWR VPWR _3112_ sky130_fd_sc_hd__a21o_2
X_6259_ _3047_ _3048_ _3050_ VGND VGND VPWR VPWR _3051_ sky130_fd_sc_hd__and3_1
XANTENNA__5618__A1_N u_pe_array.g_pe_row\[1\].g_pe_col\[0\].u_pe.act_val\[4\] VGND
+ VGND VPWR VPWR sky130_fd_sc_hd__diode_2
XANTENNA__7193__RESET_B net812 VGND VGND VPWR VPWR sky130_fd_sc_hd__diode_2
XFILLER_0_67_667 VGND VGND VPWR VPWR sky130_fd_sc_hd__fill_2
XFILLER_0_67_645 VGND VGND VPWR VPWR sky130_fd_sc_hd__fill_2
XFILLER_0_39_347 VGND VGND VPWR VPWR sky130_fd_sc_hd__fill_2
XANTENNA__7122__RESET_B net76 VGND VGND VPWR VPWR sky130_fd_sc_hd__diode_2
XFILLER_0_54_306 VGND VGND VPWR VPWR sky130_fd_sc_hd__fill_2
XFILLER_0_109_279 VGND VGND VPWR VPWR sky130_fd_sc_hd__fill_1
XANTENNA__5186__A2 _2144_ VGND VGND VPWR VPWR sky130_fd_sc_hd__diode_2
XFILLER_0_35_520 VPWR VGND VPWR VGND sky130_ef_sc_hd__decap_12
XFILLER_0_81_169 VGND VGND VPWR VPWR sky130_fd_sc_hd__decap_4
XANTENNA__6135__A1 _2740_ VGND VGND VPWR VPWR sky130_fd_sc_hd__diode_2
XFILLER_0_50_512 VGND VGND VPWR VPWR sky130_fd_sc_hd__fill_2
XANTENNA__4146__B1 _1144_ VGND VGND VPWR VPWR sky130_fd_sc_hd__diode_2
XFILLER_0_50_545 VGND VGND VPWR VPWR sky130_fd_sc_hd__decap_4
XFILLER_0_50_589 VGND VGND VPWR VPWR sky130_fd_sc_hd__fill_2
XFILLER_0_89_225 VGND VGND VPWR VPWR sky130_fd_sc_hd__decap_4
X_3960_ u_pe_array.g_pe_row\[2\].g_pe_col\[0\].u_pe.act_val\[5\] u_pe_array.g_pe_row\[2\].g_pe_col\[0\].u_pe.psum_out\[5\]
+ _0755_ VGND VGND VPWR VPWR _1132_ sky130_fd_sc_hd__mux2_1
XFILLER_0_57_166 VGND VGND VPWR VPWR sky130_fd_sc_hd__fill_2
XFILLER_0_45_317 VGND VGND VPWR VPWR sky130_fd_sc_hd__fill_2
X_3891_ u_pe_array.g_pe_row\[3\].g_pe_col\[2\].u_pe.psum_out\[7\] _1009_ VGND VGND
+ VPWR VPWR _1076_ sky130_fd_sc_hd__nand2_1
XANTENNA__5177__A2 _1666_ VGND VGND VPWR VPWR sky130_fd_sc_hd__diode_2
XFILLER_0_72_147 VGND VGND VPWR VPWR sky130_fd_sc_hd__decap_4
X_5630_ u_pe_array.g_pe_row\[1\].g_pe_col\[0\].u_pe.psum_out\[5\] _2523_ VGND VGND
+ VPWR VPWR _2524_ sky130_fd_sc_hd__xnor2_1
XFILLER_0_92_9 VGND VGND VPWR VPWR sky130_fd_sc_hd__fill_1
XFILLER_0_60_309 VGND VGND VPWR VPWR sky130_fd_sc_hd__fill_1
X_5561_ net605 _2463_ _1655_ _2467_ VGND VGND VPWR VPWR _0337_ sky130_fd_sc_hd__a22o_1
XFILLER_0_26_553 VGND VGND VPWR VPWR sky130_fd_sc_hd__fill_1
XFILLER_0_41_501 VGND VGND VPWR VPWR sky130_fd_sc_hd__decap_3
X_5492_ _2345_ u_pe_array.g_pe_row\[1\].g_pe_col\[1\].u_pe.psum_out\[7\] VGND VGND
+ VPWR VPWR _2412_ sky130_fd_sc_hd__xor2_1
XFILLER_0_13_225 VGND VGND VPWR VPWR sky130_fd_sc_hd__decap_4
X_4512_ _1573_ _1576_ _1585_ _0885_ VGND VGND VPWR VPWR _1587_ sky130_fd_sc_hd__o31a_1
X_7300_ clknet_leaf_79_clk _0359_ net814 VGND VGND VPWR VPWR u_pe_array.g_pe_row\[0\].g_pe_col\[3\].u_pe.w_buffer\[1\]
+ sky130_fd_sc_hd__dfrtp_1
XFILLER_0_111_411 VGND VGND VPWR VPWR sky130_fd_sc_hd__fill_2
XFILLER_0_110_41 VPWR VGND VPWR VGND sky130_ef_sc_hd__decap_12
Xhold115 u_pe_array.g_pe_row\[1\].g_pe_col\[0\].u_pe.move_reg\[10\] VGND VGND VPWR
+ VPWR net191 sky130_fd_sc_hd__dlygate4sd3_1
XFILLER_0_80_191 VGND VGND VPWR VPWR sky130_fd_sc_hd__fill_2
XFILLER_0_79_77 VPWR VGND VPWR VGND sky130_ef_sc_hd__decap_12
XANTENNA__4137__B1 _1144_ VGND VGND VPWR VPWR sky130_fd_sc_hd__diode_2
Xhold104 u_pe_array.g_pe_row\[2\].g_pe_col\[1\].u_pe.move_reg\[8\] VGND VGND VPWR
+ VPWR net180 sky130_fd_sc_hd__dlygate4sd3_1
Xhold126 _0254_ VGND VGND VPWR VPWR net202 sky130_fd_sc_hd__dlygate4sd3_1
X_7231_ clknet_leaf_64_clk _0294_ net73 VGND VGND VPWR VPWR u_pe_array.g_pe_row\[1\].g_pe_col\[2\].u_pe.psum_out\[5\]
+ sky130_fd_sc_hd__dfrtp_1
Xhold159 u_pe_array.u_fifo1.buffer\[1\]\[8\] VGND VGND VPWR VPWR net235 sky130_fd_sc_hd__dlygate4sd3_1
X_4443_ u_pe_array.g_pe_row\[3\].g_pe_col\[1\].u_pe.psum_out\[9\] net184 _0855_ VGND
+ VGND VPWR VPWR _1527_ sky130_fd_sc_hd__mux2_1
Xhold137 u_pe_array.u_fifo2.buffer\[6\]\[7\] VGND VGND VPWR VPWR net213 sky130_fd_sc_hd__dlygate4sd3_1
Xhold148 u_pe_array.u_fifo2.buffer\[2\]\[12\] VGND VGND VPWR VPWR net224 sky130_fd_sc_hd__dlygate4sd3_1
XFILLER_0_1_653 VGND VGND VPWR VPWR sky130_fd_sc_hd__decap_8
XFILLER_0_0_141 VPWR VGND VPWR VGND sky130_ef_sc_hd__decap_12
X_4374_ _1471_ _1469_ _1473_ VGND VGND VPWR VPWR _1475_ sky130_fd_sc_hd__o21ai_1
X_7162_ clknet_leaf_70_clk _0231_ net814 VGND VGND VPWR VPWR u_pe_array.g_pe_row\[1\].g_pe_col\[3\].u_pe.move_reg\[11\]
+ sky130_fd_sc_hd__dfrtp_1
X_6113_ _2910_ _2913_ _2922_ VGND VGND VPWR VPWR _2923_ sky130_fd_sc_hd__o21ai_1
XTAP_420 VGND VPWR sky130_fd_sc_hd__tapvpwrvgnd_1
XTAP_431 VGND VPWR sky130_fd_sc_hd__tapvpwrvgnd_1
XTAP_442 VGND VPWR sky130_fd_sc_hd__tapvpwrvgnd_1
X_7093_ clknet_leaf_92_clk _0164_ net819 VGND VGND VPWR VPWR u_pe_array.g_pe_row\[2\].g_pe_col\[2\].u_pe.psum_out\[0\]
+ sky130_fd_sc_hd__dfrtp_1
X_6044_ u_pe_array.g_pe_row\[0\].g_pe_col\[1\].u_pe.psum_out\[8\] u_pe_array.g_pe_row\[0\].g_pe_col\[1\].u_pe.move_reg\[8\]
+ _2469_ VGND VGND VPWR VPWR _2864_ sky130_fd_sc_hd__mux2_1
XANTENNA__5637__B1 _0885_ VGND VGND VPWR VPWR sky130_fd_sc_hd__diode_2
XTAP_453 VGND VPWR sky130_fd_sc_hd__tapvpwrvgnd_1
XTAP_464 VGND VPWR sky130_fd_sc_hd__tapvpwrvgnd_1
XTAP_475 VGND VPWR sky130_fd_sc_hd__tapvpwrvgnd_1
XTAP_486 VGND VPWR sky130_fd_sc_hd__tapvpwrvgnd_1
XTAP_497 VGND VPWR sky130_fd_sc_hd__tapvpwrvgnd_1
XFILLER_0_21_3 VPWR VGND VPWR VGND sky130_ef_sc_hd__decap_12
XTAP_1619 VGND VPWR sky130_fd_sc_hd__tapvpwrvgnd_1
XTAP_1608 VGND VPWR sky130_fd_sc_hd__tapvpwrvgnd_1
X_6946_ clknet_leaf_76_clk _0027_ net815 VGND VGND VPWR VPWR u_pe_array.g_pe_row\[3\].g_pe_col\[3\].u_pe.psum_out\[3\]
+ sky130_fd_sc_hd__dfrtp_1
XANTENNA__4612__B2 _1665_ VGND VGND VPWR VPWR sky130_fd_sc_hd__diode_2
X_6877_ _3421_ VGND VGND VPWR VPWR _0699_ sky130_fd_sc_hd__clkbuf_1
XFILLER_0_76_475 VGND VGND VPWR VPWR sky130_fd_sc_hd__fill_1
XFILLER_0_64_626 VGND VGND VPWR VPWR sky130_fd_sc_hd__fill_2
XFILLER_0_36_317 VGND VGND VPWR VPWR sky130_fd_sc_hd__fill_1
XANTENNA__4390__A _1407_ VGND VGND VPWR VPWR sky130_fd_sc_hd__diode_2
XFILLER_0_29_391 VGND VGND VPWR VPWR sky130_fd_sc_hd__fill_1
X_5828_ _2689_ _2690_ VGND VGND VPWR VPWR _2691_ sky130_fd_sc_hd__or2_1
XFILLER_0_106_216 VGND VGND VPWR VPWR sky130_fd_sc_hd__fill_2
X_5759_ _2619_ _2623_ VGND VGND VPWR VPWR _2627_ sky130_fd_sc_hd__nor2_1
XFILLER_0_32_501 VPWR VGND VPWR VGND sky130_ef_sc_hd__decap_12
XANTENNA__6668__A2 _2273_ VGND VGND VPWR VPWR sky130_fd_sc_hd__diode_2
XFILLER_0_44_394 VGND VGND VPWR VPWR sky130_fd_sc_hd__fill_1
X_7429_ clknet_leaf_7_clk _0478_ net74 VGND VGND VPWR VPWR u_pe_array.u_fifo2.rd_ptr\[2\]
+ sky130_fd_sc_hd__dfrtp_2
XFILLER_0_102_466 VGND VGND VPWR VPWR sky130_fd_sc_hd__decap_4
Xhold660 u_pe_array.g_pe_row\[2\].g_pe_col\[0\].u_pe.act_val\[2\] VGND VGND VPWR VPWR
+ net736 sky130_fd_sc_hd__dlygate4sd3_1
Xhold671 u_pe_array.g_pe_row\[3\].g_pe_col\[3\].u_pe.act_val\[5\] VGND VGND VPWR VPWR
+ net747 sky130_fd_sc_hd__dlygate4sd3_1
Xhold693 u_pe_array.g_pe_row\[2\].g_pe_col\[1\].u_pe.act_val\[0\] VGND VGND VPWR VPWR
+ net769 sky130_fd_sc_hd__dlygate4sd3_1
Xhold682 u_pe_array.g_pe_row\[2\].g_pe_col\[2\].u_pe.psum_out\[4\] VGND VGND VPWR
+ VPWR net758 sky130_fd_sc_hd__dlygate4sd3_1
XFILLER_0_99_512 VGND VGND VPWR VPWR sky130_fd_sc_hd__fill_2
XANTENNA__7374__RESET_B net812 VGND VGND VPWR VPWR sky130_fd_sc_hd__diode_2
XFILLER_0_99_523 VGND VGND VPWR VPWR sky130_fd_sc_hd__fill_2
XANTENNA__7303__RESET_B net814 VGND VGND VPWR VPWR sky130_fd_sc_hd__diode_2
XFILLER_0_67_442 VGND VGND VPWR VPWR sky130_fd_sc_hd__fill_2
XFILLER_0_39_111 VGND VGND VPWR VPWR sky130_fd_sc_hd__fill_1
XFILLER_0_55_615 VGND VGND VPWR VPWR sky130_fd_sc_hd__fill_1
XFILLER_0_54_114 VGND VGND VPWR VPWR sky130_fd_sc_hd__fill_1
XANTENNA__5827__C _2611_ VGND VGND VPWR VPWR sky130_fd_sc_hd__diode_2
XFILLER_0_40_27 VGND VGND VPWR VPWR sky130_fd_sc_hd__fill_1
Xload_slew5 net76 VGND VGND VPWR VPWR net816 sky130_fd_sc_hd__buf_12
XFILLER_0_40_38 VGND VGND VPWR VPWR sky130_fd_sc_hd__decap_4
XFILLER_0_82_489 VGND VGND VPWR VPWR sky130_fd_sc_hd__fill_2
XFILLER_0_62_191 VGND VGND VPWR VPWR sky130_fd_sc_hd__decap_4
XANTENNA__4119__B1 _1258_ VGND VGND VPWR VPWR sky130_fd_sc_hd__diode_2
XFILLER_0_2_406 VGND VGND VPWR VPWR sky130_fd_sc_hd__fill_2
XFILLER_0_49_25 VGND VGND VPWR VPWR sky130_fd_sc_hd__fill_1
XFILLER_0_10_217 VGND VGND VPWR VPWR sky130_fd_sc_hd__decap_4
XFILLER_0_65_57 VPWR VGND VPWR VGND sky130_ef_sc_hd__decap_12
X_4090_ u_pe_array.g_pe_row\[3\].g_pe_col\[1\].u_pe.psum_out\[11\] _1145_ VGND VGND
+ VPWR VPWR _1243_ sky130_fd_sc_hd__and2b_1
XANTENNA__7044__RESET_B net76 VGND VGND VPWR VPWR sky130_fd_sc_hd__diode_2
X_6800_ _3379_ VGND VGND VPWR VPWR _0664_ sky130_fd_sc_hd__clkbuf_1
XANTENNA__5398__A2 _2330_ VGND VGND VPWR VPWR sky130_fd_sc_hd__diode_2
X_4992_ _1787_ _1986_ VGND VGND VPWR VPWR _1987_ sky130_fd_sc_hd__or2_1
XANTENNA__6595__A1 _1818_ VGND VGND VPWR VPWR sky130_fd_sc_hd__diode_2
XFILLER_0_105_63 VGND VGND VPWR VPWR sky130_fd_sc_hd__decap_6
X_6731_ net522 _3120_ net65 VGND VGND VPWR VPWR _3344_ sky130_fd_sc_hd__mux2_1
X_3943_ net88 net81 _0828_ VGND VGND VPWR VPWR _1121_ sky130_fd_sc_hd__mux2_1
XFILLER_0_58_475 VGND VGND VPWR VPWR sky130_fd_sc_hd__fill_1
XFILLER_0_18_306 VGND VGND VPWR VPWR sky130_fd_sc_hd__fill_2
X_6662_ _3106_ u_pe_array.u_fifo1.wr_ptr\[1\] _3296_ u_pe_array.u_fifo1.wr_ptr\[2\]
+ VGND VGND VPWR VPWR _3303_ sky130_fd_sc_hd__a31o_1
XFILLER_0_45_136 VGND VGND VPWR VPWR sky130_fd_sc_hd__decap_4
XFILLER_0_18_339 VPWR VGND VPWR VGND sky130_ef_sc_hd__decap_12
X_3874_ _1059_ _1060_ VGND VGND VPWR VPWR _1061_ sky130_fd_sc_hd__nand2_1
Xclkbuf_3_2__f_clk clknet_0_clk VGND VGND VPWR VPWR clknet_3_2__leaf_clk sky130_fd_sc_hd__clkbuf_16
X_5613_ _2258_ _2507_ _2508_ _2071_ net399 VGND VGND VPWR VPWR _0348_ sky130_fd_sc_hd__a32o_1
XFILLER_0_73_489 VGND VGND VPWR VPWR sky130_fd_sc_hd__fill_2
XFILLER_0_60_106 VGND VGND VPWR VPWR sky130_fd_sc_hd__fill_2
XFILLER_0_14_501 VGND VGND VPWR VPWR sky130_fd_sc_hd__fill_2
X_6593_ net334 _1816_ _3254_ VGND VGND VPWR VPWR _3265_ sky130_fd_sc_hd__mux2_1
X_5544_ net435 _2387_ _2174_ _2458_ VGND VGND VPWR VPWR _0329_ sky130_fd_sc_hd__a22o_1
XANTENNA__3992__B_N _1145_ VGND VGND VPWR VPWR sky130_fd_sc_hd__diode_2
XFILLER_0_53_191 VPWR VGND VPWR VGND sky130_ef_sc_hd__decap_12
XANTENNA__5570__A2 _2463_ VGND VGND VPWR VPWR sky130_fd_sc_hd__diode_2
XFILLER_0_41_331 VGND VGND VPWR VPWR sky130_fd_sc_hd__fill_2
X_5475_ _2382_ _2385_ _2395_ _0885_ VGND VGND VPWR VPWR _2397_ sky130_fd_sc_hd__o31a_1
XFILLER_0_14_578 VGND VGND VPWR VPWR sky130_fd_sc_hd__decap_3
XFILLER_0_14_589 VGND VGND VPWR VPWR sky130_fd_sc_hd__decap_3
X_7214_ clknet_leaf_56_clk _0279_ net75 VGND VGND VPWR VPWR u_pe_array.g_pe_row\[1\].g_pe_col\[1\].u_pe.act_val\[3\]
+ sky130_fd_sc_hd__dfrtp_1
X_4426_ u_pe_array.g_pe_row\[3\].g_pe_col\[1\].u_pe.act_val\[1\] u_pe_array.g_pe_row\[3\].g_pe_col\[1\].u_pe.psum_out\[1\]
+ _0770_ VGND VGND VPWR VPWR _1518_ sky130_fd_sc_hd__mux2_1
XFILLER_0_1_461 VPWR VGND VPWR VGND sky130_ef_sc_hd__decap_12
X_7145_ clknet_leaf_93_clk _0214_ VGND VGND VPWR VPWR u_pe_array.u_fifo2.buffer\[8\]\[9\]
+ sky130_fd_sc_hd__dfxtp_1
X_4357_ net610 _1152_ _1458_ _1459_ VGND VGND VPWR VPWR _0141_ sky130_fd_sc_hd__a22o_1
XTAP_250 VGND VPWR sky130_fd_sc_hd__tapvpwrvgnd_1
XTAP_283 VGND VPWR sky130_fd_sc_hd__tapvpwrvgnd_1
XTAP_261 VGND VPWR sky130_fd_sc_hd__tapvpwrvgnd_1
XTAP_272 VGND VPWR sky130_fd_sc_hd__tapvpwrvgnd_1
X_4288_ net187 _1392_ _1400_ _1399_ VGND VGND VPWR VPWR _0131_ sky130_fd_sc_hd__a22o_1
X_7076_ clknet_leaf_81_clk _0149_ net815 VGND VGND VPWR VPWR u_pe_array.g_pe_row\[2\].g_pe_col\[2\].u_pe.w_buffer\[0\]
+ sky130_fd_sc_hd__dfrtp_1
X_6027_ _2855_ VGND VGND VPWR VPWR _0415_ sky130_fd_sc_hd__clkbuf_1
XTAP_294 VGND VPWR sky130_fd_sc_hd__tapvpwrvgnd_1
XANTENNA__6035__B1 _2592_ VGND VGND VPWR VPWR sky130_fd_sc_hd__diode_2
XTAP_1405 VGND VPWR sky130_fd_sc_hd__tapvpwrvgnd_1
XFILLER_0_68_206 VGND VGND VPWR VPWR sky130_fd_sc_hd__fill_1
XTAP_1438 VGND VPWR sky130_fd_sc_hd__tapvpwrvgnd_1
XTAP_1427 VGND VPWR sky130_fd_sc_hd__tapvpwrvgnd_1
XTAP_1416 VGND VPWR sky130_fd_sc_hd__tapvpwrvgnd_1
XANTENNA__5389__A2 _2322_ VGND VGND VPWR VPWR sky130_fd_sc_hd__diode_2
XANTENNA__6804__S _3382_ VGND VGND VPWR VPWR sky130_fd_sc_hd__diode_2
XTAP_1449 VGND VPWR sky130_fd_sc_hd__tapvpwrvgnd_1
XFILLER_0_49_453 VGND VGND VPWR VPWR sky130_fd_sc_hd__decap_3
X_6929_ clknet_leaf_92_clk _0012_ net819 VGND VGND VPWR VPWR u_pe_array.g_pe_row\[3\].g_pe_col\[2\].u_pe.act_val\[1\]
+ sky130_fd_sc_hd__dfrtp_2
XFILLER_0_37_615 VGND VGND VPWR VPWR sky130_fd_sc_hd__fill_1
XFILLER_0_37_626 VGND VGND VPWR VPWR sky130_fd_sc_hd__fill_2
XFILLER_0_64_434 VGND VGND VPWR VPWR sky130_fd_sc_hd__fill_2
XFILLER_0_9_561 VPWR VGND VPWR VGND sky130_ef_sc_hd__decap_12
XFILLER_0_36_136 VGND VGND VPWR VPWR sky130_fd_sc_hd__fill_2
Xfanout76 net13 VGND VGND VPWR VPWR net76 sky130_fd_sc_hd__clkbuf_16
XFILLER_0_24_309 VGND VGND VPWR VPWR sky130_fd_sc_hd__decap_4
XFILLER_0_45_670 VGND VGND VPWR VPWR sky130_fd_sc_hd__fill_2
XFILLER_0_51_139 VGND VGND VPWR VPWR sky130_fd_sc_hd__fill_2
XANTENNA__5561__A2 _2463_ VGND VGND VPWR VPWR sky130_fd_sc_hd__diode_2
XFILLER_0_102_241 VGND VGND VPWR VPWR sky130_fd_sc_hd__fill_2
XANTENNA__6510__A1 _1818_ VGND VGND VPWR VPWR sky130_fd_sc_hd__diode_2
XFILLER_0_20_537 VGND VGND VPWR VPWR sky130_fd_sc_hd__fill_2
Xhold490 u_pe_array.g_pe_row\[0\].g_pe_col\[3\].u_pe.act_val\[1\] VGND VGND VPWR VPWR
+ net566 sky130_fd_sc_hd__dlygate4sd3_1
XANTENNA__7555__RESET_B net816 VGND VGND VPWR VPWR sky130_fd_sc_hd__diode_2
XFILLER_0_99_353 VPWR VGND VPWR VGND sky130_ef_sc_hd__decap_12
XFILLER_0_99_397 VGND VGND VPWR VPWR sky130_fd_sc_hd__decap_6
XFILLER_0_99_386 VGND VGND VPWR VPWR sky130_fd_sc_hd__decap_6
XFILLER_0_99_375 VGND VGND VPWR VPWR sky130_fd_sc_hd__decap_6
XFILLER_0_87_559 VGND VGND VPWR VPWR sky130_fd_sc_hd__fill_1
XANTENNA__4052__A2 _1152_ VGND VGND VPWR VPWR sky130_fd_sc_hd__diode_2
XFILLER_0_95_581 VPWR VGND VPWR VGND sky130_ef_sc_hd__decap_12
XFILLER_0_67_272 VGND VGND VPWR VPWR sky130_fd_sc_hd__decap_8
XFILLER_0_55_456 VGND VGND VPWR VPWR sky130_fd_sc_hd__decap_8
XFILLER_0_27_169 VGND VGND VPWR VPWR sky130_fd_sc_hd__fill_2
XFILLER_0_70_437 VGND VGND VPWR VPWR sky130_fd_sc_hd__decap_8
XFILLER_0_42_128 VGND VGND VPWR VPWR sky130_fd_sc_hd__decap_3
XFILLER_0_113_517 VPWR VGND VPWR VGND sky130_ef_sc_hd__decap_12
X_3590_ _0801_ _0824_ _0825_ VGND VGND VPWR VPWR _0826_ sky130_fd_sc_hd__and3_1
XANTENNA__5552__A2 _2144_ VGND VGND VPWR VPWR sky130_fd_sc_hd__diode_2
XFILLER_0_51_673 VGND VGND VPWR VPWR sky130_fd_sc_hd__fill_2
XANTENNA__4760__B1 _0988_ VGND VGND VPWR VPWR sky130_fd_sc_hd__diode_2
X_5260_ _2196_ _2199_ _2208_ _0885_ VGND VGND VPWR VPWR _2210_ sky130_fd_sc_hd__o31a_1
XFILLER_0_50_183 VGND VGND VPWR VPWR sky130_fd_sc_hd__fill_2
X_4211_ _1273_ _1338_ _1340_ _1144_ net398 VGND VGND VPWR VPWR _0114_ sky130_fd_sc_hd__a32o_1
XANTENNA__4512__B1 _0885_ VGND VGND VPWR VPWR sky130_fd_sc_hd__diode_2
XANTENNA__7296__RESET_B net813 VGND VGND VPWR VPWR sky130_fd_sc_hd__diode_2
X_5191_ u_pe_array.g_pe_row\[1\].g_pe_col\[2\].u_pe.psum_out\[9\] u_pe_array.g_pe_row\[1\].g_pe_col\[2\].u_pe.move_reg\[9\]
+ _1661_ VGND VGND VPWR VPWR _2150_ sky130_fd_sc_hd__mux2_1
X_4142_ _1274_ _1276_ VGND VGND VPWR VPWR _1277_ sky130_fd_sc_hd__xor2_1
XANTENNA__7225__RESET_B net73 VGND VGND VPWR VPWR sky130_fd_sc_hd__diode_2
X_4073_ _1145_ u_pe_array.g_pe_row\[3\].g_pe_col\[1\].u_pe.psum_out\[9\] VGND VGND
+ VPWR VPWR _1228_ sky130_fd_sc_hd__and2_1
XFILLER_0_58_261 VGND VGND VPWR VPWR sky130_fd_sc_hd__decap_3
XFILLER_0_58_250 VGND VGND VPWR VPWR sky130_fd_sc_hd__fill_2
X_4975_ u_pe_array.u_fifo2.rd_ptr\[1\] u_pe_array.u_fifo2.rd_ptr\[0\] _1958_ u_pe_array.u_fifo2.rd_ptr\[2\]
+ VGND VGND VPWR VPWR _1971_ sky130_fd_sc_hd__and4b_2
X_6714_ net297 _3130_ net66 VGND VGND VPWR VPWR _3335_ sky130_fd_sc_hd__mux2_1
XFILLER_0_46_434 VGND VGND VPWR VPWR sky130_fd_sc_hd__fill_2
X_3926_ _1103_ _1107_ VGND VGND VPWR VPWR _1108_ sky130_fd_sc_hd__or2_1
XFILLER_0_19_648 VGND VGND VPWR VPWR sky130_fd_sc_hd__fill_2
XFILLER_0_46_456 VGND VGND VPWR VPWR sky130_fd_sc_hd__fill_2
XFILLER_0_18_136 VGND VGND VPWR VPWR sky130_fd_sc_hd__fill_2
XFILLER_0_73_264 VGND VGND VPWR VPWR sky130_fd_sc_hd__decap_8
XFILLER_0_6_531 VGND VGND VPWR VPWR sky130_fd_sc_hd__fill_1
XFILLER_0_18_169 VGND VGND VPWR VPWR sky130_fd_sc_hd__decap_4
X_6645_ net660 _0833_ VGND VGND VPWR VPWR _3292_ sky130_fd_sc_hd__and2_1
X_3857_ _1043_ _1044_ VGND VGND VPWR VPWR _1045_ sky130_fd_sc_hd__nor2_1
X_3788_ _0737_ _0990_ _0754_ VGND VGND VPWR VPWR _0991_ sky130_fd_sc_hd__mux2_1
X_6576_ _3256_ VGND VGND VPWR VPWR _0563_ sky130_fd_sc_hd__clkbuf_1
XFILLER_0_26_191 VGND VGND VPWR VPWR sky130_fd_sc_hd__fill_2
X_5527_ _2345_ u_pe_array.g_pe_row\[1\].g_pe_col\[1\].u_pe.psum_out\[9\] _2443_ VGND
+ VGND VPWR VPWR _2444_ sky130_fd_sc_hd__and3_1
XFILLER_0_42_673 VGND VGND VPWR VPWR sky130_fd_sc_hd__decap_4
XANTENNA_load_slew8_A net74 VGND VGND VPWR VPWR sky130_fd_sc_hd__diode_2
X_5458_ u_pe_array.g_pe_row\[1\].g_pe_col\[1\].u_pe.psum_out\[3\] _2364_ _2365_ VGND
+ VGND VPWR VPWR _2381_ sky130_fd_sc_hd__a21o_1
X_5389_ _0836_ _2322_ _2324_ _0833_ net574 VGND VGND VPWR VPWR _0308_ sky130_fd_sc_hd__a32o_1
XFILLER_0_10_581 VGND VGND VPWR VPWR sky130_fd_sc_hd__decap_6
X_4409_ _1504_ _1505_ VGND VGND VPWR VPWR _1506_ sky130_fd_sc_hd__or2_1
X_7128_ clknet_leaf_37_clk _0197_ net76 VGND VGND VPWR VPWR u_pe_array.g_pe_row\[2\].g_pe_col\[1\].u_pe.psum_out\[5\]
+ sky130_fd_sc_hd__dfrtp_1
XFILLER_0_5_81 VPWR VGND VPWR VGND sky130_ef_sc_hd__decap_12
X_7059_ clknet_leaf_85_clk _0134_ net74 VGND VGND VPWR VPWR u_pe_array.g_pe_row\[2\].g_pe_col\[2\].u_pe.move_reg\[11\]
+ sky130_fd_sc_hd__dfrtp_1
XANTENNA__6948__RESET_B net815 VGND VGND VPWR VPWR sky130_fd_sc_hd__diode_2
XFILLER_0_96_356 VGND VGND VPWR VPWR sky130_fd_sc_hd__fill_2
XFILLER_0_96_345 VGND VGND VPWR VPWR sky130_fd_sc_hd__decap_4
XTAP_1213 VGND VPWR sky130_fd_sc_hd__tapvpwrvgnd_1
XTAP_1202 VGND VPWR sky130_fd_sc_hd__tapvpwrvgnd_1
XANTENNA__6559__A1 _1810_ VGND VGND VPWR VPWR sky130_fd_sc_hd__diode_2
XFILLER_0_84_518 VGND VGND VPWR VPWR sky130_fd_sc_hd__fill_2
XTAP_1257 VGND VPWR sky130_fd_sc_hd__tapvpwrvgnd_1
XTAP_1246 VGND VPWR sky130_fd_sc_hd__tapvpwrvgnd_1
XTAP_1235 VGND VPWR sky130_fd_sc_hd__tapvpwrvgnd_1
XTAP_1224 VGND VPWR sky130_fd_sc_hd__tapvpwrvgnd_1
XFILLER_0_56_209 VGND VGND VPWR VPWR sky130_fd_sc_hd__fill_1
XTAP_1268 VGND VPWR sky130_fd_sc_hd__tapvpwrvgnd_1
XTAP_1279 VGND VPWR sky130_fd_sc_hd__tapvpwrvgnd_1
XFILLER_0_77_581 VGND VGND VPWR VPWR sky130_fd_sc_hd__decap_6
XANTENNA__3459__A _0729_ VGND VGND VPWR VPWR sky130_fd_sc_hd__diode_2
XFILLER_0_64_253 VGND VGND VPWR VPWR sky130_fd_sc_hd__fill_1
XFILLER_0_107_333 VGND VGND VPWR VPWR sky130_fd_sc_hd__decap_3
XANTENNA__5519__C1 _2345_ VGND VGND VPWR VPWR sky130_fd_sc_hd__diode_2
XFILLER_0_21_29 VGND VGND VPWR VPWR sky130_fd_sc_hd__fill_1
XANTENNA__6731__A1 _3120_ VGND VGND VPWR VPWR sky130_fd_sc_hd__diode_2
XFILLER_0_17_180 VGND VGND VPWR VPWR sky130_fd_sc_hd__decap_4
XFILLER_0_17_191 VGND VGND VPWR VPWR sky130_fd_sc_hd__fill_2
XANTENNA__4742__B1 _1534_ VGND VGND VPWR VPWR sky130_fd_sc_hd__diode_2
XFILLER_0_33_673 VGND VGND VPWR VPWR sky130_fd_sc_hd__fill_2
XFILLER_0_103_561 VPWR VGND VPWR VGND sky130_ef_sc_hd__decap_12
XFILLER_0_60_481 VGND VGND VPWR VPWR sky130_fd_sc_hd__fill_2
XFILLER_0_32_161 VGND VGND VPWR VPWR sky130_fd_sc_hd__fill_1
XFILLER_0_87_345 VGND VGND VPWR VPWR sky130_fd_sc_hd__fill_2
XFILLER_0_1_39 VPWR VGND VPWR VGND sky130_ef_sc_hd__decap_12
X_4760_ _1787_ _0840_ _0988_ _0747_ VGND VGND VPWR VPWR _1798_ sky130_fd_sc_hd__a22o_2
XANTENNA__5773__A2 _2387_ VGND VGND VPWR VPWR sky130_fd_sc_hd__diode_2
X_4691_ _1734_ _1735_ _1736_ VGND VGND VPWR VPWR _1737_ sky130_fd_sc_hd__or3_1
X_3711_ _0909_ _0912_ _0924_ _0885_ VGND VGND VPWR VPWR _0926_ sky130_fd_sc_hd__o31a_1
XFILLER_0_28_489 VGND VGND VPWR VPWR sky130_fd_sc_hd__fill_2
XFILLER_0_113_303 VPWR VGND VPWR VGND sky130_ef_sc_hd__decap_12
XFILLER_0_102_53 VGND VGND VPWR VPWR sky130_fd_sc_hd__decap_4
XFILLER_0_70_245 VGND VGND VPWR VPWR sky130_fd_sc_hd__fill_2
X_3642_ _0717_ _0783_ _0861_ VGND VGND VPWR VPWR _0862_ sky130_fd_sc_hd__o21a_1
X_6430_ _3178_ VGND VGND VPWR VPWR _0495_ sky130_fd_sc_hd__clkbuf_1
X_6361_ _1787_ _1141_ net52 VGND VGND VPWR VPWR _3134_ sky130_fd_sc_hd__a21o_4
XFILLER_0_101_509 VGND VGND VPWR VPWR sky130_fd_sc_hd__fill_2
X_3573_ _0780_ net774 _0809_ VGND VGND VPWR VPWR _0003_ sky130_fd_sc_hd__a21oi_1
X_5312_ _2250_ _2255_ _0885_ VGND VGND VPWR VPWR _2257_ sky130_fd_sc_hd__o21ai_1
X_6292_ u_pe_array.g_pe_row\[0\].g_pe_col\[0\].u_pe.psum_out\[8\] u_pe_array.g_pe_row\[0\].g_pe_col\[0\].u_pe.psum_out\[9\]
+ _2992_ VGND VGND VPWR VPWR _3081_ sky130_fd_sc_hd__and3_1
XANTENNA__7406__RESET_B net817 VGND VGND VPWR VPWR sky130_fd_sc_hd__diode_2
X_5243_ _2191_ _2192_ u_pe_array.g_pe_row\[1\].g_pe_col\[2\].u_pe.psum_out\[4\] VGND
+ VGND VPWR VPWR _2194_ sky130_fd_sc_hd__a21o_1
XANTENNA__6619__S _3269_ VGND VGND VPWR VPWR sky130_fd_sc_hd__diode_2
Xhold19 u_pe_array.g_pe_row\[2\].g_pe_col\[0\].u_pe.w_buffer\[0\] VGND VGND VPWR VPWR
+ net95 sky130_fd_sc_hd__dlygate4sd3_1
X_5174_ _0759_ _1826_ _0754_ VGND VGND VPWR VPWR _2141_ sky130_fd_sc_hd__mux2_1
X_4125_ net233 _1138_ _1265_ _1004_ VGND VGND VPWR VPWR _0103_ sky130_fd_sc_hd__a22o_1
XANTENNA__4264__A2 _1152_ VGND VGND VPWR VPWR sky130_fd_sc_hd__diode_2
X_4056_ _1210_ _1208_ _1212_ VGND VGND VPWR VPWR _1213_ sky130_fd_sc_hd__or3_1
XFILLER_0_36_70 VGND VGND VPWR VPWR sky130_fd_sc_hd__decap_6
XFILLER_0_109_609 VGND VGND VPWR VPWR sky130_fd_sc_hd__decap_6
XFILLER_0_93_337 VGND VGND VPWR VPWR sky130_fd_sc_hd__decap_4
XFILLER_0_74_540 VPWR VGND VPWR VGND sky130_ef_sc_hd__decap_12
X_4958_ u_pe_array.g_pe_row\[0\].g_pe_col\[3\].u_pe.w_buffer\[0\] u_pe_array.g_pe_row\[1\].g_pe_col\[3\].u_pe.w_buffer\[0\]
+ _0828_ VGND VGND VPWR VPWR _1956_ sky130_fd_sc_hd__mux2_1
X_4889_ _1892_ _1893_ VGND VGND VPWR VPWR _1895_ sky130_fd_sc_hd__nand2_1
XFILLER_0_46_253 VGND VGND VPWR VPWR sky130_fd_sc_hd__decap_4
XFILLER_0_19_489 VGND VGND VPWR VPWR sky130_fd_sc_hd__fill_2
XFILLER_0_34_415 VGND VGND VPWR VPWR sky130_fd_sc_hd__fill_2
X_3909_ _1092_ VGND VGND VPWR VPWR _1093_ sky130_fd_sc_hd__inv_2
XFILLER_0_61_223 VGND VGND VPWR VPWR sky130_fd_sc_hd__fill_1
X_6628_ net699 _2738_ _2592_ _3283_ VGND VGND VPWR VPWR _0588_ sky130_fd_sc_hd__a22o_1
XFILLER_0_15_673 VGND VGND VPWR VPWR sky130_fd_sc_hd__fill_1
X_6559_ net267 _1810_ _3239_ VGND VGND VPWR VPWR _3247_ sky130_fd_sc_hd__mux2_1
XFILLER_0_42_481 VGND VGND VPWR VPWR sky130_fd_sc_hd__fill_2
XANTENNA__6529__S _3224_ VGND VGND VPWR VPWR sky130_fd_sc_hd__diode_2
XFILLER_0_100_564 VGND VGND VPWR VPWR sky130_fd_sc_hd__decap_3
XFILLER_0_16_29 VGND VGND VPWR VPWR sky130_fd_sc_hd__decap_3
XFILLER_0_84_304 VGND VGND VPWR VPWR sky130_fd_sc_hd__fill_2
XTAP_1021 VGND VPWR sky130_fd_sc_hd__tapvpwrvgnd_1
XTAP_1010 VGND VPWR sky130_fd_sc_hd__tapvpwrvgnd_1
XFILLER_0_57_518 VGND VGND VPWR VPWR sky130_fd_sc_hd__fill_2
XFILLER_0_69_389 VGND VGND VPWR VPWR sky130_fd_sc_hd__decap_3
XTAP_1065 VGND VPWR sky130_fd_sc_hd__tapvpwrvgnd_1
XTAP_1043 VGND VPWR sky130_fd_sc_hd__tapvpwrvgnd_1
XTAP_1054 VGND VPWR sky130_fd_sc_hd__tapvpwrvgnd_1
XTAP_1032 VGND VPWR sky130_fd_sc_hd__tapvpwrvgnd_1
XANTENNA_clkbuf_leaf_52_clk_A clknet_3_7__leaf_clk VGND VGND VPWR VPWR sky130_fd_sc_hd__diode_2
XFILLER_0_32_17 VGND VGND VPWR VPWR sky130_fd_sc_hd__fill_1
XTAP_1098 VGND VPWR sky130_fd_sc_hd__tapvpwrvgnd_1
XTAP_1087 VGND VPWR sky130_fd_sc_hd__tapvpwrvgnd_1
XTAP_1076 VGND VPWR sky130_fd_sc_hd__tapvpwrvgnd_1
XFILLER_0_25_404 VGND VGND VPWR VPWR sky130_fd_sc_hd__decap_3
XFILLER_0_92_381 VGND VGND VPWR VPWR sky130_fd_sc_hd__fill_1
XANTENNA__6704__A1 _3120_ VGND VGND VPWR VPWR sky130_fd_sc_hd__diode_2
XFILLER_0_65_595 VGND VGND VPWR VPWR sky130_fd_sc_hd__fill_2
XFILLER_0_4_309 VGND VGND VPWR VPWR sky130_fd_sc_hd__fill_2
XANTENNA_clkbuf_leaf_67_clk_A clknet_3_5__leaf_clk VGND VGND VPWR VPWR sky130_fd_sc_hd__diode_2
XFILLER_0_21_632 VGND VGND VPWR VPWR sky130_fd_sc_hd__fill_2
XANTENNA__4748__A _0787_ VGND VGND VPWR VPWR sky130_fd_sc_hd__diode_2
XTAP_805 VGND VPWR sky130_fd_sc_hd__tapvpwrvgnd_1
XTAP_816 VGND VPWR sky130_fd_sc_hd__tapvpwrvgnd_1
XFILLER_0_0_559 VGND VGND VPWR VPWR sky130_fd_sc_hd__fill_1
XTAP_849 VGND VPWR sky130_fd_sc_hd__tapvpwrvgnd_1
XTAP_838 VGND VPWR sky130_fd_sc_hd__tapvpwrvgnd_1
XTAP_827 VGND VPWR sky130_fd_sc_hd__tapvpwrvgnd_1
XANTENNA__5691__A1 _2258_ VGND VGND VPWR VPWR sky130_fd_sc_hd__diode_2
XANTENNA__5316__A_N _2158_ VGND VGND VPWR VPWR sky130_fd_sc_hd__diode_2
XANTENNA__4467__B _1536_ VGND VGND VPWR VPWR sky130_fd_sc_hd__diode_2
XANTENNA__3798__S _0754_ VGND VGND VPWR VPWR sky130_fd_sc_hd__diode_2
XFILLER_0_88_643 VGND VGND VPWR VPWR sky130_fd_sc_hd__fill_1
XFILLER_0_73_57 VGND VGND VPWR VPWR sky130_fd_sc_hd__fill_1
X_5930_ _2761_ _2762_ _2768_ VGND VGND VPWR VPWR _2770_ sky130_fd_sc_hd__o21ai_1
XFILLER_0_88_676 VGND VGND VPWR VPWR sky130_fd_sc_hd__fill_1
XANTENNA__5298__B _2158_ VGND VGND VPWR VPWR sky130_fd_sc_hd__diode_2
X_7600_ clknet_leaf_27_clk _0649_ VGND VGND VPWR VPWR u_pe_array.u_fifo1.buffer\[2\]\[10\]
+ sky130_fd_sc_hd__dfxtp_1
XFILLER_0_75_337 VGND VGND VPWR VPWR sky130_fd_sc_hd__decap_4
X_5861_ u_pe_array.g_pe_row\[0\].g_pe_col\[3\].u_pe.psum_out\[9\] u_pe_array.g_pe_row\[0\].g_pe_col\[3\].u_pe.psum_out\[10\]
+ _2611_ VGND VGND VPWR VPWR _2720_ sky130_fd_sc_hd__o21a_1
XANTENNA__6902__S _3427_ VGND VGND VPWR VPWR sky130_fd_sc_hd__diode_2
XFILLER_0_56_540 VGND VGND VPWR VPWR sky130_fd_sc_hd__decap_6
X_4812_ u_pe_array.g_pe_row\[1\].g_pe_col\[2\].u_pe.act_val\[4\] u_pe_array.g_pe_row\[1\].g_pe_col\[2\].u_pe.psum_out\[4\]
+ _0756_ VGND VGND VPWR VPWR _1832_ sky130_fd_sc_hd__mux2_1
XFILLER_0_8_637 VGND VGND VPWR VPWR sky130_fd_sc_hd__decap_6
X_5792_ _2656_ _2657_ VGND VGND VPWR VPWR _2658_ sky130_fd_sc_hd__nor2_1
XANTENNA__4930__B _1847_ VGND VGND VPWR VPWR sky130_fd_sc_hd__diode_2
X_4743_ u_pe_array.g_pe_row\[2\].g_pe_col\[1\].u_pe.psum_out\[9\] u_pe_array.g_pe_row\[2\].g_pe_col\[1\].u_pe.psum_out\[10\]
+ _1672_ VGND VGND VPWR VPWR _1783_ sky130_fd_sc_hd__o21a_1
XFILLER_0_56_573 VGND VGND VPWR VPWR sky130_fd_sc_hd__fill_2
XFILLER_0_7_125 VPWR VGND VPWR VGND sky130_ef_sc_hd__decap_12
XFILLER_0_16_404 VGND VGND VPWR VPWR sky130_fd_sc_hd__fill_2
XFILLER_0_28_253 VGND VGND VPWR VPWR sky130_fd_sc_hd__decap_4
X_7531_ clknet_leaf_3_clk _0580_ VGND VGND VPWR VPWR u_pe_array.u_fifo2.buffer\[7\]\[5\]
+ sky130_fd_sc_hd__dfxtp_1
XFILLER_0_114_601 VGND VGND VPWR VPWR sky130_fd_sc_hd__fill_2
XFILLER_0_7_169 VGND VGND VPWR VPWR sky130_fd_sc_hd__decap_8
X_7462_ clknet_leaf_1_clk _0511_ VGND VGND VPWR VPWR u_pe_array.u_fifo2.buffer\[2\]\[1\]
+ sky130_fd_sc_hd__dfxtp_1
XFILLER_0_28_286 VGND VGND VPWR VPWR sky130_fd_sc_hd__decap_4
XANTENNA__4422__S _0828_ VGND VGND VPWR VPWR sky130_fd_sc_hd__diode_2
XFILLER_0_114_645 VGND VGND VPWR VPWR sky130_fd_sc_hd__fill_2
X_4674_ _1718_ _1719_ VGND VGND VPWR VPWR _1721_ sky130_fd_sc_hd__nand2_1
X_6413_ net426 _1802_ _3166_ VGND VGND VPWR VPWR _3170_ sky130_fd_sc_hd__mux2_1
X_7393_ clknet_leaf_83_clk _0445_ net818 VGND VGND VPWR VPWR u_fsm.ch_cnt\[1\] sky130_fd_sc_hd__dfrtp_1
XFILLER_0_12_610 VPWR VGND VPWR VGND sky130_ef_sc_hd__decap_12
X_3625_ u_pe_array.g_pe_row\[2\].g_pe_col\[2\].u_pe.psum_out\[7\] u_pe_array.g_pe_row\[2\].g_pe_col\[2\].u_pe.move_reg\[7\]
+ _0734_ VGND VGND VPWR VPWR _0851_ sky130_fd_sc_hd__mux2_1
XANTENNA__7240__RESET_B net813 VGND VGND VPWR VPWR sky130_fd_sc_hd__diode_2
X_6344_ _3122_ net324 _3110_ VGND VGND VPWR VPWR _3123_ sky130_fd_sc_hd__mux2_1
X_3556_ _0717_ u_fsm.state\[1\] VGND VGND VPWR VPWR _0801_ sky130_fd_sc_hd__or2_1
X_6275_ _2740_ _3064_ _3065_ _0866_ net793 VGND VGND VPWR VPWR _0453_ sky130_fd_sc_hd__a32o_1
X_3487_ u_pe_array.g_pe_row\[3\].g_pe_col\[0\].u_pe.psum_out\[10\] _0745_ _0751_ _0728_
+ VGND VGND VPWR VPWR net50 sky130_fd_sc_hd__o211a_4
X_5226_ u_pe_array.g_pe_row\[1\].g_pe_col\[2\].u_pe.act_val\[3\] u_pe_array.g_pe_row\[1\].g_pe_col\[2\].u_pe.w_reg\[0\]
+ _2158_ _2177_ VGND VGND VPWR VPWR _2178_ sky130_fd_sc_hd__a22o_1
XFILLER_0_51_3 VGND VGND VPWR VPWR sky130_fd_sc_hd__decap_8
XANTENNA__5682__A1 _2258_ VGND VGND VPWR VPWR sky130_fd_sc_hd__diode_2
X_5157_ _2127_ _2128_ VGND VGND VPWR VPWR _2129_ sky130_fd_sc_hd__or2_1
X_5088_ _2042_ _2043_ _2054_ _2045_ VGND VGND VPWR VPWR _2067_ sky130_fd_sc_hd__o211a_1
X_4108_ net755 _1138_ _0837_ _1256_ VGND VGND VPWR VPWR _0095_ sky130_fd_sc_hd__a22o_1
XFILLER_0_79_621 VGND VGND VPWR VPWR sky130_fd_sc_hd__fill_2
X_4039_ _1194_ _1196_ _0914_ VGND VGND VPWR VPWR _1198_ sky130_fd_sc_hd__a21oi_1
XANTENNA__6631__A0 _0990_ VGND VGND VPWR VPWR sky130_fd_sc_hd__diode_2
XANTENNA__3501__S _0756_ VGND VGND VPWR VPWR sky130_fd_sc_hd__diode_2
XFILLER_0_66_337 VGND VGND VPWR VPWR sky130_fd_sc_hd__fill_2
XFILLER_0_66_315 VGND VGND VPWR VPWR sky130_fd_sc_hd__decap_4
XPHY_115 VGND VGND VPWR VPWR sky130_fd_sc_hd__decap_3
XPHY_104 VGND VGND VPWR VPWR sky130_fd_sc_hd__decap_3
XANTENNA__6812__S _3382_ VGND VGND VPWR VPWR sky130_fd_sc_hd__diode_2
XPHY_148 VGND VGND VPWR VPWR sky130_fd_sc_hd__decap_3
XPHY_137 VGND VGND VPWR VPWR sky130_fd_sc_hd__decap_3
XPHY_126 VGND VGND VPWR VPWR sky130_fd_sc_hd__decap_3
XFILLER_0_93_167 VGND VGND VPWR VPWR sky130_fd_sc_hd__fill_1
XPHY_159 VGND VGND VPWR VPWR sky130_fd_sc_hd__decap_3
XFILLER_0_19_275 VGND VGND VPWR VPWR sky130_fd_sc_hd__decap_3
XFILLER_0_34_201 VGND VGND VPWR VPWR sky130_fd_sc_hd__decap_3
XANTENNA__7399__RESET_B net817 VGND VGND VPWR VPWR sky130_fd_sc_hd__diode_2
XFILLER_0_19_297 VGND VGND VPWR VPWR sky130_fd_sc_hd__fill_2
XFILLER_0_34_234 VGND VGND VPWR VPWR sky130_fd_sc_hd__fill_2
XFILLER_0_104_111 VGND VGND VPWR VPWR sky130_fd_sc_hd__fill_2
XANTENNA__7328__RESET_B net13 VGND VGND VPWR VPWR sky130_fd_sc_hd__diode_2
XFILLER_0_62_587 VGND VGND VPWR VPWR sky130_fd_sc_hd__fill_1
XFILLER_0_30_451 VGND VGND VPWR VPWR sky130_fd_sc_hd__fill_2
XANTENNA__6963__RESET_B net74 VGND VGND VPWR VPWR sky130_fd_sc_hd__diode_2
XANTENNA__5425__A1 _2258_ VGND VGND VPWR VPWR sky130_fd_sc_hd__diode_2
XFILLER_0_43_49 VGND VGND VPWR VPWR sky130_fd_sc_hd__fill_2
XPHY_6 VGND VGND VPWR VPWR sky130_fd_sc_hd__decap_3
XFILLER_0_57_337 VGND VGND VPWR VPWR sky130_fd_sc_hd__fill_2
XANTENNA__4936__B1 _1847_ VGND VGND VPWR VPWR sky130_fd_sc_hd__diode_2
XANTENNA__3647__A _0866_ VGND VGND VPWR VPWR sky130_fd_sc_hd__diode_2
XFILLER_0_5_629 VPWR VGND VPWR VGND sky130_ef_sc_hd__decap_12
XFILLER_0_80_351 VGND VGND VPWR VPWR sky130_fd_sc_hd__fill_2
XFILLER_0_4_139 VGND VGND VPWR VPWR sky130_fd_sc_hd__fill_1
XANTENNA__7069__RESET_B net74 VGND VGND VPWR VPWR sky130_fd_sc_hd__diode_2
Xhold308 u_pe_array.g_pe_row\[2\].g_pe_col\[1\].u_pe.move_reg\[11\] VGND VGND VPWR
+ VPWR net384 sky130_fd_sc_hd__dlygate4sd3_1
XFILLER_0_7_27 VPWR VGND VPWR VGND sky130_ef_sc_hd__decap_12
XFILLER_0_111_615 VGND VGND VPWR VPWR sky130_fd_sc_hd__fill_1
Xhold319 u_pe_array.g_pe_row\[0\].g_pe_col\[2\].u_pe.psum_out\[4\] VGND VGND VPWR
+ VPWR net395 sky130_fd_sc_hd__dlygate4sd3_1
X_4390_ _1407_ u_pe_array.g_pe_row\[2\].g_pe_col\[3\].u_pe.psum_out\[9\] VGND VGND
+ VPWR VPWR _1489_ sky130_fd_sc_hd__and2_1
XFILLER_0_68_57 VGND VGND VPWR VPWR sky130_fd_sc_hd__fill_1
XFILLER_0_0_389 VGND VGND VPWR VPWR sky130_fd_sc_hd__fill_1
XTAP_602 VGND VPWR sky130_fd_sc_hd__tapvpwrvgnd_1
XTAP_613 VGND VPWR sky130_fd_sc_hd__tapvpwrvgnd_1
XTAP_624 VGND VPWR sky130_fd_sc_hd__tapvpwrvgnd_1
X_6060_ u_pe_array.g_pe_row\[0\].g_pe_col\[1\].u_pe.act_val\[0\] _2873_ VGND VGND
+ VPWR VPWR _2874_ sky130_fd_sc_hd__nand2_1
XTAP_635 VGND VPWR sky130_fd_sc_hd__tapvpwrvgnd_1
XTAP_657 VGND VPWR sky130_fd_sc_hd__tapvpwrvgnd_1
XTAP_646 VGND VPWR sky130_fd_sc_hd__tapvpwrvgnd_1
XTAP_668 VGND VPWR sky130_fd_sc_hd__tapvpwrvgnd_1
XFILLER_0_84_45 VGND VGND VPWR VPWR sky130_fd_sc_hd__fill_1
X_5011_ _0836_ _2001_ _2003_ _0833_ net701 VGND VGND VPWR VPWR _0251_ sky130_fd_sc_hd__a32o_1
XTAP_679 VGND VPWR sky130_fd_sc_hd__tapvpwrvgnd_1
XFILLER_0_108_41 VPWR VGND VPWR VGND sky130_ef_sc_hd__decap_12
XFILLER_0_84_78 VGND VGND VPWR VPWR sky130_fd_sc_hd__decap_3
XFILLER_0_17_50 VGND VGND VPWR VPWR sky130_fd_sc_hd__fill_2
XFILLER_0_108_85 VGND VGND VPWR VPWR sky130_fd_sc_hd__decap_4
X_6962_ clknet_leaf_8_clk _0043_ net816 VGND VGND VPWR VPWR u_pe_array.g_pe_row\[3\].g_pe_col\[1\].u_pe.act_val\[4\]
+ sky130_fd_sc_hd__dfrtp_1
X_6893_ _3430_ VGND VGND VPWR VPWR _0706_ sky130_fd_sc_hd__clkbuf_1
XFILLER_0_48_326 VGND VGND VPWR VPWR sky130_fd_sc_hd__fill_2
X_5913_ u_pe_array.g_pe_row\[0\].g_pe_col\[2\].u_pe.act_val\[0\] VGND VGND VPWR VPWR
+ _2754_ sky130_fd_sc_hd__inv_2
XFILLER_0_75_145 VGND VGND VPWR VPWR sky130_fd_sc_hd__decap_3
X_5844_ _2611_ u_pe_array.g_pe_row\[0\].g_pe_col\[3\].u_pe.psum_out\[10\] VGND VGND
+ VPWR VPWR _2705_ sky130_fd_sc_hd__nand2_1
XFILLER_0_75_178 VGND VGND VPWR VPWR sky130_fd_sc_hd__fill_2
XFILLER_0_99_3 VGND VGND VPWR VPWR sky130_fd_sc_hd__fill_2
XFILLER_0_8_489 VPWR VGND VPWR VGND sky130_ef_sc_hd__decap_12
X_7514_ clknet_leaf_2_clk _0563_ VGND VGND VPWR VPWR u_pe_array.u_fifo2.buffer\[6\]\[1\]
+ sky130_fd_sc_hd__dfxtp_1
X_5775_ u_pe_array.g_pe_row\[0\].g_pe_col\[3\].u_pe.act_val\[3\] VGND VGND VPWR VPWR
+ _2642_ sky130_fd_sc_hd__inv_2
X_4726_ _1672_ u_pe_array.g_pe_row\[2\].g_pe_col\[1\].u_pe.psum_out\[10\] VGND VGND
+ VPWR VPWR _1768_ sky130_fd_sc_hd__nand2_1
XFILLER_0_16_234 VGND VGND VPWR VPWR sky130_fd_sc_hd__fill_2
X_4657_ u_pe_array.g_pe_row\[2\].g_pe_col\[1\].u_pe.w_reg\[0\] _1672_ _1703_ u_pe_array.g_pe_row\[2\].g_pe_col\[1\].u_pe.act_val\[4\]
+ VGND VGND VPWR VPWR _1705_ sky130_fd_sc_hd__nand4_2
XFILLER_0_71_384 VGND VGND VPWR VPWR sky130_fd_sc_hd__fill_2
XFILLER_0_71_373 VGND VGND VPWR VPWR sky130_fd_sc_hd__decap_3
X_7445_ clknet_leaf_92_clk _0494_ VGND VGND VPWR VPWR u_pe_array.u_fifo2.buffer\[0\]\[10\]
+ sky130_fd_sc_hd__dfxtp_1
XFILLER_0_31_204 VGND VGND VPWR VPWR sky130_fd_sc_hd__fill_2
XFILLER_0_114_475 VGND VGND VPWR VPWR sky130_fd_sc_hd__fill_1
X_7376_ clknet_leaf_44_clk _0429_ net812 VGND VGND VPWR VPWR u_pe_array.g_pe_row\[0\].g_pe_col\[1\].u_pe.psum_out\[0\]
+ sky130_fd_sc_hd__dfrtp_1
XFILLER_0_3_161 VGND VGND VPWR VPWR sky130_fd_sc_hd__decap_6
X_3608_ u_pe_array.g_pe_row\[2\].g_pe_col\[2\].u_pe.psum_out\[1\] u_pe_array.g_pe_row\[2\].g_pe_col\[2\].u_pe.act_val\[1\]
+ _0734_ VGND VGND VPWR VPWR _0840_ sky130_fd_sc_hd__mux2_1
X_6327_ _3111_ VGND VGND VPWR VPWR _0459_ sky130_fd_sc_hd__clkbuf_1
X_4588_ u_pe_array.g_pe_row\[2\].g_pe_col\[1\].u_pe.psum_out\[1\] u_pe_array.g_pe_row\[2\].g_pe_col\[1\].u_pe.act_val\[1\]
+ _0769_ VGND VGND VPWR VPWR _1652_ sky130_fd_sc_hd__mux2_1
XFILLER_0_12_473 VGND VGND VPWR VPWR sky130_fd_sc_hd__decap_3
X_3539_ _0718_ _0723_ VGND VGND VPWR VPWR _0786_ sky130_fd_sc_hd__nor2_1
X_6258_ u_pe_array.g_pe_row\[0\].g_pe_col\[0\].u_pe.act_val\[4\] _3049_ _3038_ _3036_
+ VGND VGND VPWR VPWR _3050_ sky130_fd_sc_hd__o22ai_1
XANTENNA__5104__B1 _0914_ VGND VGND VPWR VPWR sky130_fd_sc_hd__diode_2
X_6189_ _2988_ VGND VGND VPWR VPWR _0444_ sky130_fd_sc_hd__clkbuf_1
X_5209_ u_pe_array.g_pe_row\[1\].g_pe_col\[2\].u_pe.psum_out\[1\] _2161_ VGND VGND
+ VPWR VPWR _2163_ sky130_fd_sc_hd__nand2_1
XANTENNA__5711__S _0745_ VGND VGND VPWR VPWR sky130_fd_sc_hd__diode_2
XFILLER_0_98_248 VGND VGND VPWR VPWR sky130_fd_sc_hd__fill_2
XANTENNA__5407__B2 _2336_ VGND VGND VPWR VPWR sky130_fd_sc_hd__diode_2
XANTENNA__6080__A1 _2873_ VGND VGND VPWR VPWR sky130_fd_sc_hd__diode_2
XFILLER_0_39_304 VGND VGND VPWR VPWR sky130_fd_sc_hd__fill_2
XFILLER_0_39_337 VGND VGND VPWR VPWR sky130_fd_sc_hd__decap_3
XFILLER_0_109_225 VGND VGND VPWR VPWR sky130_fd_sc_hd__fill_1
XANTENNA__5666__B _2478_ VGND VGND VPWR VPWR sky130_fd_sc_hd__diode_2
XFILLER_0_66_167 VGND VGND VPWR VPWR sky130_fd_sc_hd__fill_1
XFILLER_0_82_649 VGND VGND VPWR VPWR sky130_fd_sc_hd__fill_1
XFILLER_0_35_532 VGND VGND VPWR VPWR sky130_fd_sc_hd__decap_4
XANTENNA__7162__RESET_B net814 VGND VGND VPWR VPWR sky130_fd_sc_hd__diode_2
XFILLER_0_35_565 VGND VGND VPWR VPWR sky130_fd_sc_hd__decap_3
XFILLER_0_62_362 VGND VGND VPWR VPWR sky130_fd_sc_hd__fill_2
XFILLER_0_50_524 VGND VGND VPWR VPWR sky130_fd_sc_hd__fill_2
XFILLER_0_35_587 VGND VGND VPWR VPWR sky130_fd_sc_hd__decap_4
XANTENNA__4146__A1 _1273_ VGND VGND VPWR VPWR sky130_fd_sc_hd__diode_2
XANTENNA__3914__B _1009_ VGND VGND VPWR VPWR sky130_fd_sc_hd__diode_2
XFILLER_0_30_281 VGND VGND VPWR VPWR sky130_fd_sc_hd__decap_4
XFILLER_0_30_292 VGND VGND VPWR VPWR sky130_fd_sc_hd__fill_2
XFILLER_0_38_38 VGND VGND VPWR VPWR sky130_fd_sc_hd__fill_2
XFILLER_0_54_15 VPWR VGND VPWR VGND sky130_ef_sc_hd__decap_12
XANTENNA__5428__B1_N _2345_ VGND VGND VPWR VPWR sky130_fd_sc_hd__diode_2
XFILLER_0_85_465 VGND VGND VPWR VPWR sky130_fd_sc_hd__fill_2
XFILLER_0_70_58 VGND VGND VPWR VPWR sky130_fd_sc_hd__fill_2
X_3890_ u_pe_array.g_pe_row\[3\].g_pe_col\[2\].u_pe.psum_out\[7\] VGND VGND VPWR VPWR
+ _1075_ sky130_fd_sc_hd__inv_2
XFILLER_0_57_189 VGND VGND VPWR VPWR sky130_fd_sc_hd__decap_4
XFILLER_0_38_392 VGND VGND VPWR VPWR sky130_fd_sc_hd__fill_2
X_5560_ u_pe_array.g_pe_row\[1\].g_pe_col\[3\].u_pe.psum_out\[5\] u_pe_array.g_pe_row\[1\].g_pe_col\[3\].u_pe.act_val\[5\]
+ _0745_ VGND VGND VPWR VPWR _2467_ sky130_fd_sc_hd__mux2_1
XFILLER_0_85_9 VGND VGND VPWR VPWR sky130_fd_sc_hd__fill_1
XFILLER_0_81_671 VGND VGND VPWR VPWR sky130_fd_sc_hd__fill_1
X_5491_ _2258_ _2409_ _2411_ _2071_ net405 VGND VGND VPWR VPWR _0323_ sky130_fd_sc_hd__a32o_1
XFILLER_0_80_170 VGND VGND VPWR VPWR sky130_fd_sc_hd__decap_6
X_4511_ _1573_ _1576_ _1585_ VGND VGND VPWR VPWR _1586_ sky130_fd_sc_hd__o21ai_1
XFILLER_0_41_513 VGND VGND VPWR VPWR sky130_fd_sc_hd__decap_6
XFILLER_0_111_401 VGND VGND VPWR VPWR sky130_fd_sc_hd__fill_2
XFILLER_0_110_53 VPWR VGND VPWR VGND sky130_ef_sc_hd__decap_12
Xhold116 _0314_ VGND VGND VPWR VPWR net192 sky130_fd_sc_hd__dlygate4sd3_1
XANTENNA__4137__A1 _0864_ VGND VGND VPWR VPWR sky130_fd_sc_hd__diode_2
X_7230_ clknet_leaf_58_clk _0293_ net813 VGND VGND VPWR VPWR u_pe_array.g_pe_row\[1\].g_pe_col\[2\].u_pe.psum_out\[4\]
+ sky130_fd_sc_hd__dfrtp_1
X_4442_ net180 _1524_ _1526_ _1399_ VGND VGND VPWR VPWR _0159_ sky130_fd_sc_hd__a22o_1
Xhold105 u_pe_array.g_pe_row\[3\].g_pe_col\[2\].u_pe.move_reg\[9\] VGND VGND VPWR
+ VPWR net181 sky130_fd_sc_hd__dlygate4sd3_1
Xhold149 u_pe_array.u_fifo1.buffer\[2\]\[7\] VGND VGND VPWR VPWR net225 sky130_fd_sc_hd__dlygate4sd3_1
XFILLER_0_79_89 VGND VGND VPWR VPWR sky130_fd_sc_hd__decap_8
Xhold138 u_pe_array.g_pe_row\[0\].g_pe_col\[1\].u_pe.move_reg\[10\] VGND VGND VPWR
+ VPWR net214 sky130_fd_sc_hd__dlygate4sd3_1
Xhold127 u_pe_array.g_pe_row\[1\].g_pe_col\[1\].u_pe.move_reg\[10\] VGND VGND VPWR
+ VPWR net203 sky130_fd_sc_hd__dlygate4sd3_1
XFILLER_0_110_97 VGND VGND VPWR VPWR sky130_fd_sc_hd__fill_2
XANTENNA__5885__B2 _0722_ VGND VGND VPWR VPWR sky130_fd_sc_hd__diode_2
XFILLER_0_0_153 VGND VGND VPWR VPWR sky130_fd_sc_hd__decap_8
X_4373_ _1471_ _1469_ _1473_ VGND VGND VPWR VPWR _1474_ sky130_fd_sc_hd__or3_1
X_7161_ clknet_leaf_71_clk _0230_ net814 VGND VGND VPWR VPWR u_pe_array.g_pe_row\[1\].g_pe_col\[3\].u_pe.move_reg\[10\]
+ sky130_fd_sc_hd__dfrtp_1
X_6112_ _2920_ _2921_ VGND VGND VPWR VPWR _2922_ sky130_fd_sc_hd__and2b_1
XFILLER_0_0_197 VPWR VGND VPWR VGND sky130_ef_sc_hd__decap_12
XTAP_410 VGND VPWR sky130_fd_sc_hd__tapvpwrvgnd_1
XTAP_421 VGND VPWR sky130_fd_sc_hd__tapvpwrvgnd_1
XTAP_432 VGND VPWR sky130_fd_sc_hd__tapvpwrvgnd_1
X_7092_ clknet_leaf_81_clk net96 net815 VGND VGND VPWR VPWR u_pe_array.g_pe_row\[2\].g_pe_col\[2\].u_pe.w_reg\[1\]
+ sky130_fd_sc_hd__dfrtp_1
X_6043_ net219 _2738_ _2863_ _0722_ VGND VGND VPWR VPWR _0423_ sky130_fd_sc_hd__a22o_1
XTAP_443 VGND VPWR sky130_fd_sc_hd__tapvpwrvgnd_1
XTAP_454 VGND VPWR sky130_fd_sc_hd__tapvpwrvgnd_1
XTAP_465 VGND VPWR sky130_fd_sc_hd__tapvpwrvgnd_1
XTAP_476 VGND VPWR sky130_fd_sc_hd__tapvpwrvgnd_1
XANTENNA__6627__S _0747_ VGND VGND VPWR VPWR sky130_fd_sc_hd__diode_2
XANTENNA__3648__B1 _0867_ VGND VGND VPWR VPWR sky130_fd_sc_hd__diode_2
XTAP_487 VGND VPWR sky130_fd_sc_hd__tapvpwrvgnd_1
XTAP_498 VGND VPWR sky130_fd_sc_hd__tapvpwrvgnd_1
XFILLER_0_28_71 VGND VGND VPWR VPWR sky130_fd_sc_hd__fill_1
XTAP_1609 VGND VPWR sky130_fd_sc_hd__tapvpwrvgnd_1
XFILLER_0_95_218 VGND VGND VPWR VPWR sky130_fd_sc_hd__fill_2
X_6945_ clknet_leaf_77_clk _0026_ net815 VGND VGND VPWR VPWR u_pe_array.g_pe_row\[3\].g_pe_col\[3\].u_pe.psum_out\[2\]
+ sky130_fd_sc_hd__dfrtp_1
XANTENNA__6362__S _3110_ VGND VGND VPWR VPWR sky130_fd_sc_hd__diode_2
XFILLER_0_88_281 VGND VGND VPWR VPWR sky130_fd_sc_hd__decap_3
XANTENNA__4612__A2 _1524_ VGND VGND VPWR VPWR sky130_fd_sc_hd__diode_2
XFILLER_0_48_134 VGND VGND VPWR VPWR sky130_fd_sc_hd__decap_4
X_6876_ net241 _3126_ _3412_ VGND VGND VPWR VPWR _3421_ sky130_fd_sc_hd__mux2_1
X_5827_ u_pe_array.g_pe_row\[0\].g_pe_col\[3\].u_pe.psum_out\[8\] u_pe_array.g_pe_row\[0\].g_pe_col\[3\].u_pe.psum_out\[7\]
+ _2611_ VGND VGND VPWR VPWR _2690_ sky130_fd_sc_hd__and3b_1
XFILLER_0_106_206 VGND VGND VPWR VPWR sky130_fd_sc_hd__fill_1
XFILLER_0_91_457 VGND VGND VPWR VPWR sky130_fd_sc_hd__fill_1
XFILLER_0_17_543 VPWR VGND VPWR VGND sky130_ef_sc_hd__decap_12
X_5758_ net672 _2387_ _2625_ _2626_ VGND VGND VPWR VPWR _0375_ sky130_fd_sc_hd__a22o_1
X_4709_ u_pe_array.g_pe_row\[2\].g_pe_col\[1\].u_pe.psum_out\[8\] u_pe_array.g_pe_row\[2\].g_pe_col\[1\].u_pe.psum_out\[7\]
+ _1672_ VGND VGND VPWR VPWR _1753_ sky130_fd_sc_hd__and3b_1
XFILLER_0_32_513 VGND VGND VPWR VPWR sky130_fd_sc_hd__decap_8
X_5689_ _2573_ _2577_ VGND VGND VPWR VPWR _2578_ sky130_fd_sc_hd__or2_1
XANTENNA__4610__S _1661_ VGND VGND VPWR VPWR sky130_fd_sc_hd__diode_2
XFILLER_0_71_192 VGND VGND VPWR VPWR sky130_fd_sc_hd__decap_4
X_7428_ clknet_leaf_8_clk _0477_ net74 VGND VGND VPWR VPWR u_pe_array.u_fifo2.rd_ptr\[1\]
+ sky130_fd_sc_hd__dfrtp_4
XANTENNA__5706__S _0828_ VGND VGND VPWR VPWR sky130_fd_sc_hd__diode_2
XFILLER_0_8_92 VGND VGND VPWR VPWR sky130_fd_sc_hd__decap_8
X_7359_ clknet_leaf_42_clk _0414_ net813 VGND VGND VPWR VPWR u_pe_array.g_pe_row\[0\].g_pe_col\[1\].u_pe.w_buffer\[0\]
+ sky130_fd_sc_hd__dfrtp_1
Xhold661 u_pe_array.g_pe_row\[3\].g_pe_col\[1\].u_pe.psum_out\[5\] VGND VGND VPWR
+ VPWR net737 sky130_fd_sc_hd__dlygate4sd3_1
Xhold672 u_pe_array.u_fifo2.rd_ptr\[1\] VGND VGND VPWR VPWR net748 sky130_fd_sc_hd__dlygate4sd3_1
Xhold650 u_pe_array.g_pe_row\[3\].g_pe_col\[2\].u_pe.act_val\[5\] VGND VGND VPWR VPWR
+ net726 sky130_fd_sc_hd__dlygate4sd3_1
XANTENNA__3887__B1 _0887_ VGND VGND VPWR VPWR sky130_fd_sc_hd__diode_2
Xhold683 u_pe_array.g_pe_row\[0\].g_pe_col\[2\].u_pe.act_val\[0\] VGND VGND VPWR VPWR
+ net759 sky130_fd_sc_hd__dlygate4sd3_1
Xhold694 u_pe_array.g_pe_row\[3\].g_pe_col\[3\].u_pe.act_val\[3\] VGND VGND VPWR VPWR
+ net770 sky130_fd_sc_hd__dlygate4sd3_1
XANTENNA__6537__S _3224_ VGND VGND VPWR VPWR sky130_fd_sc_hd__diode_2
XFILLER_0_99_557 VGND VGND VPWR VPWR sky130_fd_sc_hd__decap_3
XANTENNA__6053__B2 _0722_ VGND VGND VPWR VPWR sky130_fd_sc_hd__diode_2
XFILLER_0_79_281 VGND VGND VPWR VPWR sky130_fd_sc_hd__decap_4
XANTENNA__7343__RESET_B net812 VGND VGND VPWR VPWR sky130_fd_sc_hd__diode_2
XFILLER_0_54_137 VGND VGND VPWR VPWR sky130_fd_sc_hd__decap_3
XFILLER_0_54_126 VGND VGND VPWR VPWR sky130_fd_sc_hd__decap_4
Xload_slew6 net76 VGND VGND VPWR VPWR net817 sky130_fd_sc_hd__buf_12
XFILLER_0_82_468 VGND VGND VPWR VPWR sky130_fd_sc_hd__decap_3
XFILLER_0_35_351 VGND VGND VPWR VPWR sky130_fd_sc_hd__fill_1
XFILLER_0_105_261 VGND VGND VPWR VPWR sky130_fd_sc_hd__fill_1
XFILLER_0_105_250 VGND VGND VPWR VPWR sky130_fd_sc_hd__fill_1
XFILLER_0_23_557 VGND VGND VPWR VPWR sky130_fd_sc_hd__decap_3
XANTENNA__5351__S _0756_ VGND VGND VPWR VPWR sky130_fd_sc_hd__diode_2
XFILLER_0_65_69 VGND VGND VPWR VPWR sky130_fd_sc_hd__fill_1
X_6730_ _3343_ VGND VGND VPWR VPWR _0630_ sky130_fd_sc_hd__clkbuf_1
X_4991_ u_pe_array.g_pe_row\[0\].g_pe_col\[2\].u_pe.act_val\[1\] u_pe_array.g_pe_row\[0\].g_pe_col\[2\].u_pe.psum_out\[1\]
+ _0756_ VGND VGND VPWR VPWR _1986_ sky130_fd_sc_hd__mux2_1
XFILLER_0_85_240 VGND VGND VPWR VPWR sky130_fd_sc_hd__fill_2
X_3942_ _1120_ VGND VGND VPWR VPWR _0065_ sky130_fd_sc_hd__clkbuf_1
XANTENNA__7084__RESET_B net816 VGND VGND VPWR VPWR sky130_fd_sc_hd__diode_2
XFILLER_0_73_413 VGND VGND VPWR VPWR sky130_fd_sc_hd__fill_1
X_6661_ _3106_ u_pe_array.u_fifo1.wr_ptr\[1\] u_pe_array.u_fifo1.wr_ptr\[2\] _3296_
+ VGND VGND VPWR VPWR _3302_ sky130_fd_sc_hd__and4_1
XANTENNA__7013__RESET_B net818 VGND VGND VPWR VPWR sky130_fd_sc_hd__diode_2
X_3873_ _1049_ _1050_ _1047_ VGND VGND VPWR VPWR _1060_ sky130_fd_sc_hd__o21ai_2
XFILLER_0_14_73 VGND VGND VPWR VPWR sky130_fd_sc_hd__decap_3
XFILLER_0_18_329 VGND VGND VPWR VPWR sky130_fd_sc_hd__decap_4
XFILLER_0_73_457 VGND VGND VPWR VPWR sky130_fd_sc_hd__fill_1
XFILLER_0_73_446 VGND VGND VPWR VPWR sky130_fd_sc_hd__fill_2
X_5612_ _2504_ _2506_ _2495_ VGND VGND VPWR VPWR _2508_ sky130_fd_sc_hd__o21ai_1
XANTENNA__6910__S _3427_ VGND VGND VPWR VPWR sky130_fd_sc_hd__diode_2
X_6592_ _3264_ VGND VGND VPWR VPWR _0571_ sky130_fd_sc_hd__clkbuf_1
XANTENNA__5555__B1 _1655_ VGND VGND VPWR VPWR sky130_fd_sc_hd__diode_2
X_5543_ _2456_ _2457_ VGND VGND VPWR VPWR _2458_ sky130_fd_sc_hd__xnor2_1
XFILLER_0_26_362 VGND VGND VPWR VPWR sky130_fd_sc_hd__fill_2
XANTENNA__4430__S _0769_ VGND VGND VPWR VPWR sky130_fd_sc_hd__diode_2
XFILLER_0_5_289 VGND VGND VPWR VPWR sky130_fd_sc_hd__fill_1
X_5474_ _2382_ _2385_ _2395_ VGND VGND VPWR VPWR _2396_ sky130_fd_sc_hd__o21ai_1
XFILLER_0_30_94 VGND VGND VPWR VPWR sky130_fd_sc_hd__fill_2
XFILLER_0_111_242 VPWR VGND VPWR VGND sky130_ef_sc_hd__decap_12
X_7213_ clknet_leaf_56_clk _0278_ net75 VGND VGND VPWR VPWR u_pe_array.g_pe_row\[1\].g_pe_col\[1\].u_pe.act_val\[2\]
+ sky130_fd_sc_hd__dfrtp_2
X_4425_ net769 _1392_ _1258_ _1517_ VGND VGND VPWR VPWR _0151_ sky130_fd_sc_hd__a22o_1
X_4356_ _1455_ _1457_ _0914_ VGND VGND VPWR VPWR _1459_ sky130_fd_sc_hd__a21oi_1
X_7144_ clknet_leaf_93_clk _0213_ VGND VGND VPWR VPWR u_pe_array.u_fifo2.buffer\[8\]\[8\]
+ sky130_fd_sc_hd__dfxtp_1
XFILLER_0_1_473 VPWR VGND VPWR VGND sky130_ef_sc_hd__decap_12
XTAP_240 VGND VPWR sky130_fd_sc_hd__tapvpwrvgnd_1
XTAP_251 VGND VPWR sky130_fd_sc_hd__tapvpwrvgnd_1
XFILLER_0_39_81 VGND VGND VPWR VPWR sky130_fd_sc_hd__decap_8
XTAP_284 VGND VPWR sky130_fd_sc_hd__tapvpwrvgnd_1
XTAP_262 VGND VPWR sky130_fd_sc_hd__tapvpwrvgnd_1
XTAP_273 VGND VPWR sky130_fd_sc_hd__tapvpwrvgnd_1
X_4287_ u_pe_array.g_pe_row\[2\].g_pe_col\[3\].u_pe.psum_out\[8\] u_pe_array.g_pe_row\[2\].g_pe_col\[3\].u_pe.move_reg\[8\]
+ _0855_ VGND VGND VPWR VPWR _1400_ sky130_fd_sc_hd__mux2_1
X_7075_ clknet_leaf_81_clk _0148_ net74 VGND VGND VPWR VPWR u_pe_array.g_pe_row\[2\].g_pe_col\[3\].u_pe.psum_out\[12\]
+ sky130_fd_sc_hd__dfrtp_1
X_6026_ net30 u_pe_array.g_pe_row\[0\].g_pe_col\[1\].u_pe.w_buffer\[1\] _0827_ VGND
+ VGND VPWR VPWR _2855_ sky130_fd_sc_hd__mux2_1
XTAP_295 VGND VPWR sky130_fd_sc_hd__tapvpwrvgnd_1
XTAP_1406 VGND VPWR sky130_fd_sc_hd__tapvpwrvgnd_1
Xclkbuf_leaf_93_clk clknet_3_0__leaf_clk VGND VGND VPWR VPWR clknet_leaf_93_clk sky130_fd_sc_hd__clkbuf_16
XTAP_1439 VGND VPWR sky130_fd_sc_hd__tapvpwrvgnd_1
XTAP_1428 VGND VPWR sky130_fd_sc_hd__tapvpwrvgnd_1
XTAP_1417 VGND VPWR sky130_fd_sc_hd__tapvpwrvgnd_1
XFILLER_0_76_251 VGND VGND VPWR VPWR sky130_fd_sc_hd__fill_1
XFILLER_0_49_476 VGND VGND VPWR VPWR sky130_fd_sc_hd__fill_2
X_6928_ clknet_leaf_9_clk _0011_ net819 VGND VGND VPWR VPWR u_pe_array.g_pe_row\[3\].g_pe_col\[2\].u_pe.act_val\[0\]
+ sky130_fd_sc_hd__dfrtp_4
XANTENNA__6105__B _2873_ VGND VGND VPWR VPWR sky130_fd_sc_hd__diode_2
XFILLER_0_76_284 VGND VGND VPWR VPWR sky130_fd_sc_hd__decap_8
X_6859_ _3411_ VGND VGND VPWR VPWR _3412_ sky130_fd_sc_hd__clkbuf_8
XANTENNA__6820__S _3382_ VGND VGND VPWR VPWR sky130_fd_sc_hd__diode_2
XFILLER_0_9_573 VPWR VGND VPWR VGND sky130_ef_sc_hd__decap_12
XFILLER_0_91_298 VGND VGND VPWR VPWR sky130_fd_sc_hd__fill_2
XFILLER_0_17_384 VGND VGND VPWR VPWR sky130_fd_sc_hd__fill_2
XFILLER_0_32_398 VGND VGND VPWR VPWR sky130_fd_sc_hd__fill_2
Xhold480 u_pe_array.u_fifo1.buffer\[1\]\[4\] VGND VGND VPWR VPWR net556 sky130_fd_sc_hd__dlygate4sd3_1
XFILLER_0_3_3 VPWR VGND VPWR VGND sky130_ef_sc_hd__decap_12
Xhold491 u_pe_array.g_pe_row\[2\].g_pe_col\[2\].u_pe.psum_out\[12\] VGND VGND VPWR
+ VPWR net567 sky130_fd_sc_hd__dlygate4sd3_1
Xclkbuf_leaf_84_clk clknet_3_1__leaf_clk VGND VGND VPWR VPWR clknet_leaf_84_clk sky130_fd_sc_hd__clkbuf_16
XANTENNA__5785__B1 _0913_ VGND VGND VPWR VPWR sky130_fd_sc_hd__diode_2
XFILLER_0_95_593 VGND VGND VPWR VPWR sky130_fd_sc_hd__decap_8
XFILLER_0_43_608 VGND VGND VPWR VPWR sky130_fd_sc_hd__fill_1
XFILLER_0_27_148 VGND VGND VPWR VPWR sky130_fd_sc_hd__fill_2
XFILLER_0_113_529 VPWR VGND VPWR VGND sky130_ef_sc_hd__decap_12
XFILLER_0_51_641 VGND VGND VPWR VPWR sky130_fd_sc_hd__fill_2
XFILLER_0_35_181 VGND VGND VPWR VPWR sky130_fd_sc_hd__fill_2
XFILLER_0_11_505 VPWR VGND VPWR VGND sky130_ef_sc_hd__decap_12
XFILLER_0_23_365 VGND VGND VPWR VPWR sky130_fd_sc_hd__fill_2
XANTENNA__4760__B2 _0747_ VGND VGND VPWR VPWR sky130_fd_sc_hd__diode_2
XANTENNA__4760__A1 _1787_ VGND VGND VPWR VPWR sky130_fd_sc_hd__diode_2
X_4210_ _1339_ VGND VGND VPWR VPWR _1340_ sky130_fd_sc_hd__inv_2
XFILLER_0_76_13 VGND VGND VPWR VPWR sky130_fd_sc_hd__decap_8
X_5190_ net393 _2144_ _2149_ _1665_ VGND VGND VPWR VPWR _0284_ sky130_fd_sc_hd__a22o_1
X_4141_ u_pe_array.g_pe_row\[3\].g_pe_col\[0\].u_pe.act_val\[0\] _1275_ VGND VGND
+ VPWR VPWR _1276_ sky130_fd_sc_hd__nand2_1
XFILLER_0_76_79 VGND VGND VPWR VPWR sky130_fd_sc_hd__decap_4
X_4072_ _1226_ _1227_ net828 _0916_ VGND VGND VPWR VPWR _0088_ sky130_fd_sc_hd__a2bb2o_1
XANTENNA__7265__RESET_B net812 VGND VGND VPWR VPWR sky130_fd_sc_hd__diode_2
XFILLER_0_78_527 VGND VGND VPWR VPWR sky130_fd_sc_hd__fill_1
Xclkbuf_leaf_75_clk clknet_3_4__leaf_clk VGND VGND VPWR VPWR clknet_leaf_75_clk sky130_fd_sc_hd__clkbuf_16
XANTENNA__4028__B1 _1144_ VGND VGND VPWR VPWR sky130_fd_sc_hd__diode_2
XFILLER_0_58_240 VGND VGND VPWR VPWR sky130_fd_sc_hd__fill_1
X_4974_ u_pe_array.u_fifo2.rd_ptr\[0\] _1968_ u_pe_array.u_fifo2.rd_ptr\[1\] VGND
+ VGND VPWR VPWR _1970_ sky130_fd_sc_hd__and3b_2
X_6713_ _3334_ VGND VGND VPWR VPWR _0622_ sky130_fd_sc_hd__clkbuf_1
XFILLER_0_58_273 VGND VGND VPWR VPWR sky130_fd_sc_hd__fill_2
X_3925_ u_pe_array.g_pe_row\[3\].g_pe_col\[2\].u_pe.psum_out\[10\] _1106_ _1096_ VGND
+ VGND VPWR VPWR _1107_ sky130_fd_sc_hd__mux2_1
XFILLER_0_73_232 VGND VGND VPWR VPWR sky130_fd_sc_hd__fill_2
X_6644_ _3291_ VGND VGND VPWR VPWR _0596_ sky130_fd_sc_hd__clkbuf_1
XFILLER_0_61_416 VGND VGND VPWR VPWR sky130_fd_sc_hd__fill_1
X_3856_ u_pe_array.g_pe_row\[3\].g_pe_col\[2\].u_pe.act_val\[4\] u_pe_array.g_pe_row\[3\].g_pe_col\[2\].u_pe.w_reg\[0\]
+ _1041_ _1042_ VGND VGND VPWR VPWR _1044_ sky130_fd_sc_hd__o2bb2a_1
XFILLER_0_81_3 VPWR VGND VPWR VGND sky130_ef_sc_hd__decap_12
XFILLER_0_61_449 VGND VGND VPWR VPWR sky130_fd_sc_hd__fill_2
XFILLER_0_42_630 VGND VGND VPWR VPWR sky130_fd_sc_hd__decap_4
XFILLER_0_6_587 VGND VGND VPWR VPWR sky130_fd_sc_hd__fill_1
X_6575_ net577 _1798_ _3254_ VGND VGND VPWR VPWR _3256_ sky130_fd_sc_hd__mux2_1
XFILLER_0_26_170 VGND VGND VPWR VPWR sky130_fd_sc_hd__fill_2
X_3787_ u_pe_array.g_pe_row\[3\].g_pe_col\[2\].u_pe.psum_out\[2\] u_pe_array.g_pe_row\[3\].g_pe_col\[2\].u_pe.act_val\[2\]
+ _0745_ VGND VGND VPWR VPWR _0990_ sky130_fd_sc_hd__mux2_2
X_5526_ net638 VGND VGND VPWR VPWR _2443_ sky130_fd_sc_hd__inv_2
XFILLER_0_14_365 VGND VGND VPWR VPWR sky130_fd_sc_hd__fill_2
X_5457_ _2377_ _2378_ u_pe_array.g_pe_row\[1\].g_pe_col\[1\].u_pe.psum_out\[4\] VGND
+ VGND VPWR VPWR _2380_ sky130_fd_sc_hd__a21o_1
X_4408_ _1407_ u_pe_array.g_pe_row\[2\].g_pe_col\[3\].u_pe.psum_out\[11\] VGND VGND
+ VPWR VPWR _1505_ sky130_fd_sc_hd__and2b_1
XFILLER_0_41_195 VGND VGND VPWR VPWR sky130_fd_sc_hd__fill_2
X_5388_ _1787_ _2323_ VGND VGND VPWR VPWR _2324_ sky130_fd_sc_hd__or2_1
XFILLER_0_1_281 VGND VGND VPWR VPWR sky130_fd_sc_hd__decap_8
XANTENNA__3504__S _0756_ VGND VGND VPWR VPWR sky130_fd_sc_hd__diode_2
X_7127_ clknet_leaf_37_clk _0196_ net76 VGND VGND VPWR VPWR u_pe_array.g_pe_row\[2\].g_pe_col\[1\].u_pe.psum_out\[4\]
+ sky130_fd_sc_hd__dfrtp_1
X_4339_ u_pe_array.g_pe_row\[2\].g_pe_col\[3\].u_pe.w_reg\[0\] u_pe_array.g_pe_row\[2\].g_pe_col\[3\].u_pe.act_val\[3\]
+ _1429_ _1442_ VGND VGND VPWR VPWR _1443_ sky130_fd_sc_hd__a31o_1
XFILLER_0_5_93 VPWR VGND VPWR VGND sky130_ef_sc_hd__decap_12
X_7058_ clknet_leaf_85_clk net131 net74 VGND VGND VPWR VPWR u_pe_array.g_pe_row\[2\].g_pe_col\[2\].u_pe.move_reg\[10\]
+ sky130_fd_sc_hd__dfrtp_1
X_6009_ _2837_ _2841_ VGND VGND VPWR VPWR _2842_ sky130_fd_sc_hd__or2_1
XFILLER_0_69_505 VGND VGND VPWR VPWR sky130_fd_sc_hd__decap_3
Xclkbuf_leaf_66_clk clknet_3_5__leaf_clk VGND VGND VPWR VPWR clknet_leaf_66_clk sky130_fd_sc_hd__clkbuf_16
XTAP_1214 VGND VPWR sky130_fd_sc_hd__tapvpwrvgnd_1
XTAP_1203 VGND VPWR sky130_fd_sc_hd__tapvpwrvgnd_1
XTAP_1247 VGND VPWR sky130_fd_sc_hd__tapvpwrvgnd_1
XTAP_1236 VGND VPWR sky130_fd_sc_hd__tapvpwrvgnd_1
XTAP_1225 VGND VPWR sky130_fd_sc_hd__tapvpwrvgnd_1
XANTENNA__6988__RESET_B net817 VGND VGND VPWR VPWR sky130_fd_sc_hd__diode_2
XTAP_1269 VGND VPWR sky130_fd_sc_hd__tapvpwrvgnd_1
XTAP_1258 VGND VPWR sky130_fd_sc_hd__tapvpwrvgnd_1
XFILLER_0_92_541 VGND VGND VPWR VPWR sky130_fd_sc_hd__fill_2
XANTENNA__6917__RESET_B net813 VGND VGND VPWR VPWR sky130_fd_sc_hd__diode_2
XFILLER_0_21_19 VGND VGND VPWR VPWR sky130_fd_sc_hd__fill_1
XFILLER_0_92_585 VGND VGND VPWR VPWR sky130_fd_sc_hd__decap_3
XANTENNA__4742__A1 _1725_ VGND VGND VPWR VPWR sky130_fd_sc_hd__diode_2
XFILLER_0_103_551 VGND VGND VPWR VPWR sky130_fd_sc_hd__fill_2
XFILLER_0_103_573 VGND VGND VPWR VPWR sky130_fd_sc_hd__fill_2
XANTENNA__3922__B _1009_ VGND VGND VPWR VPWR sky130_fd_sc_hd__diode_2
Xclkbuf_leaf_57_clk clknet_3_6__leaf_clk VGND VGND VPWR VPWR clknet_leaf_57_clk sky130_fd_sc_hd__clkbuf_16
XFILLER_0_62_15 VPWR VGND VPWR VGND sky130_ef_sc_hd__decap_12
XFILLER_0_55_243 VGND VGND VPWR VPWR sky130_fd_sc_hd__fill_2
XFILLER_0_55_221 VGND VGND VPWR VPWR sky130_fd_sc_hd__fill_1
X_3710_ _0909_ _0912_ _0924_ VGND VGND VPWR VPWR _0925_ sky130_fd_sc_hd__o21ai_1
X_4690_ _1712_ _1722_ VGND VGND VPWR VPWR _1736_ sky130_fd_sc_hd__and2_1
XFILLER_0_55_276 VGND VGND VPWR VPWR sky130_fd_sc_hd__fill_2
XFILLER_0_55_254 VGND VGND VPWR VPWR sky130_fd_sc_hd__decap_3
XANTENNA__6183__B1 _2174_ VGND VGND VPWR VPWR sky130_fd_sc_hd__diode_2
X_3641_ u_pe_array.g_pe_row\[0\].g_pe_col\[0\].u_pe.en_r VGND VGND VPWR VPWR _0861_
+ sky130_fd_sc_hd__buf_8
XFILLER_0_3_502 VGND VGND VPWR VPWR sky130_fd_sc_hd__fill_2
XFILLER_0_113_337 VPWR VGND VPWR VGND sky130_ef_sc_hd__decap_12
XFILLER_0_113_315 VPWR VGND VPWR VGND sky130_ef_sc_hd__decap_12
X_6360_ _3133_ VGND VGND VPWR VPWR _0470_ sky130_fd_sc_hd__clkbuf_1
XFILLER_0_70_268 VPWR VGND VPWR VGND sky130_ef_sc_hd__decap_12
X_3572_ net773 _0779_ VGND VGND VPWR VPWR _0813_ sky130_fd_sc_hd__nand2_1
X_5311_ _2250_ _2255_ VGND VGND VPWR VPWR _2256_ sky130_fd_sc_hd__and2_1
XFILLER_0_51_482 VGND VGND VPWR VPWR sky130_fd_sc_hd__fill_2
X_6291_ u_pe_array.g_pe_row\[0\].g_pe_col\[0\].u_pe.psum_out\[9\] _2992_ VGND VGND
+ VPWR VPWR _3080_ sky130_fd_sc_hd__or2_1
XFILLER_0_11_346 VGND VGND VPWR VPWR sky130_fd_sc_hd__fill_2
XFILLER_0_11_335 VGND VGND VPWR VPWR sky130_fd_sc_hd__fill_1
X_5242_ u_pe_array.g_pe_row\[1\].g_pe_col\[2\].u_pe.psum_out\[4\] _2191_ _2192_ VGND
+ VGND VPWR VPWR _2193_ sky130_fd_sc_hd__nand3_1
X_5173_ net786 _1666_ _1655_ _2140_ VGND VGND VPWR VPWR _0276_ sky130_fd_sc_hd__a22o_1
X_4124_ u_pe_array.g_pe_row\[3\].g_pe_col\[3\].u_pe.psum_out\[8\] u_pe_array.g_pe_row\[3\].g_pe_col\[3\].u_pe.move_reg\[8\]
+ _0855_ VGND VGND VPWR VPWR _1265_ sky130_fd_sc_hd__mux2_1
Xinput1 h_in0[0] VGND VGND VPWR VPWR net1 sky130_fd_sc_hd__dlymetal6s2s_1
Xclkbuf_leaf_48_clk clknet_3_7__leaf_clk VGND VGND VPWR VPWR clknet_leaf_48_clk sky130_fd_sc_hd__clkbuf_16
X_4055_ u_pe_array.g_pe_row\[3\].g_pe_col\[1\].u_pe.psum_out\[7\] _1211_ _1201_ VGND
+ VGND VPWR VPWR _1212_ sky130_fd_sc_hd__mux2_1
XANTENNA__6635__S _0747_ VGND VGND VPWR VPWR sky130_fd_sc_hd__diode_2
X_4957_ net519 _1714_ _0887_ _1955_ VGND VGND VPWR VPWR _0245_ sky130_fd_sc_hd__a22o_1
XFILLER_0_19_446 VGND VGND VPWR VPWR sky130_fd_sc_hd__fill_2
X_4888_ _1892_ _1893_ VGND VGND VPWR VPWR _1894_ sky130_fd_sc_hd__nor2_1
X_3908_ _1076_ _1090_ _1091_ VGND VGND VPWR VPWR _1092_ sky130_fd_sc_hd__a21oi_1
XFILLER_0_6_351 VPWR VGND VPWR VGND sky130_ef_sc_hd__decap_12
X_6627_ _0986_ net7 _0747_ VGND VGND VPWR VPWR _3283_ sky130_fd_sc_hd__mux2_1
X_3839_ u_pe_array.g_pe_row\[3\].g_pe_col\[2\].u_pe.act_val\[2\] u_pe_array.g_pe_row\[3\].g_pe_col\[2\].u_pe.w_reg\[0\]
+ _1018_ VGND VGND VPWR VPWR _1028_ sky130_fd_sc_hd__and3_1
XFILLER_0_61_279 VGND VGND VPWR VPWR sky130_fd_sc_hd__fill_1
X_6558_ _3246_ VGND VGND VPWR VPWR _0555_ sky130_fd_sc_hd__clkbuf_1
XFILLER_0_30_622 VGND VGND VPWR VPWR sky130_fd_sc_hd__fill_2
XFILLER_0_42_460 VGND VGND VPWR VPWR sky130_fd_sc_hd__fill_2
X_5509_ _2418_ _2421_ _2426_ VGND VGND VPWR VPWR _2428_ sky130_fd_sc_hd__a21oi_1
XANTENNA__6477__A1 _1812_ VGND VGND VPWR VPWR sky130_fd_sc_hd__diode_2
X_6489_ _3209_ VGND VGND VPWR VPWR _0523_ sky130_fd_sc_hd__clkbuf_1
XFILLER_0_42_493 VGND VGND VPWR VPWR sky130_fd_sc_hd__fill_2
XANTENNA__4838__B _1847_ VGND VGND VPWR VPWR sky130_fd_sc_hd__diode_2
XFILLER_0_100_587 VGND VGND VPWR VPWR sky130_fd_sc_hd__fill_1
XANTENNA__7187__RESET_B net73 VGND VGND VPWR VPWR sky130_fd_sc_hd__diode_2
XANTENNA__7116__RESET_B net816 VGND VGND VPWR VPWR sky130_fd_sc_hd__diode_2
Xclkbuf_leaf_39_clk clknet_3_6__leaf_clk VGND VGND VPWR VPWR clknet_leaf_39_clk sky130_fd_sc_hd__clkbuf_16
XANTENNA__6545__S _3239_ VGND VGND VPWR VPWR sky130_fd_sc_hd__diode_2
XFILLER_0_97_644 VPWR VGND VPWR VGND sky130_ef_sc_hd__decap_12
XFILLER_0_96_132 VGND VGND VPWR VPWR sky130_fd_sc_hd__fill_1
XTAP_1022 VGND VPWR sky130_fd_sc_hd__tapvpwrvgnd_1
XTAP_1011 VGND VPWR sky130_fd_sc_hd__tapvpwrvgnd_1
XTAP_1000 VGND VPWR sky130_fd_sc_hd__tapvpwrvgnd_1
XFILLER_0_84_316 VGND VGND VPWR VPWR sky130_fd_sc_hd__fill_2
XTAP_1044 VGND VPWR sky130_fd_sc_hd__tapvpwrvgnd_1
XTAP_1055 VGND VPWR sky130_fd_sc_hd__tapvpwrvgnd_1
XTAP_1033 VGND VPWR sky130_fd_sc_hd__tapvpwrvgnd_1
XFILLER_0_32_29 VGND VGND VPWR VPWR sky130_fd_sc_hd__decap_4
XTAP_1099 VGND VPWR sky130_fd_sc_hd__tapvpwrvgnd_1
XTAP_1088 VGND VPWR sky130_fd_sc_hd__tapvpwrvgnd_1
XTAP_1077 VGND VPWR sky130_fd_sc_hd__tapvpwrvgnd_1
XTAP_1066 VGND VPWR sky130_fd_sc_hd__tapvpwrvgnd_1
XFILLER_0_108_643 VGND VGND VPWR VPWR sky130_fd_sc_hd__fill_1
XFILLER_0_52_202 VGND VGND VPWR VPWR sky130_fd_sc_hd__decap_6
XFILLER_0_25_449 VGND VGND VPWR VPWR sky130_fd_sc_hd__decap_3
XFILLER_0_80_577 VGND VGND VPWR VPWR sky130_fd_sc_hd__fill_2
XANTENNA__3518__A2 _0769_ VGND VGND VPWR VPWR sky130_fd_sc_hd__diode_2
XFILLER_0_40_408 VGND VGND VPWR VPWR sky130_fd_sc_hd__fill_2
XFILLER_0_52_279 VGND VGND VPWR VPWR sky130_fd_sc_hd__decap_3
XFILLER_0_40_419 VGND VGND VPWR VPWR sky130_fd_sc_hd__fill_1
XFILLER_0_0_505 VPWR VGND VPWR VGND sky130_ef_sc_hd__decap_12
XFILLER_0_21_644 VGND VGND VPWR VPWR sky130_fd_sc_hd__fill_1
XFILLER_0_57_15 VPWR VGND VPWR VGND sky130_ef_sc_hd__decap_12
XTAP_817 VGND VPWR sky130_fd_sc_hd__tapvpwrvgnd_1
XTAP_806 VGND VPWR sky130_fd_sc_hd__tapvpwrvgnd_1
XTAP_839 VGND VPWR sky130_fd_sc_hd__tapvpwrvgnd_1
XTAP_828 VGND VPWR sky130_fd_sc_hd__tapvpwrvgnd_1
XFILLER_0_88_655 VGND VGND VPWR VPWR sky130_fd_sc_hd__fill_2
X_5860_ _2258_ _2718_ _2719_ _2571_ net317 VGND VGND VPWR VPWR _0384_ sky130_fd_sc_hd__a32o_1
X_4811_ net603 _1666_ _1655_ _1831_ VGND VGND VPWR VPWR _0223_ sky130_fd_sc_hd__a22o_1
XFILLER_0_28_210 VGND VGND VPWR VPWR sky130_fd_sc_hd__fill_2
X_5791_ u_pe_array.g_pe_row\[0\].g_pe_col\[3\].u_pe.psum_out\[4\] _2643_ _2644_ VGND
+ VGND VPWR VPWR _2657_ sky130_fd_sc_hd__a21boi_1
X_4742_ _1725_ _1781_ _1782_ _1534_ net331 VGND VGND VPWR VPWR _0203_ sky130_fd_sc_hd__a32o_1
XFILLER_0_7_137 VPWR VGND VPWR VGND sky130_ef_sc_hd__decap_12
XFILLER_0_16_416 VGND VGND VPWR VPWR sky130_fd_sc_hd__fill_2
X_7530_ clknet_leaf_2_clk _0579_ VGND VGND VPWR VPWR u_pe_array.u_fifo2.buffer\[7\]\[4\]
+ sky130_fd_sc_hd__dfxtp_1
XFILLER_0_83_382 VGND VGND VPWR VPWR sky130_fd_sc_hd__fill_1
XFILLER_0_71_544 VGND VGND VPWR VPWR sky130_fd_sc_hd__fill_2
X_4673_ _1718_ _1719_ VGND VGND VPWR VPWR _1720_ sky130_fd_sc_hd__nor2_1
XFILLER_0_16_449 VPWR VGND VPWR VGND sky130_ef_sc_hd__decap_12
XFILLER_0_22_62 VGND VGND VPWR VPWR sky130_fd_sc_hd__fill_1
X_7461_ clknet_leaf_4_clk _0510_ VGND VGND VPWR VPWR u_pe_array.u_fifo2.buffer\[2\]\[0\]
+ sky130_fd_sc_hd__dfxtp_1
X_3624_ net128 _0834_ _0850_ u_fsm.psum_shift_en VGND VGND VPWR VPWR _0017_ sky130_fd_sc_hd__a22o_1
X_6412_ _3169_ VGND VGND VPWR VPWR _0486_ sky130_fd_sc_hd__clkbuf_1
X_7392_ clknet_leaf_83_clk _0444_ net818 VGND VGND VPWR VPWR u_fsm.ch_cnt\[0\] sky130_fd_sc_hd__dfrtp_1
XFILLER_0_43_279 VGND VGND VPWR VPWR sky130_fd_sc_hd__fill_1
XFILLER_0_3_321 VGND VGND VPWR VPWR sky130_fd_sc_hd__fill_2
XFILLER_0_12_622 VPWR VGND VPWR VGND sky130_ef_sc_hd__decap_12
XFILLER_0_101_318 VPWR VGND VPWR VGND sky130_ef_sc_hd__decap_12
X_6343_ _1787_ _1134_ net58 VGND VGND VPWR VPWR _3122_ sky130_fd_sc_hd__a21o_2
X_3555_ _0800_ VGND VGND VPWR VPWR u_fsm.next_state\[0\] sky130_fd_sc_hd__buf_1
X_6274_ _3057_ _3063_ VGND VGND VPWR VPWR _3065_ sky130_fd_sc_hd__or2_1
X_3486_ u_pe_array.g_pe_row\[3\].g_pe_col\[0\].u_pe.move_reg\[10\] _0730_ VGND VGND
+ VPWR VPWR _0751_ sky130_fd_sc_hd__or2_1
X_5225_ u_pe_array.g_pe_row\[1\].g_pe_col\[2\].u_pe.act_val\[2\] VGND VGND VPWR VPWR
+ _2177_ sky130_fd_sc_hd__inv_2
XANTENNA__7280__RESET_B net814 VGND VGND VPWR VPWR sky130_fd_sc_hd__diode_2
X_5156_ _2029_ u_pe_array.g_pe_row\[1\].g_pe_col\[3\].u_pe.psum_out\[11\] VGND VGND
+ VPWR VPWR _2128_ sky130_fd_sc_hd__and2b_1
XFILLER_0_98_419 VGND VGND VPWR VPWR sky130_fd_sc_hd__fill_1
X_5087_ _2063_ _2065_ VGND VGND VPWR VPWR _2066_ sky130_fd_sc_hd__xnor2_2
X_4107_ u_pe_array.g_pe_row\[3\].g_pe_col\[3\].u_pe.psum_out\[0\] u_pe_array.g_pe_row\[3\].g_pe_col\[3\].u_pe.act_val\[0\]
+ _0769_ VGND VGND VPWR VPWR _1256_ sky130_fd_sc_hd__mux2_1
XFILLER_0_78_110 VGND VGND VPWR VPWR sky130_fd_sc_hd__fill_2
X_4038_ _1194_ _1196_ VGND VGND VPWR VPWR _1197_ sky130_fd_sc_hd__or2_1
XANTENNA__6631__A1 net9 VGND VGND VPWR VPWR sky130_fd_sc_hd__diode_2
XFILLER_0_2_83 VGND VGND VPWR VPWR sky130_fd_sc_hd__fill_1
XPHY_116 VGND VGND VPWR VPWR sky130_fd_sc_hd__decap_3
XPHY_105 VGND VGND VPWR VPWR sky130_fd_sc_hd__decap_3
XFILLER_0_93_124 VGND VGND VPWR VPWR sky130_fd_sc_hd__fill_1
XPHY_149 VGND VGND VPWR VPWR sky130_fd_sc_hd__decap_3
XPHY_138 VGND VGND VPWR VPWR sky130_fd_sc_hd__decap_3
XANTENNA__5198__B2 _1665_ VGND VGND VPWR VPWR sky130_fd_sc_hd__diode_2
XPHY_127 VGND VGND VPWR VPWR sky130_fd_sc_hd__decap_3
X_5989_ _2822_ _2823_ VGND VGND VPWR VPWR _2824_ sky130_fd_sc_hd__nand2_1
XFILLER_0_47_541 VGND VGND VPWR VPWR sky130_fd_sc_hd__fill_1
XANTENNA__5709__S _0770_ VGND VGND VPWR VPWR sky130_fd_sc_hd__diode_2
XANTENNA__4945__B2 _0916_ VGND VGND VPWR VPWR sky130_fd_sc_hd__diode_2
XFILLER_0_74_360 VGND VGND VPWR VPWR sky130_fd_sc_hd__fill_2
X_7659_ clknet_leaf_22_clk _0708_ VGND VGND VPWR VPWR u_pe_array.u_fifo1.buffer\[7\]\[4\]
+ sky130_fd_sc_hd__dfxtp_1
XFILLER_0_62_544 VGND VGND VPWR VPWR sky130_fd_sc_hd__fill_2
XFILLER_0_7_671 VGND VGND VPWR VPWR sky130_fd_sc_hd__fill_1
XANTENNA__7368__RESET_B net812 VGND VGND VPWR VPWR sky130_fd_sc_hd__diode_2
XANTENNA__6870__A1 _3120_ VGND VGND VPWR VPWR sky130_fd_sc_hd__diode_2
XANTENNA__4881__B1 _0914_ VGND VGND VPWR VPWR sky130_fd_sc_hd__diode_2
XANTENNA_input28_A w_in_flat[1] VGND VGND VPWR VPWR sky130_fd_sc_hd__diode_2
XFILLER_0_69_110 VGND VGND VPWR VPWR sky130_fd_sc_hd__fill_2
XANTENNA__6932__RESET_B net819 VGND VGND VPWR VPWR sky130_fd_sc_hd__diode_2
XFILLER_0_69_176 VGND VGND VPWR VPWR sky130_fd_sc_hd__decap_3
XPHY_7 VGND VGND VPWR VPWR sky130_fd_sc_hd__decap_3
XFILLER_0_65_371 VPWR VGND VPWR VGND sky130_ef_sc_hd__decap_12
XFILLER_0_38_585 VGND VGND VPWR VPWR sky130_fd_sc_hd__decap_3
XFILLER_0_108_484 VGND VGND VPWR VPWR sky130_fd_sc_hd__fill_1
XFILLER_0_53_544 VGND VGND VPWR VPWR sky130_fd_sc_hd__decap_6
Xhold309 u_pe_array.g_pe_row\[0\].g_pe_col\[1\].u_pe.psum_out\[6\] VGND VGND VPWR
+ VPWR net385 sky130_fd_sc_hd__dlygate4sd3_1
XFILLER_0_7_39 VPWR VGND VPWR VGND sky130_ef_sc_hd__decap_12
XFILLER_0_0_335 VGND VGND VPWR VPWR sky130_fd_sc_hd__fill_1
XANTENNA__7038__RESET_B net76 VGND VGND VPWR VPWR sky130_fd_sc_hd__diode_2
XTAP_603 VGND VPWR sky130_fd_sc_hd__tapvpwrvgnd_1
XTAP_614 VGND VPWR sky130_fd_sc_hd__tapvpwrvgnd_1
XTAP_625 VGND VPWR sky130_fd_sc_hd__tapvpwrvgnd_1
X_5010_ _1787_ _2002_ VGND VGND VPWR VPWR _2003_ sky130_fd_sc_hd__or2_1
XTAP_636 VGND VPWR sky130_fd_sc_hd__tapvpwrvgnd_1
XTAP_658 VGND VPWR sky130_fd_sc_hd__tapvpwrvgnd_1
XTAP_647 VGND VPWR sky130_fd_sc_hd__tapvpwrvgnd_1
XANTENNA__4872__B1 _1847_ VGND VGND VPWR VPWR sky130_fd_sc_hd__diode_2
XFILLER_0_84_24 VGND VGND VPWR VPWR sky130_fd_sc_hd__fill_1
XTAP_669 VGND VPWR sky130_fd_sc_hd__tapvpwrvgnd_1
XFILLER_0_108_53 VGND VGND VPWR VPWR sky130_fd_sc_hd__decap_6
XANTENNA__6613__A1 _1808_ VGND VGND VPWR VPWR sky130_fd_sc_hd__diode_2
XFILLER_0_88_441 VGND VGND VPWR VPWR sky130_fd_sc_hd__fill_2
X_6961_ clknet_leaf_17_clk _0042_ net816 VGND VGND VPWR VPWR u_pe_array.g_pe_row\[3\].g_pe_col\[1\].u_pe.act_val\[3\]
+ sky130_fd_sc_hd__dfrtp_2
XFILLER_0_88_485 VGND VGND VPWR VPWR sky130_fd_sc_hd__fill_2
X_6892_ net501 _3114_ _3427_ VGND VGND VPWR VPWR _3430_ sky130_fd_sc_hd__mux2_1
XFILLER_0_48_305 VGND VGND VPWR VPWR sky130_fd_sc_hd__decap_3
X_5912_ _2750_ _2752_ VGND VGND VPWR VPWR _2753_ sky130_fd_sc_hd__xnor2_1
XFILLER_0_75_124 VGND VGND VPWR VPWR sky130_fd_sc_hd__fill_2
XFILLER_0_48_338 VGND VGND VPWR VPWR sky130_fd_sc_hd__decap_3
X_5843_ _2683_ _2686_ _2691_ _2703_ VGND VGND VPWR VPWR _2704_ sky130_fd_sc_hd__a211o_1
XFILLER_0_91_617 VGND VGND VPWR VPWR sky130_fd_sc_hd__decap_3
XFILLER_0_63_308 VGND VGND VPWR VPWR sky130_fd_sc_hd__fill_2
XFILLER_0_16_224 VGND VGND VPWR VPWR sky130_fd_sc_hd__fill_1
XFILLER_0_29_596 VGND VGND VPWR VPWR sky130_fd_sc_hd__fill_2
X_5774_ _2628_ _2638_ _2637_ VGND VGND VPWR VPWR _2641_ sky130_fd_sc_hd__a21oi_1
X_7513_ clknet_leaf_3_clk _0562_ VGND VGND VPWR VPWR u_pe_array.u_fifo2.buffer\[6\]\[0\]
+ sky130_fd_sc_hd__dfxtp_1
X_4725_ _1746_ _1749_ _1754_ _1766_ VGND VGND VPWR VPWR _1767_ sky130_fd_sc_hd__a211o_1
XFILLER_0_44_555 VGND VGND VPWR VPWR sky130_fd_sc_hd__decap_6
XFILLER_0_16_257 VGND VGND VPWR VPWR sky130_fd_sc_hd__fill_2
X_4656_ _1672_ _1703_ u_pe_array.g_pe_row\[2\].g_pe_col\[1\].u_pe.act_val\[4\] u_pe_array.g_pe_row\[2\].g_pe_col\[1\].u_pe.w_reg\[0\]
+ VGND VGND VPWR VPWR _1704_ sky130_fd_sc_hd__a22o_1
XFILLER_0_44_577 VGND VGND VPWR VPWR sky130_fd_sc_hd__fill_2
XFILLER_0_16_268 VGND VGND VPWR VPWR sky130_fd_sc_hd__decap_3
X_7444_ clknet_leaf_92_clk _0493_ VGND VGND VPWR VPWR u_pe_array.u_fifo2.buffer\[0\]\[9\]
+ sky130_fd_sc_hd__dfxtp_1
X_7375_ clknet_leaf_42_clk net100 net75 VGND VGND VPWR VPWR u_pe_array.g_pe_row\[0\].g_pe_col\[1\].u_pe.w_reg\[1\]
+ sky130_fd_sc_hd__dfrtp_1
X_4587_ net727 _1524_ _1258_ _1651_ VGND VGND VPWR VPWR _0179_ sky130_fd_sc_hd__a22o_1
XFILLER_0_24_290 VGND VGND VPWR VPWR sky130_fd_sc_hd__fill_2
X_3607_ net764 _0834_ _0837_ _0839_ VGND VGND VPWR VPWR _0011_ sky130_fd_sc_hd__a22o_1
X_6326_ _3103_ net552 _3110_ VGND VGND VPWR VPWR _3111_ sky130_fd_sc_hd__mux2_1
X_3538_ _0718_ _0723_ _0717_ VGND VGND VPWR VPWR _0785_ sky130_fd_sc_hd__and3b_1
XFILLER_0_12_452 VGND VGND VPWR VPWR sky130_fd_sc_hd__fill_1
XANTENNA_clkbuf_leaf_51_clk_A clknet_3_7__leaf_clk VGND VGND VPWR VPWR sky130_fd_sc_hd__diode_2
XFILLER_0_12_485 VGND VGND VPWR VPWR sky130_fd_sc_hd__decap_3
X_6257_ u_pe_array.g_pe_row\[0\].g_pe_col\[0\].u_pe.psum_out\[5\] _2992_ VGND VGND
+ VPWR VPWR _3049_ sky130_fd_sc_hd__nand2_1
X_3469_ _0740_ VGND VGND VPWR VPWR net55 sky130_fd_sc_hd__clkbuf_2
XANTENNA__6852__A1 _3130_ VGND VGND VPWR VPWR sky130_fd_sc_hd__diode_2
X_6188_ _0785_ _0719_ u_fsm.ch_cnt\[0\] VGND VGND VPWR VPWR _2988_ sky130_fd_sc_hd__mux2_1
X_5208_ u_pe_array.g_pe_row\[1\].g_pe_col\[2\].u_pe.psum_out\[1\] _2161_ VGND VGND
+ VPWR VPWR _2162_ sky130_fd_sc_hd__or2_1
XFILLER_0_98_205 VGND VGND VPWR VPWR sky130_fd_sc_hd__fill_2
XANTENNA__4608__S _1661_ VGND VGND VPWR VPWR sky130_fd_sc_hd__diode_2
X_5139_ _2029_ u_pe_array.g_pe_row\[1\].g_pe_col\[3\].u_pe.psum_out\[9\] VGND VGND
+ VPWR VPWR _2113_ sky130_fd_sc_hd__nor2_1
XFILLER_0_98_227 VGND VGND VPWR VPWR sky130_fd_sc_hd__fill_2
XANTENNA__5407__A2 _2144_ VGND VGND VPWR VPWR sky130_fd_sc_hd__diode_2
XANTENNA_clkbuf_leaf_66_clk_A clknet_3_5__leaf_clk VGND VGND VPWR VPWR sky130_fd_sc_hd__diode_2
XFILLER_0_79_485 VGND VGND VPWR VPWR sky130_fd_sc_hd__fill_2
XFILLER_0_67_614 VGND VGND VPWR VPWR sky130_fd_sc_hd__fill_2
XFILLER_0_94_477 VGND VGND VPWR VPWR sky130_fd_sc_hd__fill_2
XFILLER_0_47_393 VGND VGND VPWR VPWR sky130_fd_sc_hd__fill_2
XFILLER_0_62_352 VGND VGND VPWR VPWR sky130_fd_sc_hd__decap_6
XANTENNA__7549__RESET_B net815 VGND VGND VPWR VPWR sky130_fd_sc_hd__diode_2
XFILLER_0_105_421 VGND VGND VPWR VPWR sky130_fd_sc_hd__fill_2
XFILLER_0_62_385 VGND VGND VPWR VPWR sky130_fd_sc_hd__decap_3
XFILLER_0_22_205 VGND VGND VPWR VPWR sky130_fd_sc_hd__fill_1
XFILLER_0_35_599 VGND VGND VPWR VPWR sky130_fd_sc_hd__fill_2
XFILLER_0_105_476 VGND VGND VPWR VPWR sky130_fd_sc_hd__fill_2
XFILLER_0_22_238 VGND VGND VPWR VPWR sky130_fd_sc_hd__fill_2
XANTENNA__5174__S _0754_ VGND VGND VPWR VPWR sky130_fd_sc_hd__diode_2
XFILLER_0_50_569 VGND VGND VPWR VPWR sky130_fd_sc_hd__fill_1
XANTENNA_clkbuf_leaf_19_clk_A clknet_3_2__leaf_clk VGND VGND VPWR VPWR sky130_fd_sc_hd__diode_2
XANTENNA__7131__RESET_B net816 VGND VGND VPWR VPWR sky130_fd_sc_hd__diode_2
XANTENNA__3930__B _1009_ VGND VGND VPWR VPWR sky130_fd_sc_hd__diode_2
XFILLER_0_89_238 VGND VGND VPWR VPWR sky130_fd_sc_hd__fill_2
XFILLER_0_54_27 VGND VGND VPWR VPWR sky130_fd_sc_hd__fill_1
XANTENNA__6359__A0 _3132_ VGND VGND VPWR VPWR sky130_fd_sc_hd__diode_2
XFILLER_0_70_15 VPWR VGND VPWR VGND sky130_ef_sc_hd__decap_12
XFILLER_0_57_113 VGND VGND VPWR VPWR sky130_fd_sc_hd__fill_1
XFILLER_0_85_477 VGND VGND VPWR VPWR sky130_fd_sc_hd__fill_2
XFILLER_0_73_617 VGND VGND VPWR VPWR sky130_fd_sc_hd__decap_3
XFILLER_0_73_606 VGND VGND VPWR VPWR sky130_fd_sc_hd__fill_2
XFILLER_0_72_127 VGND VGND VPWR VPWR sky130_fd_sc_hd__fill_2
XFILLER_0_72_116 VGND VGND VPWR VPWR sky130_fd_sc_hd__fill_1
XFILLER_0_26_511 VGND VGND VPWR VPWR sky130_fd_sc_hd__fill_1
XFILLER_0_108_270 VPWR VGND VPWR VGND sky130_ef_sc_hd__decap_12
XFILLER_0_5_416 VGND VGND VPWR VPWR sky130_fd_sc_hd__fill_1
X_5490_ _2410_ VGND VGND VPWR VPWR _2411_ sky130_fd_sc_hd__inv_2
XFILLER_0_5_449 VGND VGND VPWR VPWR sky130_fd_sc_hd__fill_1
X_4510_ _1583_ _1584_ VGND VGND VPWR VPWR _1585_ sky130_fd_sc_hd__and2b_1
XFILLER_0_13_216 VGND VGND VPWR VPWR sky130_fd_sc_hd__fill_1
XFILLER_0_102_3 VPWR VGND VPWR VGND sky130_ef_sc_hd__decap_12
XFILLER_0_79_57 VGND VGND VPWR VPWR sky130_fd_sc_hd__decap_6
Xhold106 u_pe_array.g_pe_row\[2\].g_pe_col\[0\].u_pe.move_reg\[12\] VGND VGND VPWR
+ VPWR net182 sky130_fd_sc_hd__dlygate4sd3_1
XANTENNA__7219__RESET_B net812 VGND VGND VPWR VPWR sky130_fd_sc_hd__diode_2
Xhold117 u_pe_array.g_pe_row\[2\].g_pe_col\[1\].u_pe.move_reg\[10\] VGND VGND VPWR
+ VPWR net193 sky130_fd_sc_hd__dlygate4sd3_1
X_4441_ u_pe_array.g_pe_row\[3\].g_pe_col\[1\].u_pe.psum_out\[8\] u_pe_array.g_pe_row\[3\].g_pe_col\[1\].u_pe.move_reg\[8\]
+ _0855_ VGND VGND VPWR VPWR _1526_ sky130_fd_sc_hd__mux2_1
XFILLER_0_41_558 VGND VGND VPWR VPWR sky130_fd_sc_hd__fill_2
XFILLER_0_111_446 VGND VGND VPWR VPWR sky130_fd_sc_hd__fill_2
XFILLER_0_110_65 VGND VGND VPWR VPWR sky130_fd_sc_hd__decap_3
XANTENNA__5885__A2 _2600_ VGND VGND VPWR VPWR sky130_fd_sc_hd__diode_2
Xhold139 _0398_ VGND VGND VPWR VPWR net215 sky130_fd_sc_hd__dlygate4sd3_1
Xhold128 _0286_ VGND VGND VPWR VPWR net204 sky130_fd_sc_hd__dlygate4sd3_1
X_7160_ clknet_leaf_70_clk _0229_ net814 VGND VGND VPWR VPWR u_pe_array.g_pe_row\[1\].g_pe_col\[3\].u_pe.move_reg\[9\]
+ sky130_fd_sc_hd__dfrtp_1
X_6111_ _2918_ _2919_ VGND VGND VPWR VPWR _2921_ sky130_fd_sc_hd__nand2_1
XTAP_400 VGND VPWR sky130_fd_sc_hd__tapvpwrvgnd_1
X_4372_ u_pe_array.g_pe_row\[2\].g_pe_col\[3\].u_pe.psum_out\[7\] _1472_ _1462_ VGND
+ VGND VPWR VPWR _1473_ sky130_fd_sc_hd__mux2_1
XANTENNA__6908__S _3427_ VGND VGND VPWR VPWR sky130_fd_sc_hd__diode_2
XTAP_411 VGND VPWR sky130_fd_sc_hd__tapvpwrvgnd_1
XTAP_422 VGND VPWR sky130_fd_sc_hd__tapvpwrvgnd_1
XTAP_433 VGND VPWR sky130_fd_sc_hd__tapvpwrvgnd_1
X_7091_ clknet_leaf_87_clk net103 net819 VGND VGND VPWR VPWR u_pe_array.g_pe_row\[2\].g_pe_col\[2\].u_pe.w_reg\[0\]
+ sky130_fd_sc_hd__dfrtp_4
X_6042_ u_pe_array.g_pe_row\[0\].g_pe_col\[1\].u_pe.psum_out\[7\] net118 _2469_ VGND
+ VGND VPWR VPWR _2863_ sky130_fd_sc_hd__mux2_1
XTAP_444 VGND VPWR sky130_fd_sc_hd__tapvpwrvgnd_1
XTAP_455 VGND VPWR sky130_fd_sc_hd__tapvpwrvgnd_1
XTAP_466 VGND VPWR sky130_fd_sc_hd__tapvpwrvgnd_1
XANTENNA__4428__S _0769_ VGND VGND VPWR VPWR sky130_fd_sc_hd__diode_2
XTAP_488 VGND VPWR sky130_fd_sc_hd__tapvpwrvgnd_1
XTAP_477 VGND VPWR sky130_fd_sc_hd__tapvpwrvgnd_1
XTAP_499 VGND VPWR sky130_fd_sc_hd__tapvpwrvgnd_1
XFILLER_0_49_614 VGND VGND VPWR VPWR sky130_fd_sc_hd__fill_2
X_6944_ clknet_leaf_78_clk _0025_ net815 VGND VGND VPWR VPWR u_pe_array.g_pe_row\[3\].g_pe_col\[3\].u_pe.psum_out\[1\]
+ sky130_fd_sc_hd__dfrtp_1
XFILLER_0_88_293 VGND VGND VPWR VPWR sky130_fd_sc_hd__fill_2
XFILLER_0_49_647 VGND VGND VPWR VPWR sky130_fd_sc_hd__decap_3
XFILLER_0_44_82 VGND VGND VPWR VPWR sky130_fd_sc_hd__fill_2
X_6875_ _3420_ VGND VGND VPWR VPWR _0698_ sky130_fd_sc_hd__clkbuf_1
XFILLER_0_76_477 VGND VGND VPWR VPWR sky130_fd_sc_hd__fill_2
XFILLER_0_63_127 VGND VGND VPWR VPWR sky130_fd_sc_hd__decap_3
X_5826_ _2611_ u_pe_array.g_pe_row\[0\].g_pe_col\[3\].u_pe.psum_out\[7\] _2687_ _2688_
+ VGND VGND VPWR VPWR _2689_ sky130_fd_sc_hd__a22oi_1
XFILLER_0_17_533 VGND VGND VPWR VPWR sky130_fd_sc_hd__decap_4
XFILLER_0_17_555 VGND VGND VPWR VPWR sky130_fd_sc_hd__decap_4
X_5757_ _2618_ _2624_ _0885_ VGND VGND VPWR VPWR _2626_ sky130_fd_sc_hd__o21a_1
X_4708_ _1672_ u_pe_array.g_pe_row\[2\].g_pe_col\[1\].u_pe.psum_out\[7\] _1750_ _1751_
+ VGND VGND VPWR VPWR _1752_ sky130_fd_sc_hd__a22oi_1
XFILLER_0_32_525 VGND VGND VPWR VPWR sky130_fd_sc_hd__decap_6
X_5688_ u_pe_array.g_pe_row\[1\].g_pe_col\[0\].u_pe.psum_out\[10\] _2576_ _2565_ VGND
+ VGND VPWR VPWR _2577_ sky130_fd_sc_hd__mux2_1
X_7427_ clknet_leaf_8_clk _0476_ net74 VGND VGND VPWR VPWR u_pe_array.u_fifo2.rd_ptr\[0\]
+ sky130_fd_sc_hd__dfrtp_4
XANTENNA__4399__A _1407_ VGND VGND VPWR VPWR sky130_fd_sc_hd__diode_2
XFILLER_0_32_536 VGND VGND VPWR VPWR sky130_fd_sc_hd__decap_8
X_4639_ _1680_ _1684_ VGND VGND VPWR VPWR _1688_ sky130_fd_sc_hd__nor2_1
XANTENNA__3507__S _0756_ VGND VGND VPWR VPWR sky130_fd_sc_hd__diode_2
Xhold651 u_pe_array.g_pe_row\[2\].g_pe_col\[0\].u_pe.act_val\[0\] VGND VGND VPWR VPWR
+ net727 sky130_fd_sc_hd__dlygate4sd3_1
Xhold662 u_pe_array.g_pe_row\[1\].g_pe_col\[0\].u_pe.psum_out\[9\] VGND VGND VPWR
+ VPWR net738 sky130_fd_sc_hd__dlygate4sd3_1
X_7358_ clknet_leaf_65_clk _0413_ net818 VGND VGND VPWR VPWR u_pe_array.g_pe_row\[0\].g_pe_col\[2\].u_pe.psum_out\[12\]
+ sky130_fd_sc_hd__dfrtp_1
Xhold640 u_pe_array.g_pe_row\[0\].g_pe_col\[3\].u_pe.psum_out\[4\] VGND VGND VPWR
+ VPWR net716 sky130_fd_sc_hd__dlygate4sd3_1
XFILLER_0_40_580 VGND VGND VPWR VPWR sky130_fd_sc_hd__fill_1
XANTENNA__6818__S _3382_ VGND VGND VPWR VPWR sky130_fd_sc_hd__diode_2
X_6309_ _3094_ _3095_ VGND VGND VPWR VPWR _3096_ sky130_fd_sc_hd__or2_1
Xhold673 u_pe_array.g_pe_row\[0\].g_pe_col\[1\].u_pe.psum_out\[12\] VGND VGND VPWR
+ VPWR net749 sky130_fd_sc_hd__dlygate4sd3_1
X_7289_ clknet_leaf_38_clk _0348_ net813 VGND VGND VPWR VPWR u_pe_array.g_pe_row\[1\].g_pe_col\[0\].u_pe.psum_out\[3\]
+ sky130_fd_sc_hd__dfrtp_1
Xhold695 u_pe_array.g_pe_row\[2\].g_pe_col\[2\].u_pe.act_val\[5\] VGND VGND VPWR VPWR
+ net771 sky130_fd_sc_hd__dlygate4sd3_1
Xhold684 u_pe_array.g_pe_row\[1\].g_pe_col\[3\].u_pe.psum_out\[6\] VGND VGND VPWR
+ VPWR net760 sky130_fd_sc_hd__dlygate4sd3_1
XFILLER_0_99_503 VGND VGND VPWR VPWR sky130_fd_sc_hd__fill_1
XANTENNA__6119__A _2873_ VGND VGND VPWR VPWR sky130_fd_sc_hd__diode_2
XFILLER_0_99_547 VGND VGND VPWR VPWR sky130_fd_sc_hd__fill_1
XANTENNA_hold544_A u_pe_array.g_pe_row\[2\].g_pe_col\[0\].u_pe.move_reg\[8\] VGND
+ VGND VPWR VPWR sky130_fd_sc_hd__diode_2
XANTENNA__6053__A2 _2738_ VGND VGND VPWR VPWR sky130_fd_sc_hd__diode_2
XANTENNA__6553__S _3239_ VGND VGND VPWR VPWR sky130_fd_sc_hd__diode_2
XFILLER_0_94_263 VGND VGND VPWR VPWR sky130_fd_sc_hd__fill_1
XANTENNA__3478__A _0728_ VGND VGND VPWR VPWR sky130_fd_sc_hd__diode_2
XFILLER_0_67_455 VGND VGND VPWR VPWR sky130_fd_sc_hd__fill_1
XFILLER_0_27_308 VGND VGND VPWR VPWR sky130_fd_sc_hd__fill_2
XFILLER_0_94_285 VGND VGND VPWR VPWR sky130_fd_sc_hd__fill_2
XFILLER_0_35_341 VGND VGND VPWR VPWR sky130_fd_sc_hd__fill_2
XANTENNA__7383__RESET_B net812 VGND VGND VPWR VPWR sky130_fd_sc_hd__diode_2
XANTENNA__4801__S _0754_ VGND VGND VPWR VPWR sky130_fd_sc_hd__diode_2
Xload_slew7 net74 VGND VGND VPWR VPWR net818 sky130_fd_sc_hd__buf_12
XANTENNA__7312__RESET_B net814 VGND VGND VPWR VPWR sky130_fd_sc_hd__diode_2
XANTENNA__4119__A2 _1138_ VGND VGND VPWR VPWR sky130_fd_sc_hd__diode_2
XFILLER_0_50_377 VGND VGND VPWR VPWR sky130_fd_sc_hd__fill_2
XFILLER_0_101_490 VGND VGND VPWR VPWR sky130_fd_sc_hd__decap_4
XFILLER_0_65_15 VPWR VGND VPWR VGND sky130_ef_sc_hd__decap_12
XFILLER_0_4_29 VPWR VGND VPWR VGND sky130_ef_sc_hd__decap_12
X_4990_ u_pe_array.u_fifo2.buffer\[8\]\[1\] _1960_ _1980_ _1984_ _0819_ VGND VGND
+ VPWR VPWR _1985_ sky130_fd_sc_hd__a221o_2
X_3941_ net85 net79 _0828_ VGND VGND VPWR VPWR _1120_ sky130_fd_sc_hd__mux2_1
X_6660_ _3300_ _3298_ _3301_ _3105_ VGND VGND VPWR VPWR _0602_ sky130_fd_sc_hd__o2bb2a_1
XFILLER_0_45_105 VGND VGND VPWR VPWR sky130_fd_sc_hd__fill_1
XFILLER_0_18_319 VGND VGND VPWR VPWR sky130_fd_sc_hd__decap_3
X_3872_ _1057_ _1058_ VGND VGND VPWR VPWR _1059_ sky130_fd_sc_hd__nor2_1
X_5611_ _2495_ _2504_ _2506_ VGND VGND VPWR VPWR _2507_ sky130_fd_sc_hd__or3_1
X_6591_ net303 _1814_ _3254_ VGND VGND VPWR VPWR _3264_ sky130_fd_sc_hd__mux2_1
X_5542_ u_pe_array.g_pe_row\[1\].g_pe_col\[1\].u_pe.psum_out\[12\] _2448_ VGND VGND
+ VPWR VPWR _2457_ sky130_fd_sc_hd__xor2_1
XFILLER_0_30_40 VGND VGND VPWR VPWR sky130_fd_sc_hd__decap_8
XANTENNA__7053__RESET_B net819 VGND VGND VPWR VPWR sky130_fd_sc_hd__diode_2
XFILLER_0_30_73 VGND VGND VPWR VPWR sky130_fd_sc_hd__fill_1
X_5473_ _2393_ _2394_ VGND VGND VPWR VPWR _2395_ sky130_fd_sc_hd__and2b_1
XANTENNA__5108__A _2029_ VGND VGND VPWR VPWR sky130_fd_sc_hd__diode_2
XFILLER_0_111_254 VPWR VGND VPWR VGND sky130_ef_sc_hd__decap_12
X_4424_ u_pe_array.g_pe_row\[3\].g_pe_col\[1\].u_pe.act_val\[0\] u_pe_array.g_pe_row\[3\].g_pe_col\[1\].u_pe.psum_out\[0\]
+ _0770_ VGND VGND VPWR VPWR _1517_ sky130_fd_sc_hd__mux2_1
X_7212_ clknet_leaf_57_clk _0277_ net75 VGND VGND VPWR VPWR u_pe_array.g_pe_row\[1\].g_pe_col\[1\].u_pe.act_val\[1\]
+ sky130_fd_sc_hd__dfrtp_1
XFILLER_0_1_441 VGND VGND VPWR VPWR sky130_fd_sc_hd__decap_6
XFILLER_0_22_580 VGND VGND VPWR VPWR sky130_fd_sc_hd__decap_3
X_7143_ clknet_leaf_8_clk _0212_ VGND VGND VPWR VPWR u_pe_array.u_fifo2.buffer\[8\]\[7\]
+ sky130_fd_sc_hd__dfxtp_1
X_4355_ _1455_ _1457_ VGND VGND VPWR VPWR _1458_ sky130_fd_sc_hd__or2_1
XFILLER_0_1_485 VPWR VGND VPWR VGND sky130_ef_sc_hd__decap_12
XTAP_230 VGND VPWR sky130_fd_sc_hd__tapvpwrvgnd_1
XTAP_241 VGND VPWR sky130_fd_sc_hd__tapvpwrvgnd_1
X_7074_ clknet_leaf_85_clk _0147_ net74 VGND VGND VPWR VPWR u_pe_array.g_pe_row\[2\].g_pe_col\[3\].u_pe.psum_out\[11\]
+ sky130_fd_sc_hd__dfrtp_1
XTAP_263 VGND VPWR sky130_fd_sc_hd__tapvpwrvgnd_1
XTAP_252 VGND VPWR sky130_fd_sc_hd__tapvpwrvgnd_1
XTAP_274 VGND VPWR sky130_fd_sc_hd__tapvpwrvgnd_1
X_4286_ net129 _1392_ _1398_ _1399_ VGND VGND VPWR VPWR _0130_ sky130_fd_sc_hd__a22o_1
X_6025_ _2854_ VGND VGND VPWR VPWR _0414_ sky130_fd_sc_hd__clkbuf_1
XANTENNA__5491__B1 _2071_ VGND VGND VPWR VPWR sky130_fd_sc_hd__diode_2
XTAP_296 VGND VPWR sky130_fd_sc_hd__tapvpwrvgnd_1
XTAP_285 VGND VPWR sky130_fd_sc_hd__tapvpwrvgnd_1
XANTENNA__4385__C _1407_ VGND VGND VPWR VPWR sky130_fd_sc_hd__diode_2
XANTENNA__4294__B2 _1399_ VGND VGND VPWR VPWR sky130_fd_sc_hd__diode_2
XANTENNA__6035__A2 _2738_ VGND VGND VPWR VPWR sky130_fd_sc_hd__diode_2
XTAP_1429 VGND VPWR sky130_fd_sc_hd__tapvpwrvgnd_1
XTAP_1418 VGND VPWR sky130_fd_sc_hd__tapvpwrvgnd_1
XTAP_1407 VGND VPWR sky130_fd_sc_hd__tapvpwrvgnd_1
X_6927_ clknet_leaf_76_clk _0010_ net815 VGND VGND VPWR VPWR u_pe_array.g_pe_row\[3\].g_pe_col\[3\].u_pe.w_buffer\[1\]
+ sky130_fd_sc_hd__dfrtp_1
XFILLER_0_76_263 VPWR VGND VPWR VGND sky130_ef_sc_hd__decap_12
X_6858_ _3106_ u_pe_array.u_fifo1.wr_ptr\[1\] _3380_ VGND VGND VPWR VPWR _3411_ sky130_fd_sc_hd__and3b_1
XFILLER_0_9_541 VPWR VGND VPWR VGND sky130_ef_sc_hd__decap_12
XFILLER_0_107_516 VPWR VGND VPWR VGND sky130_ef_sc_hd__decap_12
XFILLER_0_91_255 VGND VGND VPWR VPWR sky130_fd_sc_hd__fill_2
XFILLER_0_9_585 VPWR VGND VPWR VGND sky130_ef_sc_hd__decap_12
X_5809_ _2671_ _2672_ _2673_ VGND VGND VPWR VPWR _2674_ sky130_fd_sc_hd__or3_1
X_6789_ net217 _3124_ _3366_ VGND VGND VPWR VPWR _3374_ sky130_fd_sc_hd__mux2_1
XANTENNA__5717__S _0770_ VGND VGND VPWR VPWR sky130_fd_sc_hd__diode_2
XFILLER_0_44_193 VGND VGND VPWR VPWR sky130_fd_sc_hd__decap_3
XFILLER_0_44_182 VGND VGND VPWR VPWR sky130_fd_sc_hd__fill_2
XFILLER_0_32_355 VGND VGND VPWR VPWR sky130_fd_sc_hd__fill_2
Xhold481 u_pe_array.u_fifo1.buffer\[4\]\[4\] VGND VGND VPWR VPWR net557 sky130_fd_sc_hd__dlygate4sd3_1
Xhold470 u_pe_array.g_pe_row\[1\].g_pe_col\[1\].u_pe.psum_out\[9\] VGND VGND VPWR
+ VPWR net546 sky130_fd_sc_hd__dlygate4sd3_1
XFILLER_0_102_298 VGND VGND VPWR VPWR sky130_fd_sc_hd__fill_2
Xhold492 u_pe_array.u_fifo1.buffer\[8\]\[1\] VGND VGND VPWR VPWR net568 sky130_fd_sc_hd__dlygate4sd3_1
XANTENNA__3480__B _0730_ VGND VGND VPWR VPWR sky130_fd_sc_hd__diode_2
XFILLER_0_99_311 VGND VGND VPWR VPWR sky130_fd_sc_hd__decap_4
XANTENNA_input10_A h_in1[3] VGND VGND VPWR VPWR sky130_fd_sc_hd__diode_2
XFILLER_0_28_617 VGND VGND VPWR VPWR sky130_fd_sc_hd__decap_4
XFILLER_0_55_469 VGND VGND VPWR VPWR sky130_fd_sc_hd__decap_8
XFILLER_0_55_447 VGND VGND VPWR VPWR sky130_fd_sc_hd__fill_1
XFILLER_0_63_491 VGND VGND VPWR VPWR sky130_fd_sc_hd__fill_2
XFILLER_0_50_141 VGND VGND VPWR VPWR sky130_fd_sc_hd__decap_4
XFILLER_0_50_174 VGND VGND VPWR VPWR sky130_fd_sc_hd__fill_2
XFILLER_0_11_517 VGND VGND VPWR VPWR sky130_fd_sc_hd__fill_2
XFILLER_0_23_377 VGND VGND VPWR VPWR sky130_fd_sc_hd__fill_2
X_4140_ u_pe_array.g_pe_row\[3\].g_pe_col\[0\].u_pe.w_reg\[1\] VGND VGND VPWR VPWR
+ _1275_ sky130_fd_sc_hd__clkbuf_8
X_4071_ _1216_ _1220_ _1225_ net72 VGND VGND VPWR VPWR _1227_ sky130_fd_sc_hd__a31o_1
XANTENNA__4028__A1 _0864_ VGND VGND VPWR VPWR sky130_fd_sc_hd__diode_2
XANTENNA__3766__A_N _0869_ VGND VGND VPWR VPWR sky130_fd_sc_hd__diode_2
XANTENNA__5776__A1 _2611_ VGND VGND VPWR VPWR sky130_fd_sc_hd__diode_2
X_4973_ u_pe_array.u_fifo2.rd_ptr\[1\] u_pe_array.u_fifo2.rd_ptr\[0\] _1968_ VGND
+ VGND VPWR VPWR _1969_ sky130_fd_sc_hd__and3_2
X_6712_ net266 _3128_ net66 VGND VGND VPWR VPWR _3334_ sky130_fd_sc_hd__mux2_1
XFILLER_0_73_200 VGND VGND VPWR VPWR sky130_fd_sc_hd__fill_2
XFILLER_0_19_617 VGND VGND VPWR VPWR sky130_fd_sc_hd__fill_2
XFILLER_0_19_639 VGND VGND VPWR VPWR sky130_fd_sc_hd__decap_3
X_3924_ _1104_ _1105_ VGND VGND VPWR VPWR _1106_ sky130_fd_sc_hd__and2_1
XFILLER_0_73_222 VGND VGND VPWR VPWR sky130_fd_sc_hd__fill_2
XANTENNA__7234__RESET_B net73 VGND VGND VPWR VPWR sky130_fd_sc_hd__diode_2
X_6643_ net692 _0833_ VGND VGND VPWR VPWR _3291_ sky130_fd_sc_hd__and2_1
XANTENNA__4441__S _0855_ VGND VGND VPWR VPWR sky130_fd_sc_hd__diode_2
X_3855_ _1041_ _1042_ u_pe_array.g_pe_row\[3\].g_pe_col\[2\].u_pe.act_val\[4\] u_pe_array.g_pe_row\[3\].g_pe_col\[2\].u_pe.w_reg\[0\]
+ VGND VGND VPWR VPWR _1043_ sky130_fd_sc_hd__and4bb_1
XFILLER_0_6_533 VPWR VGND VPWR VGND sky130_ef_sc_hd__decap_12
XFILLER_0_41_83 VGND VGND VPWR VPWR sky130_fd_sc_hd__decap_4
X_3786_ net826 _0834_ _0837_ _0989_ VGND VGND VPWR VPWR _0040_ sky130_fd_sc_hd__a22o_1
X_6574_ _3255_ VGND VGND VPWR VPWR _0562_ sky130_fd_sc_hd__clkbuf_1
X_5525_ _2440_ _2441_ _2430_ VGND VGND VPWR VPWR _2442_ sky130_fd_sc_hd__a21oi_1
XFILLER_0_14_344 VGND VGND VPWR VPWR sky130_fd_sc_hd__fill_1
X_5456_ u_pe_array.g_pe_row\[1\].g_pe_col\[1\].u_pe.psum_out\[4\] _2377_ _2378_ VGND
+ VGND VPWR VPWR _2379_ sky130_fd_sc_hd__nand3_1
XFILLER_0_74_3 VPWR VGND VPWR VGND sky130_ef_sc_hd__decap_12
X_4407_ u_pe_array.g_pe_row\[2\].g_pe_col\[3\].u_pe.psum_out\[11\] _1407_ VGND VGND
+ VPWR VPWR _1504_ sky130_fd_sc_hd__and2b_1
X_5387_ u_pe_array.g_pe_row\[0\].g_pe_col\[0\].u_pe.act_val\[4\] u_pe_array.g_pe_row\[0\].g_pe_col\[0\].u_pe.psum_out\[4\]
+ _0755_ VGND VGND VPWR VPWR _2323_ sky130_fd_sc_hd__mux2_1
XANTENNA__3711__B1 _0885_ VGND VGND VPWR VPWR sky130_fd_sc_hd__diode_2
X_7126_ clknet_leaf_37_clk _0195_ net76 VGND VGND VPWR VPWR u_pe_array.g_pe_row\[2\].g_pe_col\[1\].u_pe.psum_out\[3\]
+ sky130_fd_sc_hd__dfrtp_1
X_4338_ u_pe_array.g_pe_row\[2\].g_pe_col\[3\].u_pe.act_val\[2\] u_pe_array.g_pe_row\[2\].g_pe_col\[3\].u_pe.psum_out\[3\]
+ _1407_ VGND VGND VPWR VPWR _1442_ sky130_fd_sc_hd__and3b_1
XANTENNA__6256__A2 _2992_ VGND VGND VPWR VPWR sky130_fd_sc_hd__diode_2
X_4269_ u_pe_array.g_pe_row\[2\].g_pe_col\[3\].u_pe.act_val\[0\] u_pe_array.g_pe_row\[2\].g_pe_col\[3\].u_pe.psum_out\[0\]
+ _0770_ VGND VGND VPWR VPWR _1390_ sky130_fd_sc_hd__mux2_1
XANTENNA_input2_A h_in0[1] VGND VGND VPWR VPWR sky130_fd_sc_hd__diode_2
X_7057_ clknet_leaf_89_clk net190 net74 VGND VGND VPWR VPWR u_pe_array.g_pe_row\[2\].g_pe_col\[2\].u_pe.move_reg\[9\]
+ sky130_fd_sc_hd__dfrtp_1
X_6008_ u_pe_array.g_pe_row\[0\].g_pe_col\[2\].u_pe.psum_out\[10\] _2840_ _2830_ VGND
+ VGND VPWR VPWR _2841_ sky130_fd_sc_hd__mux2_1
XFILLER_0_69_528 VGND VGND VPWR VPWR sky130_fd_sc_hd__decap_3
XTAP_1204 VGND VPWR sky130_fd_sc_hd__tapvpwrvgnd_1
XTAP_1248 VGND VPWR sky130_fd_sc_hd__tapvpwrvgnd_1
XTAP_1237 VGND VPWR sky130_fd_sc_hd__tapvpwrvgnd_1
XTAP_1226 VGND VPWR sky130_fd_sc_hd__tapvpwrvgnd_1
XTAP_1215 VGND VPWR sky130_fd_sc_hd__tapvpwrvgnd_1
XFILLER_0_77_550 VGND VGND VPWR VPWR sky130_fd_sc_hd__decap_8
XTAP_1259 VGND VPWR sky130_fd_sc_hd__tapvpwrvgnd_1
XFILLER_0_77_594 VGND VGND VPWR VPWR sky130_fd_sc_hd__fill_2
XFILLER_0_9_360 VGND VGND VPWR VPWR sky130_fd_sc_hd__decap_8
XFILLER_0_37_436 VGND VGND VPWR VPWR sky130_fd_sc_hd__fill_2
XFILLER_0_107_313 VPWR VGND VPWR VGND sky130_ef_sc_hd__decap_12
XFILLER_0_64_277 VGND VGND VPWR VPWR sky130_fd_sc_hd__fill_2
XFILLER_0_52_417 VGND VGND VPWR VPWR sky130_fd_sc_hd__decap_3
XFILLER_0_9_393 VGND VGND VPWR VPWR sky130_fd_sc_hd__decap_6
XFILLER_0_9_382 VGND VGND VPWR VPWR sky130_fd_sc_hd__decap_8
XFILLER_0_92_597 VGND VGND VPWR VPWR sky130_fd_sc_hd__decap_4
XFILLER_0_64_288 VGND VGND VPWR VPWR sky130_fd_sc_hd__decap_8
XANTENNA__6957__RESET_B net818 VGND VGND VPWR VPWR sky130_fd_sc_hd__diode_2
XFILLER_0_33_642 VGND VGND VPWR VPWR sky130_fd_sc_hd__fill_2
XANTENNA__3950__B1 _0837_ VGND VGND VPWR VPWR sky130_fd_sc_hd__diode_2
XFILLER_0_103_585 VGND VGND VPWR VPWR sky130_fd_sc_hd__fill_2
XANTENNA__3481__A2 _0745_ VGND VGND VPWR VPWR sky130_fd_sc_hd__diode_2
XFILLER_0_62_27 VGND VGND VPWR VPWR sky130_fd_sc_hd__fill_1
XFILLER_0_55_266 VGND VGND VPWR VPWR sky130_fd_sc_hd__decap_4
XFILLER_0_70_214 VGND VGND VPWR VPWR sky130_fd_sc_hd__fill_2
X_3640_ _0859_ VGND VGND VPWR VPWR _0860_ sky130_fd_sc_hd__inv_2
XFILLER_0_24_631 VGND VGND VPWR VPWR sky130_fd_sc_hd__fill_2
XFILLER_0_113_327 VGND VGND VPWR VPWR sky130_fd_sc_hd__decap_8
X_3571_ _0812_ VGND VGND VPWR VPWR _0002_ sky130_fd_sc_hd__clkbuf_1
XFILLER_0_113_349 VPWR VGND VPWR VGND sky130_ef_sc_hd__decap_12
XFILLER_0_102_99 VGND VGND VPWR VPWR sky130_fd_sc_hd__fill_2
X_6290_ u_pe_array.g_pe_row\[0\].g_pe_col\[0\].u_pe.psum_out\[9\] _2992_ VGND VGND
+ VPWR VPWR _3079_ sky130_fd_sc_hd__nand2_1
X_5310_ _2243_ _2253_ _2254_ VGND VGND VPWR VPWR _2255_ sky130_fd_sc_hd__a21oi_1
XFILLER_0_51_472 VGND VGND VPWR VPWR sky130_fd_sc_hd__fill_1
XFILLER_0_60_9 VGND VGND VPWR VPWR sky130_fd_sc_hd__fill_2
XFILLER_0_23_185 VGND VGND VPWR VPWR sky130_fd_sc_hd__fill_1
X_5241_ _2190_ u_pe_array.g_pe_row\[1\].g_pe_col\[2\].u_pe.act_val\[4\] u_pe_array.g_pe_row\[1\].g_pe_col\[2\].u_pe.w_reg\[0\]
+ _2158_ VGND VGND VPWR VPWR _2192_ sky130_fd_sc_hd__nand4_1
XANTENNA__3605__S _0755_ VGND VGND VPWR VPWR sky130_fd_sc_hd__diode_2
XANTENNA_clkbuf_3_0__f_clk_A clknet_0_clk VGND VGND VPWR VPWR sky130_fd_sc_hd__diode_2
X_5172_ _0757_ _1824_ _0754_ VGND VGND VPWR VPWR _2140_ sky130_fd_sc_hd__mux2_1
X_4123_ net260 _1138_ _1264_ _1004_ VGND VGND VPWR VPWR _0102_ sky130_fd_sc_hd__a22o_1
X_4054_ _1145_ u_pe_array.g_pe_row\[3\].g_pe_col\[1\].u_pe.psum_out\[7\] VGND VGND
+ VPWR VPWR _1211_ sky130_fd_sc_hd__xor2_1
Xinput2 h_in0[1] VGND VGND VPWR VPWR net2 sky130_fd_sc_hd__buf_1
XFILLER_0_36_61 VGND VGND VPWR VPWR sky130_fd_sc_hd__fill_2
XANTENNA__4436__S _0855_ VGND VGND VPWR VPWR sky130_fd_sc_hd__diode_2
XFILLER_0_36_83 VGND VGND VPWR VPWR sky130_fd_sc_hd__fill_1
XFILLER_0_66_509 VGND VGND VPWR VPWR sky130_fd_sc_hd__fill_2
XFILLER_0_59_561 VGND VGND VPWR VPWR sky130_fd_sc_hd__decap_6
X_4956_ _1953_ _1954_ VGND VGND VPWR VPWR _1955_ sky130_fd_sc_hd__xnor2_1
XFILLER_0_74_531 VGND VGND VPWR VPWR sky130_fd_sc_hd__fill_1
XFILLER_0_59_594 VGND VGND VPWR VPWR sky130_fd_sc_hd__fill_2
XFILLER_0_46_211 VGND VGND VPWR VPWR sky130_fd_sc_hd__fill_2
X_4887_ u_pe_array.g_pe_row\[2\].g_pe_col\[0\].u_pe.psum_out\[4\] _1879_ _1880_ VGND
+ VGND VPWR VPWR _1893_ sky130_fd_sc_hd__a21boi_1
XFILLER_0_74_575 VGND VGND VPWR VPWR sky130_fd_sc_hd__decap_8
XFILLER_0_46_277 VGND VGND VPWR VPWR sky130_fd_sc_hd__fill_2
XFILLER_0_46_266 VGND VGND VPWR VPWR sky130_fd_sc_hd__decap_3
XFILLER_0_46_244 VGND VGND VPWR VPWR sky130_fd_sc_hd__fill_2
X_3907_ u_pe_array.g_pe_row\[3\].g_pe_col\[2\].u_pe.psum_out\[8\] _1076_ VGND VGND
+ VPWR VPWR _1091_ sky130_fd_sc_hd__nor2_1
XFILLER_0_74_597 VGND VGND VPWR VPWR sky130_fd_sc_hd__fill_2
XFILLER_0_61_236 VGND VGND VPWR VPWR sky130_fd_sc_hd__fill_1
X_6626_ _3282_ VGND VGND VPWR VPWR _0587_ sky130_fd_sc_hd__clkbuf_1
XFILLER_0_6_341 VGND VGND VPWR VPWR sky130_fd_sc_hd__fill_2
X_3838_ u_pe_array.g_pe_row\[3\].g_pe_col\[2\].u_pe.act_val\[1\] u_pe_array.g_pe_row\[3\].g_pe_col\[2\].u_pe.psum_out\[2\]
+ _1009_ VGND VGND VPWR VPWR _1027_ sky130_fd_sc_hd__and3b_1
XFILLER_0_34_428 VGND VGND VPWR VPWR sky130_fd_sc_hd__fill_2
X_6557_ net252 _1808_ _3239_ VGND VGND VPWR VPWR _3246_ sky130_fd_sc_hd__mux2_1
XFILLER_0_6_363 VGND VGND VPWR VPWR sky130_fd_sc_hd__fill_1
XFILLER_0_14_141 VGND VGND VPWR VPWR sky130_fd_sc_hd__decap_3
XFILLER_0_15_653 VPWR VGND VPWR VGND sky130_ef_sc_hd__decap_12
XFILLER_0_104_349 VGND VGND VPWR VPWR sky130_fd_sc_hd__fill_2
X_5508_ _2418_ _2421_ _2426_ VGND VGND VPWR VPWR _2427_ sky130_fd_sc_hd__and3_1
X_3769_ _0970_ _0972_ _0977_ VGND VGND VPWR VPWR _0978_ sky130_fd_sc_hd__o21ai_1
XFILLER_0_42_472 VGND VGND VPWR VPWR sky130_fd_sc_hd__fill_2
XFILLER_0_30_645 VGND VGND VPWR VPWR sky130_fd_sc_hd__fill_2
X_6488_ net520 _1788_ _3208_ VGND VGND VPWR VPWR _3209_ sky130_fd_sc_hd__mux2_1
XFILLER_0_100_544 VGND VGND VPWR VPWR sky130_fd_sc_hd__fill_2
XFILLER_0_100_533 VGND VGND VPWR VPWR sky130_fd_sc_hd__decap_4
XFILLER_0_100_511 VGND VGND VPWR VPWR sky130_fd_sc_hd__fill_2
X_5439_ u_pe_array.g_pe_row\[1\].g_pe_col\[1\].u_pe.act_val\[2\] VGND VGND VPWR VPWR
+ _2363_ sky130_fd_sc_hd__inv_2
XANTENNA__4200__A _1275_ VGND VGND VPWR VPWR sky130_fd_sc_hd__diode_2
XFILLER_0_10_380 VPWR VGND VPWR VGND sky130_ef_sc_hd__decap_12
XANTENNA__3931__A_N _1009_ VGND VGND VPWR VPWR sky130_fd_sc_hd__diode_2
X_7109_ clknet_leaf_36_clk _0180_ net76 VGND VGND VPWR VPWR u_pe_array.g_pe_row\[2\].g_pe_col\[0\].u_pe.act_val\[1\]
+ sky130_fd_sc_hd__dfrtp_1
XANTENNA__6826__S _3382_ VGND VGND VPWR VPWR sky130_fd_sc_hd__diode_2
XANTENNA__5730__S _2469_ VGND VGND VPWR VPWR sky130_fd_sc_hd__diode_2
XFILLER_0_97_656 VPWR VGND VPWR VGND sky130_ef_sc_hd__decap_12
XTAP_1012 VGND VPWR sky130_fd_sc_hd__tapvpwrvgnd_1
XTAP_1001 VGND VPWR sky130_fd_sc_hd__tapvpwrvgnd_1
XANTENNA__7156__RESET_B net814 VGND VGND VPWR VPWR sky130_fd_sc_hd__diode_2
XFILLER_0_96_188 VGND VGND VPWR VPWR sky130_fd_sc_hd__fill_2
XFILLER_0_84_328 VGND VGND VPWR VPWR sky130_fd_sc_hd__fill_2
XTAP_1045 VGND VPWR sky130_fd_sc_hd__tapvpwrvgnd_1
XTAP_1056 VGND VPWR sky130_fd_sc_hd__tapvpwrvgnd_1
XTAP_1034 VGND VPWR sky130_fd_sc_hd__tapvpwrvgnd_1
XTAP_1023 VGND VPWR sky130_fd_sc_hd__tapvpwrvgnd_1
XANTENNA__6561__S _3239_ VGND VGND VPWR VPWR sky130_fd_sc_hd__diode_2
XANTENNA__5685__B _2478_ VGND VGND VPWR VPWR sky130_fd_sc_hd__diode_2
XTAP_1089 VGND VPWR sky130_fd_sc_hd__tapvpwrvgnd_1
XTAP_1078 VGND VPWR sky130_fd_sc_hd__tapvpwrvgnd_1
XTAP_1067 VGND VPWR sky130_fd_sc_hd__tapvpwrvgnd_1
XFILLER_0_107_143 VGND VGND VPWR VPWR sky130_fd_sc_hd__fill_2
XFILLER_0_107_132 VGND VGND VPWR VPWR sky130_fd_sc_hd__fill_2
XFILLER_0_80_545 VGND VGND VPWR VPWR sky130_fd_sc_hd__fill_2
XFILLER_0_80_589 VGND VGND VPWR VPWR sky130_fd_sc_hd__fill_2
XFILLER_0_21_623 VGND VGND VPWR VPWR sky130_fd_sc_hd__decap_3
XFILLER_0_0_517 VPWR VGND VPWR VGND sky130_ef_sc_hd__decap_12
XFILLER_0_20_133 VGND VGND VPWR VPWR sky130_fd_sc_hd__fill_1
XTAP_807 VGND VPWR sky130_fd_sc_hd__tapvpwrvgnd_1
XFILLER_0_0_539 VPWR VGND VPWR VGND sky130_ef_sc_hd__decap_12
XFILLER_0_57_27 VPWR VGND VPWR VGND sky130_ef_sc_hd__decap_12
XTAP_829 VGND VPWR sky130_fd_sc_hd__tapvpwrvgnd_1
XTAP_818 VGND VPWR sky130_fd_sc_hd__tapvpwrvgnd_1
XFILLER_0_73_15 VPWR VGND VPWR VGND sky130_ef_sc_hd__decap_12
XFILLER_0_88_645 VGND VGND VPWR VPWR sky130_fd_sc_hd__fill_2
XFILLER_0_87_144 VGND VGND VPWR VPWR sky130_fd_sc_hd__decap_4
X_4810_ _1830_ net4 _0754_ VGND VGND VPWR VPWR _1831_ sky130_fd_sc_hd__mux2_1
X_5790_ u_pe_array.g_pe_row\[0\].g_pe_col\[3\].u_pe.psum_out\[5\] _2655_ VGND VGND
+ VPWR VPWR _2656_ sky130_fd_sc_hd__xnor2_1
XTAP_1590 VGND VPWR sky130_fd_sc_hd__tapvpwrvgnd_1
XFILLER_0_90_309 VGND VGND VPWR VPWR sky130_fd_sc_hd__decap_4
X_4741_ _1772_ _1775_ _1780_ VGND VGND VPWR VPWR _1782_ sky130_fd_sc_hd__or3_1
XFILLER_0_56_553 VPWR VGND VPWR VGND sky130_ef_sc_hd__decap_12
X_4672_ u_pe_array.g_pe_row\[2\].g_pe_col\[1\].u_pe.psum_out\[4\] _1704_ _1705_ VGND
+ VGND VPWR VPWR _1719_ sky130_fd_sc_hd__a21boi_1
X_7460_ clknet_leaf_5_clk _0509_ VGND VGND VPWR VPWR u_pe_array.u_fifo2.buffer\[1\]\[12\]
+ sky130_fd_sc_hd__dfxtp_1
XFILLER_0_7_149 VPWR VGND VPWR VGND sky130_ef_sc_hd__decap_12
XFILLER_0_22_74 VGND VGND VPWR VPWR sky130_fd_sc_hd__decap_4
XFILLER_0_113_113 VGND VGND VPWR VPWR sky130_fd_sc_hd__fill_2
XFILLER_0_71_556 VGND VGND VPWR VPWR sky130_fd_sc_hd__fill_2
XFILLER_0_43_236 VGND VGND VPWR VPWR sky130_fd_sc_hd__fill_2
X_3623_ u_pe_array.g_pe_row\[2\].g_pe_col\[2\].u_pe.move_reg\[6\] u_pe_array.g_pe_row\[2\].g_pe_col\[2\].u_pe.psum_out\[6\]
+ _0755_ VGND VGND VPWR VPWR _0850_ sky130_fd_sc_hd__mux2_1
X_6411_ net428 _1800_ _3166_ VGND VGND VPWR VPWR _3169_ sky130_fd_sc_hd__mux2_1
XFILLER_0_113_124 VGND VGND VPWR VPWR sky130_fd_sc_hd__decap_3
X_7391_ clknet_leaf_83_clk u_fsm.psum_shift_en net818 VGND VGND VPWR VPWR u_pe_array.g_pe_row\[0\].g_pe_col\[0\].u_pe.psum_shift_en_d
+ sky130_fd_sc_hd__dfrtp_1
XFILLER_0_3_333 VGND VGND VPWR VPWR sky130_fd_sc_hd__fill_1
XANTENNA__4939__B _1847_ VGND VGND VPWR VPWR sky130_fd_sc_hd__diode_2
X_6342_ _3121_ VGND VGND VPWR VPWR _0464_ sky130_fd_sc_hd__clkbuf_1
X_3554_ _0790_ _0793_ _0799_ VGND VGND VPWR VPWR _0800_ sky130_fd_sc_hd__or3_1
XFILLER_0_11_111 VGND VGND VPWR VPWR sky130_fd_sc_hd__fill_1
XFILLER_0_3_388 VGND VGND VPWR VPWR sky130_fd_sc_hd__fill_2
XFILLER_0_12_634 VGND VGND VPWR VPWR sky130_fd_sc_hd__decap_8
XFILLER_0_12_645 VPWR VGND VPWR VGND sky130_ef_sc_hd__decap_12
X_6273_ _3057_ _3063_ VGND VGND VPWR VPWR _3064_ sky130_fd_sc_hd__nand2_1
X_3485_ u_pe_array.g_pe_row\[3\].g_pe_col\[0\].u_pe.psum_out\[9\] _0745_ _0750_ _0728_
+ VGND VGND VPWR VPWR net61 sky130_fd_sc_hd__o211a_1
XFILLER_0_11_155 VGND VGND VPWR VPWR sky130_fd_sc_hd__fill_2
XFILLER_0_11_133 VGND VGND VPWR VPWR sky130_fd_sc_hd__decap_3
X_5224_ _2165_ _2171_ _2175_ VGND VGND VPWR VPWR _2176_ sky130_fd_sc_hd__a21o_1
XANTENNA__5116__A _0914_ VGND VGND VPWR VPWR sky130_fd_sc_hd__diode_2
X_5155_ u_pe_array.g_pe_row\[1\].g_pe_col\[3\].u_pe.psum_out\[11\] _2029_ VGND VGND
+ VPWR VPWR _2127_ sky130_fd_sc_hd__and2b_1
XFILLER_0_37_3 VGND VGND VPWR VPWR sky130_fd_sc_hd__decap_3
X_4106_ _1255_ VGND VGND VPWR VPWR _0094_ sky130_fd_sc_hd__clkbuf_1
X_5086_ u_pe_array.g_pe_row\[1\].g_pe_col\[3\].u_pe.w_reg\[0\] u_pe_array.g_pe_row\[1\].g_pe_col\[3\].u_pe.act_val\[3\]
+ _2051_ _2064_ VGND VGND VPWR VPWR _2065_ sky130_fd_sc_hd__a31o_1
X_4037_ _1183_ _1185_ _1195_ VGND VGND VPWR VPWR _1196_ sky130_fd_sc_hd__o21ai_1
XANTENNA__4642__A1 _1672_ VGND VGND VPWR VPWR sky130_fd_sc_hd__diode_2
XPHY_106 VGND VGND VPWR VPWR sky130_fd_sc_hd__decap_3
XPHY_139 VGND VGND VPWR VPWR sky130_fd_sc_hd__decap_3
XPHY_128 VGND VGND VPWR VPWR sky130_fd_sc_hd__decap_3
XANTENNA__5198__A2 _2144_ VGND VGND VPWR VPWR sky130_fd_sc_hd__diode_2
XFILLER_0_59_391 VGND VGND VPWR VPWR sky130_fd_sc_hd__fill_1
XPHY_117 VGND VGND VPWR VPWR sky130_fd_sc_hd__decap_3
X_5988_ u_pe_array.g_pe_row\[0\].g_pe_col\[2\].u_pe.psum_out\[8\] _2743_ VGND VGND
+ VPWR VPWR _2823_ sky130_fd_sc_hd__or2_1
XFILLER_0_19_211 VGND VGND VPWR VPWR sky130_fd_sc_hd__decap_3
X_4939_ u_pe_array.g_pe_row\[2\].g_pe_col\[0\].u_pe.psum_out\[10\] _1847_ VGND VGND
+ VPWR VPWR _1940_ sky130_fd_sc_hd__or2_1
XFILLER_0_74_350 VGND VGND VPWR VPWR sky130_fd_sc_hd__fill_1
X_7658_ clknet_leaf_20_clk _0707_ VGND VGND VPWR VPWR u_pe_array.u_fifo1.buffer\[7\]\[3\]
+ sky130_fd_sc_hd__dfxtp_1
XFILLER_0_74_383 VGND VGND VPWR VPWR sky130_fd_sc_hd__fill_2
XFILLER_0_62_523 VGND VGND VPWR VPWR sky130_fd_sc_hd__fill_2
X_6609_ net481 _1804_ _3269_ VGND VGND VPWR VPWR _3274_ sky130_fd_sc_hd__mux2_1
XFILLER_0_34_247 VGND VGND VPWR VPWR sky130_fd_sc_hd__decap_3
X_7589_ clknet_leaf_27_clk _0638_ VGND VGND VPWR VPWR u_pe_array.u_fifo1.buffer\[1\]\[12\]
+ sky130_fd_sc_hd__dfxtp_1
XANTENNA__7337__RESET_B net812 VGND VGND VPWR VPWR sky130_fd_sc_hd__diode_2
XFILLER_0_97_442 VGND VGND VPWR VPWR sky130_fd_sc_hd__decap_4
XFILLER_0_69_122 VGND VGND VPWR VPWR sky130_fd_sc_hd__fill_1
XFILLER_0_43_29 VGND VGND VPWR VPWR sky130_fd_sc_hd__fill_1
XPHY_8 VGND VGND VPWR VPWR sky130_fd_sc_hd__decap_3
XFILLER_0_97_497 VGND VGND VPWR VPWR sky130_fd_sc_hd__fill_2
XFILLER_0_85_648 VGND VGND VPWR VPWR sky130_fd_sc_hd__fill_2
XANTENNA__4804__S _0754_ VGND VGND VPWR VPWR sky130_fd_sc_hd__diode_2
XANTENNA__4397__B1 _1407_ VGND VGND VPWR VPWR sky130_fd_sc_hd__diode_2
XANTENNA__6972__RESET_B net815 VGND VGND VPWR VPWR sky130_fd_sc_hd__diode_2
XFILLER_0_65_383 VGND VGND VPWR VPWR sky130_fd_sc_hd__decap_6
XFILLER_0_65_361 VGND VGND VPWR VPWR sky130_fd_sc_hd__decap_8
XFILLER_0_53_512 VGND VGND VPWR VPWR sky130_fd_sc_hd__decap_8
XFILLER_0_5_609 VGND VGND VPWR VPWR sky130_fd_sc_hd__decap_6
XFILLER_0_25_225 VGND VGND VPWR VPWR sky130_fd_sc_hd__decap_3
XFILLER_0_80_342 VGND VGND VPWR VPWR sky130_fd_sc_hd__fill_1
XFILLER_0_13_409 VPWR VGND VPWR VGND sky130_ef_sc_hd__decap_12
XFILLER_0_111_617 VPWR VGND VPWR VGND sky130_ef_sc_hd__decap_12
XFILLER_0_110_105 VGND VGND VPWR VPWR sky130_fd_sc_hd__fill_1
XFILLER_0_68_15 VPWR VGND VPWR VGND sky130_ef_sc_hd__decap_12
XANTENNA__6320__A _0788_ VGND VGND VPWR VPWR sky130_fd_sc_hd__diode_2
XANTENNA__5649__B1 _2174_ VGND VGND VPWR VPWR sky130_fd_sc_hd__diode_2
XFILLER_0_21_475 VGND VGND VPWR VPWR sky130_fd_sc_hd__fill_2
XFILLER_0_21_486 VGND VGND VPWR VPWR sky130_fd_sc_hd__fill_2
XTAP_604 VGND VPWR sky130_fd_sc_hd__tapvpwrvgnd_1
XTAP_615 VGND VPWR sky130_fd_sc_hd__tapvpwrvgnd_1
XTAP_626 VGND VPWR sky130_fd_sc_hd__tapvpwrvgnd_1
XTAP_637 VGND VPWR sky130_fd_sc_hd__tapvpwrvgnd_1
XTAP_659 VGND VPWR sky130_fd_sc_hd__tapvpwrvgnd_1
XTAP_648 VGND VPWR sky130_fd_sc_hd__tapvpwrvgnd_1
XANTENNA__7078__RESET_B net816 VGND VGND VPWR VPWR sky130_fd_sc_hd__diode_2
X_6960_ clknet_leaf_17_clk _0041_ net816 VGND VGND VPWR VPWR u_pe_array.g_pe_row\[3\].g_pe_col\[1\].u_pe.act_val\[2\]
+ sky130_fd_sc_hd__dfrtp_2
XANTENNA__7007__RESET_B net816 VGND VGND VPWR VPWR sky130_fd_sc_hd__diode_2
XFILLER_0_88_453 VGND VGND VPWR VPWR sky130_fd_sc_hd__fill_2
X_5911_ u_pe_array.g_pe_row\[0\].g_pe_col\[2\].u_pe.psum_out\[2\] _2751_ VGND VGND
+ VPWR VPWR _2752_ sky130_fd_sc_hd__xnor2_1
X_6891_ _3429_ VGND VGND VPWR VPWR _0705_ sky130_fd_sc_hd__clkbuf_1
XFILLER_0_88_475 VGND VGND VPWR VPWR sky130_fd_sc_hd__fill_1
X_5842_ _2698_ VGND VGND VPWR VPWR _2703_ sky130_fd_sc_hd__inv_2
XFILLER_0_75_158 VGND VGND VPWR VPWR sky130_fd_sc_hd__decap_4
XANTENNA__4388__B1 net72 VGND VGND VPWR VPWR sky130_fd_sc_hd__diode_2
XFILLER_0_29_553 VGND VGND VPWR VPWR sky130_fd_sc_hd__fill_1
X_5773_ net663 _2387_ _2174_ _2640_ VGND VGND VPWR VPWR _0376_ sky130_fd_sc_hd__a22o_1
X_4724_ _1761_ VGND VGND VPWR VPWR _1766_ sky130_fd_sc_hd__inv_2
X_7512_ clknet_leaf_5_clk _0561_ VGND VGND VPWR VPWR u_pe_array.u_fifo2.buffer\[5\]\[12\]
+ sky130_fd_sc_hd__dfxtp_1
XFILLER_0_16_247 VGND VGND VPWR VPWR sky130_fd_sc_hd__fill_1
XANTENNA__5750__B1_N _2611_ VGND VGND VPWR VPWR sky130_fd_sc_hd__diode_2
XANTENNA__5545__S _0828_ VGND VGND VPWR VPWR sky130_fd_sc_hd__diode_2
X_4655_ u_pe_array.g_pe_row\[2\].g_pe_col\[1\].u_pe.act_val\[3\] VGND VGND VPWR VPWR
+ _1703_ sky130_fd_sc_hd__inv_2
X_7443_ clknet_leaf_2_clk _0492_ VGND VGND VPWR VPWR u_pe_array.u_fifo2.buffer\[0\]\[8\]
+ sky130_fd_sc_hd__dfxtp_1
XFILLER_0_114_477 VPWR VGND VPWR VGND sky130_ef_sc_hd__decap_12
X_7374_ clknet_leaf_43_clk net108 net812 VGND VGND VPWR VPWR u_pe_array.g_pe_row\[0\].g_pe_col\[1\].u_pe.w_reg\[0\]
+ sky130_fd_sc_hd__dfrtp_4
X_4586_ u_pe_array.g_pe_row\[2\].g_pe_col\[1\].u_pe.act_val\[0\] u_pe_array.g_pe_row\[2\].g_pe_col\[1\].u_pe.psum_out\[0\]
+ _0770_ VGND VGND VPWR VPWR _1651_ sky130_fd_sc_hd__mux2_1
X_3606_ net21 _0838_ _0819_ VGND VGND VPWR VPWR _0839_ sky130_fd_sc_hd__mux2_1
X_6325_ _3109_ VGND VGND VPWR VPWR _3110_ sky130_fd_sc_hd__buf_4
X_3537_ _0717_ _0781_ _0782_ _0783_ VGND VGND VPWR VPWR _0784_ sky130_fd_sc_hd__o31ai_1
X_6256_ _3046_ _2992_ u_pe_array.g_pe_row\[0\].g_pe_col\[0\].u_pe.psum_out\[6\] VGND
+ VGND VPWR VPWR _3048_ sky130_fd_sc_hd__a21o_1
X_3468_ _0728_ _0739_ VGND VGND VPWR VPWR _0740_ sky130_fd_sc_hd__and2_1
X_6187_ _2987_ VGND VGND VPWR VPWR _0443_ sky130_fd_sc_hd__clkbuf_1
X_5207_ _2156_ _2160_ VGND VGND VPWR VPWR _2161_ sky130_fd_sc_hd__xnor2_1
XANTENNA__7430__RESET_B net74 VGND VGND VPWR VPWR sky130_fd_sc_hd__diode_2
X_5138_ _2029_ u_pe_array.g_pe_row\[1\].g_pe_col\[3\].u_pe.psum_out\[9\] VGND VGND
+ VPWR VPWR _2112_ sky130_fd_sc_hd__and2_1
XANTENNA__6065__B1 _2571_ VGND VGND VPWR VPWR sky130_fd_sc_hd__diode_2
XFILLER_0_79_420 VGND VGND VPWR VPWR sky130_fd_sc_hd__fill_2
XANTENNA__4615__B2 _1665_ VGND VGND VPWR VPWR sky130_fd_sc_hd__diode_2
X_5069_ u_pe_array.g_pe_row\[1\].g_pe_col\[3\].u_pe.w_reg\[0\] u_pe_array.g_pe_row\[1\].g_pe_col\[3\].u_pe.act_val\[3\]
+ VGND VGND VPWR VPWR _2049_ sky130_fd_sc_hd__nand2_1
XANTENNA__5812__B1 _2571_ VGND VGND VPWR VPWR sky130_fd_sc_hd__diode_2
XFILLER_0_94_412 VGND VGND VPWR VPWR sky130_fd_sc_hd__fill_2
XFILLER_0_79_464 VGND VGND VPWR VPWR sky130_fd_sc_hd__fill_2
XFILLER_0_66_136 VGND VGND VPWR VPWR sky130_fd_sc_hd__decap_4
XFILLER_0_109_216 VGND VGND VPWR VPWR sky130_fd_sc_hd__fill_2
XFILLER_0_66_147 VGND VGND VPWR VPWR sky130_fd_sc_hd__fill_1
XFILLER_0_54_309 VGND VGND VPWR VPWR sky130_fd_sc_hd__decap_4
XANTENNA__3748__B _0869_ VGND VGND VPWR VPWR sky130_fd_sc_hd__diode_2
XFILLER_0_94_489 VGND VGND VPWR VPWR sky130_fd_sc_hd__fill_2
XFILLER_0_75_670 VGND VGND VPWR VPWR sky130_fd_sc_hd__fill_2
XFILLER_0_47_361 VGND VGND VPWR VPWR sky130_fd_sc_hd__fill_2
XFILLER_0_105_433 VPWR VGND VPWR VGND sky130_ef_sc_hd__decap_12
XANTENNA__5963__B _2743_ VGND VGND VPWR VPWR sky130_fd_sc_hd__diode_2
XFILLER_0_105_455 VGND VGND VPWR VPWR sky130_fd_sc_hd__fill_2
XANTENNA__5879__B1 _2592_ VGND VGND VPWR VPWR sky130_fd_sc_hd__diode_2
XFILLER_0_100_160 VGND VGND VPWR VPWR sky130_fd_sc_hd__fill_1
XFILLER_0_100_193 VGND VGND VPWR VPWR sky130_fd_sc_hd__decap_3
XANTENNA__7171__RESET_B net813 VGND VGND VPWR VPWR sky130_fd_sc_hd__diode_2
XANTENNA__7100__RESET_B net819 VGND VGND VPWR VPWR sky130_fd_sc_hd__diode_2
XFILLER_0_85_401 VGND VGND VPWR VPWR sky130_fd_sc_hd__fill_2
XFILLER_0_97_294 VGND VGND VPWR VPWR sky130_fd_sc_hd__fill_2
XFILLER_0_85_445 VGND VGND VPWR VPWR sky130_fd_sc_hd__decap_3
XFILLER_0_85_423 VGND VGND VPWR VPWR sky130_fd_sc_hd__fill_2
XFILLER_0_58_637 VGND VGND VPWR VPWR sky130_fd_sc_hd__decap_4
XFILLER_0_70_27 VGND VGND VPWR VPWR sky130_fd_sc_hd__fill_1
XFILLER_0_73_629 VGND VGND VPWR VPWR sky130_fd_sc_hd__fill_2
XANTENNA__5031__B2 _1665_ VGND VGND VPWR VPWR sky130_fd_sc_hd__diode_2
XFILLER_0_38_372 VGND VGND VPWR VPWR sky130_fd_sc_hd__decap_3
XFILLER_0_81_651 VGND VGND VPWR VPWR sky130_fd_sc_hd__decap_3
XFILLER_0_5_406 VGND VGND VPWR VPWR sky130_fd_sc_hd__fill_2
XFILLER_0_108_282 VPWR VGND VPWR VGND sky130_ef_sc_hd__decap_12
XFILLER_0_81_673 VGND VGND VPWR VPWR sky130_fd_sc_hd__fill_2
XFILLER_0_26_578 VGND VGND VPWR VPWR sky130_fd_sc_hd__fill_1
XFILLER_0_80_183 VGND VGND VPWR VPWR sky130_fd_sc_hd__fill_2
X_4440_ net153 _1524_ _1525_ _1399_ VGND VGND VPWR VPWR _0158_ sky130_fd_sc_hd__a22o_1
XFILLER_0_53_397 VGND VGND VPWR VPWR sky130_fd_sc_hd__decap_3
XANTENNA__6531__A1 _1810_ VGND VGND VPWR VPWR sky130_fd_sc_hd__diode_2
Xhold107 u_pe_array.g_pe_row\[3\].g_pe_col\[2\].u_pe.move_reg\[12\] VGND VGND VPWR
+ VPWR net183 sky130_fd_sc_hd__dlygate4sd3_1
Xhold129 u_pe_array.u_fifo1.buffer\[5\]\[7\] VGND VGND VPWR VPWR net205 sky130_fd_sc_hd__dlygate4sd3_1
Xhold118 _0161_ VGND VGND VPWR VPWR net194 sky130_fd_sc_hd__dlygate4sd3_1
X_6110_ _2918_ _2919_ VGND VGND VPWR VPWR _2920_ sky130_fd_sc_hd__nor2_1
XANTENNA__7259__RESET_B net75 VGND VGND VPWR VPWR sky130_fd_sc_hd__diode_2
X_4371_ _1407_ u_pe_array.g_pe_row\[2\].g_pe_col\[3\].u_pe.psum_out\[7\] VGND VGND
+ VPWR VPWR _1472_ sky130_fd_sc_hd__xor2_1
XFILLER_0_21_250 VGND VGND VPWR VPWR sky130_fd_sc_hd__decap_4
X_7090_ clknet_leaf_37_clk _0163_ net816 VGND VGND VPWR VPWR u_pe_array.g_pe_row\[2\].g_pe_col\[1\].u_pe.move_reg\[12\]
+ sky130_fd_sc_hd__dfrtp_1
XTAP_412 VGND VPWR sky130_fd_sc_hd__tapvpwrvgnd_1
XTAP_401 VGND VPWR sky130_fd_sc_hd__tapvpwrvgnd_1
XTAP_423 VGND VPWR sky130_fd_sc_hd__tapvpwrvgnd_1
X_6041_ net171 _2738_ _2862_ _0722_ VGND VGND VPWR VPWR _0422_ sky130_fd_sc_hd__a22o_1
XANTENNA_hold29_A u_pe_array.g_pe_row\[0\].g_pe_col\[3\].u_pe.w_buffer\[0\] VGND VGND
+ VPWR VPWR sky130_fd_sc_hd__diode_2
XTAP_434 VGND VPWR sky130_fd_sc_hd__tapvpwrvgnd_1
XTAP_445 VGND VPWR sky130_fd_sc_hd__tapvpwrvgnd_1
XTAP_456 VGND VPWR sky130_fd_sc_hd__tapvpwrvgnd_1
XTAP_467 VGND VPWR sky130_fd_sc_hd__tapvpwrvgnd_1
XTAP_489 VGND VPWR sky130_fd_sc_hd__tapvpwrvgnd_1
XTAP_478 VGND VPWR sky130_fd_sc_hd__tapvpwrvgnd_1
XFILLER_0_95_209 VGND VGND VPWR VPWR sky130_fd_sc_hd__fill_1
X_6943_ clknet_leaf_89_clk _0024_ net74 VGND VGND VPWR VPWR u_pe_array.g_pe_row\[3\].g_pe_col\[3\].u_pe.psum_out\[0\]
+ sky130_fd_sc_hd__dfrtp_1
X_6874_ net272 _3124_ _3412_ VGND VGND VPWR VPWR _3420_ sky130_fd_sc_hd__mux2_1
XFILLER_0_88_272 VGND VGND VPWR VPWR sky130_fd_sc_hd__fill_2
XFILLER_0_48_125 VGND VGND VPWR VPWR sky130_fd_sc_hd__fill_2
XFILLER_0_76_456 VGND VGND VPWR VPWR sky130_fd_sc_hd__decap_6
X_5825_ _2611_ u_pe_array.g_pe_row\[0\].g_pe_col\[3\].u_pe.psum_out\[8\] VGND VGND
+ VPWR VPWR _2688_ sky130_fd_sc_hd__or2_1
XFILLER_0_17_523 VGND VGND VPWR VPWR sky130_fd_sc_hd__decap_3
XANTENNA__6770__A1 _3132_ VGND VGND VPWR VPWR sky130_fd_sc_hd__diode_2
XFILLER_0_72_640 VGND VGND VPWR VPWR sky130_fd_sc_hd__fill_2
X_5756_ _2618_ _2624_ VGND VGND VPWR VPWR _2625_ sky130_fd_sc_hd__nand2_1
X_5687_ _2574_ _2575_ VGND VGND VPWR VPWR _2576_ sky130_fd_sc_hd__and2_1
X_4707_ _1672_ u_pe_array.g_pe_row\[2\].g_pe_col\[1\].u_pe.psum_out\[8\] VGND VGND
+ VPWR VPWR _1751_ sky130_fd_sc_hd__or2_1
XANTENNA__3584__A1 _0819_ VGND VGND VPWR VPWR sky130_fd_sc_hd__diode_2
XFILLER_0_17_589 VGND VGND VPWR VPWR sky130_fd_sc_hd__fill_1
X_4638_ net697 _1152_ _1686_ _1687_ VGND VGND VPWR VPWR _0194_ sky130_fd_sc_hd__a22o_1
X_7426_ clknet_leaf_6_clk _0475_ net816 VGND VGND VPWR VPWR u_pe_array.u_fifo2.wr_ptr\[3\]
+ sky130_fd_sc_hd__dfrtp_1
XFILLER_0_102_436 VGND VGND VPWR VPWR sky130_fd_sc_hd__fill_2
Xhold630 u_pe_array.g_pe_row\[1\].g_pe_col\[2\].u_pe.psum_out\[4\] VGND VGND VPWR
+ VPWR net706 sky130_fd_sc_hd__dlygate4sd3_1
XANTENNA__4533__B1 _1534_ VGND VGND VPWR VPWR sky130_fd_sc_hd__diode_2
Xhold641 u_pe_array.g_pe_row\[2\].g_pe_col\[0\].u_pe.psum_out\[2\] VGND VGND VPWR
+ VPWR net717 sky130_fd_sc_hd__dlygate4sd3_1
XFILLER_0_102_458 VGND VGND VPWR VPWR sky130_fd_sc_hd__decap_4
XFILLER_0_102_447 VGND VGND VPWR VPWR sky130_fd_sc_hd__fill_2
Xhold663 u_pe_array.g_pe_row\[3\].g_pe_col\[0\].u_pe.psum_out\[8\] VGND VGND VPWR
+ VPWR net739 sky130_fd_sc_hd__dlygate4sd3_1
X_7357_ clknet_leaf_65_clk _0412_ net818 VGND VGND VPWR VPWR u_pe_array.g_pe_row\[0\].g_pe_col\[2\].u_pe.psum_out\[11\]
+ sky130_fd_sc_hd__dfrtp_1
XFILLER_0_12_272 VGND VGND VPWR VPWR sky130_fd_sc_hd__fill_2
Xhold652 u_pe_array.g_pe_row\[2\].g_pe_col\[2\].u_pe.act_val\[1\] VGND VGND VPWR VPWR
+ net728 sky130_fd_sc_hd__dlygate4sd3_1
X_4569_ u_pe_array.g_pe_row\[2\].g_pe_col\[2\].u_pe.psum_out\[11\] _1536_ VGND VGND
+ VPWR VPWR _1638_ sky130_fd_sc_hd__and2b_1
XANTENNA__3887__A2 _0875_ VGND VGND VPWR VPWR sky130_fd_sc_hd__diode_2
Xhold696 u_pe_array.g_pe_row\[0\].g_pe_col\[0\].u_pe.psum_out\[5\] VGND VGND VPWR
+ VPWR net772 sky130_fd_sc_hd__dlygate4sd3_1
Xhold685 u_pe_array.g_pe_row\[0\].g_pe_col\[1\].u_pe.psum_out\[5\] VGND VGND VPWR
+ VPWR net761 sky130_fd_sc_hd__dlygate4sd3_1
Xhold674 u_pe_array.g_pe_row\[0\].g_pe_col\[0\].u_pe.psum_out\[10\] VGND VGND VPWR
+ VPWR net750 sky130_fd_sc_hd__dlygate4sd3_1
X_6308_ _2992_ u_pe_array.g_pe_row\[0\].g_pe_col\[0\].u_pe.psum_out\[11\] VGND VGND
+ VPWR VPWR _3095_ sky130_fd_sc_hd__and2b_1
X_7288_ clknet_leaf_56_clk _0347_ net813 VGND VGND VPWR VPWR u_pe_array.g_pe_row\[1\].g_pe_col\[0\].u_pe.psum_out\[2\]
+ sky130_fd_sc_hd__dfrtp_1
X_6239_ _3009_ _3019_ _3018_ VGND VGND VPWR VPWR _3033_ sky130_fd_sc_hd__a21o_1
XTAP_990 VGND VPWR sky130_fd_sc_hd__tapvpwrvgnd_1
XANTENNA__6834__S _3397_ VGND VGND VPWR VPWR sky130_fd_sc_hd__diode_2
XANTENNA__6589__A1 _1812_ VGND VGND VPWR VPWR sky130_fd_sc_hd__diode_2
XFILLER_0_79_250 VGND VGND VPWR VPWR sky130_fd_sc_hd__decap_4
XANTENNA__5677__C _2478_ VGND VGND VPWR VPWR sky130_fd_sc_hd__diode_2
XFILLER_0_94_253 VGND VGND VPWR VPWR sky130_fd_sc_hd__fill_1
XFILLER_0_54_106 VGND VGND VPWR VPWR sky130_fd_sc_hd__decap_6
XFILLER_0_94_297 VGND VGND VPWR VPWR sky130_fd_sc_hd__fill_2
XFILLER_0_40_19 VGND VGND VPWR VPWR sky130_fd_sc_hd__fill_1
XANTENNA__5693__B _2478_ VGND VGND VPWR VPWR sky130_fd_sc_hd__diode_2
XFILLER_0_63_673 VGND VGND VPWR VPWR sky130_fd_sc_hd__fill_2
Xload_slew8 net74 VGND VGND VPWR VPWR net819 sky130_fd_sc_hd__buf_12
XFILLER_0_90_481 VGND VGND VPWR VPWR sky130_fd_sc_hd__fill_2
XANTENNA__5185__S _1661_ VGND VGND VPWR VPWR sky130_fd_sc_hd__diode_2
XANTENNA__3494__A _0755_ VGND VGND VPWR VPWR sky130_fd_sc_hd__diode_2
XFILLER_0_23_537 VGND VGND VPWR VPWR sky130_fd_sc_hd__fill_2
XANTENNA__7352__RESET_B net818 VGND VGND VPWR VPWR sky130_fd_sc_hd__diode_2
XFILLER_0_10_209 VGND VGND VPWR VPWR sky130_fd_sc_hd__fill_2
XFILLER_0_65_27 VPWR VGND VPWR VGND sky130_ef_sc_hd__decap_12
XANTENNA_max_cap72_A _0913_ VGND VGND VPWR VPWR sky130_fd_sc_hd__diode_2
XANTENNA__6029__B1 _2592_ VGND VGND VPWR VPWR sky130_fd_sc_hd__diode_2
XFILLER_0_81_15 VGND VGND VPWR VPWR sky130_fd_sc_hd__decap_4
XFILLER_0_85_220 VGND VGND VPWR VPWR sky130_fd_sc_hd__fill_2
X_3940_ net429 _0875_ _0887_ _1119_ VGND VGND VPWR VPWR _0064_ sky130_fd_sc_hd__a22o_1
XFILLER_0_105_55 VGND VGND VPWR VPWR sky130_fd_sc_hd__fill_1
XANTENNA_clkbuf_leaf_50_clk_A clknet_3_7__leaf_clk VGND VGND VPWR VPWR sky130_fd_sc_hd__diode_2
XFILLER_0_46_629 VGND VGND VPWR VPWR sky130_fd_sc_hd__fill_2
XFILLER_0_18_309 VGND VGND VPWR VPWR sky130_fd_sc_hd__decap_3
XFILLER_0_39_670 VGND VGND VPWR VPWR sky130_fd_sc_hd__fill_2
X_3871_ _1042_ _1043_ _1056_ VGND VGND VPWR VPWR _1058_ sky130_fd_sc_hd__nor3_1
X_5610_ _2505_ VGND VGND VPWR VPWR _2506_ sky130_fd_sc_hd__inv_2
X_6590_ _3263_ VGND VGND VPWR VPWR _0570_ sky130_fd_sc_hd__clkbuf_1
XANTENNA__5555__A2 _2463_ VGND VGND VPWR VPWR sky130_fd_sc_hd__diode_2
X_5541_ _2447_ _2452_ _2455_ _2450_ VGND VGND VPWR VPWR _2456_ sky130_fd_sc_hd__a22oi_1
XFILLER_0_26_353 VGND VGND VPWR VPWR sky130_fd_sc_hd__fill_1
XANTENNA__4763__B1 _0990_ VGND VGND VPWR VPWR sky130_fd_sc_hd__diode_2
XANTENNA_clkbuf_leaf_65_clk_A clknet_3_5__leaf_clk VGND VGND VPWR VPWR sky130_fd_sc_hd__diode_2
XANTENNA__3608__S _0734_ VGND VGND VPWR VPWR sky130_fd_sc_hd__diode_2
XFILLER_0_41_323 VGND VGND VPWR VPWR sky130_fd_sc_hd__fill_2
X_5472_ _2391_ _2392_ VGND VGND VPWR VPWR _2394_ sky130_fd_sc_hd__nand2_1
X_7211_ clknet_leaf_54_clk _0276_ net75 VGND VGND VPWR VPWR u_pe_array.g_pe_row\[1\].g_pe_col\[1\].u_pe.act_val\[0\]
+ sky130_fd_sc_hd__dfrtp_1
XANTENNA__6504__A1 _1812_ VGND VGND VPWR VPWR sky130_fd_sc_hd__diode_2
XFILLER_0_14_559 VGND VGND VPWR VPWR sky130_fd_sc_hd__decap_3
XFILLER_0_69_6 VGND VGND VPWR VPWR sky130_fd_sc_hd__fill_2
X_4423_ _1516_ VGND VGND VPWR VPWR _0150_ sky130_fd_sc_hd__clkbuf_1
XANTENNA__7093__RESET_B net819 VGND VGND VPWR VPWR sky130_fd_sc_hd__diode_2
XFILLER_0_111_266 VPWR VGND VPWR VGND sky130_ef_sc_hd__decap_12
X_4354_ _1444_ _1446_ _1456_ VGND VGND VPWR VPWR _1457_ sky130_fd_sc_hd__o21ai_1
X_7142_ clknet_leaf_93_clk _0211_ VGND VGND VPWR VPWR u_pe_array.u_fifo2.buffer\[8\]\[6\]
+ sky130_fd_sc_hd__dfxtp_1
XANTENNA__4439__S _0855_ VGND VGND VPWR VPWR sky130_fd_sc_hd__diode_2
XANTENNA__7022__RESET_B net815 VGND VGND VPWR VPWR sky130_fd_sc_hd__diode_2
XTAP_231 VGND VPWR sky130_fd_sc_hd__tapvpwrvgnd_1
XTAP_242 VGND VPWR sky130_fd_sc_hd__tapvpwrvgnd_1
XFILLER_0_1_497 VGND VGND VPWR VPWR sky130_fd_sc_hd__decap_6
X_7073_ clknet_leaf_88_clk _0146_ net74 VGND VGND VPWR VPWR u_pe_array.g_pe_row\[2\].g_pe_col\[3\].u_pe.psum_out\[10\]
+ sky130_fd_sc_hd__dfrtp_2
X_6024_ net29 u_pe_array.g_pe_row\[0\].g_pe_col\[1\].u_pe.w_buffer\[0\] _0827_ VGND
+ VGND VPWR VPWR _2854_ sky130_fd_sc_hd__mux2_1
X_4285_ _0721_ VGND VGND VPWR VPWR _1399_ sky130_fd_sc_hd__clkbuf_8
XTAP_264 VGND VPWR sky130_fd_sc_hd__tapvpwrvgnd_1
XTAP_253 VGND VPWR sky130_fd_sc_hd__tapvpwrvgnd_1
XTAP_275 VGND VPWR sky130_fd_sc_hd__tapvpwrvgnd_1
XANTENNA__5491__A1 _2258_ VGND VGND VPWR VPWR sky130_fd_sc_hd__diode_2
XTAP_297 VGND VPWR sky130_fd_sc_hd__tapvpwrvgnd_1
XTAP_286 VGND VPWR sky130_fd_sc_hd__tapvpwrvgnd_1
XANTENNA__4294__A2 _1392_ VGND VGND VPWR VPWR sky130_fd_sc_hd__diode_2
XTAP_1419 VGND VPWR sky130_fd_sc_hd__tapvpwrvgnd_1
XTAP_1408 VGND VPWR sky130_fd_sc_hd__tapvpwrvgnd_1
X_6926_ clknet_leaf_77_clk _0009_ net815 VGND VGND VPWR VPWR u_pe_array.g_pe_row\[3\].g_pe_col\[3\].u_pe.w_buffer\[0\]
+ sky130_fd_sc_hd__dfrtp_1
X_6857_ _3410_ VGND VGND VPWR VPWR _0690_ sky130_fd_sc_hd__clkbuf_1
XFILLER_0_71_70 VGND VGND VPWR VPWR sky130_fd_sc_hd__fill_2
XANTENNA_clkbuf_leaf_18_clk_A clknet_3_2__leaf_clk VGND VGND VPWR VPWR sky130_fd_sc_hd__diode_2
XFILLER_0_9_553 VGND VGND VPWR VPWR sky130_fd_sc_hd__decap_6
XFILLER_0_107_528 VPWR VGND VPWR VGND sky130_ef_sc_hd__decap_12
X_6788_ _3373_ VGND VGND VPWR VPWR _0658_ sky130_fd_sc_hd__clkbuf_1
XANTENNA__6743__A1 _3132_ VGND VGND VPWR VPWR sky130_fd_sc_hd__diode_2
XFILLER_0_91_245 VGND VGND VPWR VPWR sky130_fd_sc_hd__fill_2
XFILLER_0_17_331 VGND VGND VPWR VPWR sky130_fd_sc_hd__decap_3
X_5808_ _2651_ _2660_ VGND VGND VPWR VPWR _2673_ sky130_fd_sc_hd__and2_1
XFILLER_0_36_128 VGND VGND VPWR VPWR sky130_fd_sc_hd__decap_8
XFILLER_0_45_662 VGND VGND VPWR VPWR sky130_fd_sc_hd__fill_2
XFILLER_0_9_597 VPWR VGND VPWR VGND sky130_ef_sc_hd__decap_12
X_5739_ _2258_ _2607_ _2609_ _2571_ net404 VGND VGND VPWR VPWR _0373_ sky130_fd_sc_hd__a32o_1
XFILLER_0_60_632 VGND VGND VPWR VPWR sky130_fd_sc_hd__fill_2
XFILLER_0_32_334 VGND VGND VPWR VPWR sky130_fd_sc_hd__fill_1
X_7409_ clknet_leaf_59_clk u_fsm.en net813 VGND VGND VPWR VPWR u_pe_array.g_pe_row\[0\].g_pe_col\[0\].u_pe.en_r
+ sky130_fd_sc_hd__dfrtp_1
XFILLER_0_13_570 VPWR VGND VPWR VGND sky130_ef_sc_hd__decap_12
Xhold471 u_pe_array.g_pe_row\[1\].g_pe_col\[0\].u_pe.act_val\[3\] VGND VGND VPWR VPWR
+ net547 sky130_fd_sc_hd__dlygate4sd3_1
Xhold460 u_pe_array.u_fifo2.buffer\[2\]\[5\] VGND VGND VPWR VPWR net536 sky130_fd_sc_hd__dlygate4sd3_1
Xhold493 u_pe_array.g_pe_row\[1\].g_pe_col\[0\].u_pe.psum_out\[6\] VGND VGND VPWR
+ VPWR net569 sky130_fd_sc_hd__dlygate4sd3_1
Xhold482 u_pe_array.u_fifo2.buffer\[2\]\[4\] VGND VGND VPWR VPWR net558 sky130_fd_sc_hd__dlygate4sd3_1
XFILLER_0_59_209 VGND VGND VPWR VPWR sky130_fd_sc_hd__fill_2
XFILLER_0_82_212 VGND VGND VPWR VPWR sky130_fd_sc_hd__decap_3
XANTENNA__4993__B1 _0833_ VGND VGND VPWR VPWR sky130_fd_sc_hd__diode_2
XFILLER_0_82_245 VGND VGND VPWR VPWR sky130_fd_sc_hd__fill_2
XFILLER_0_67_297 VPWR VGND VPWR VGND sky130_ef_sc_hd__decap_12
XFILLER_0_55_437 VGND VGND VPWR VPWR sky130_fd_sc_hd__fill_2
XANTENNA__4812__S _0756_ VGND VGND VPWR VPWR sky130_fd_sc_hd__diode_2
XFILLER_0_51_610 VGND VGND VPWR VPWR sky130_fd_sc_hd__fill_2
XFILLER_0_50_164 VGND VGND VPWR VPWR sky130_fd_sc_hd__decap_3
XFILLER_0_23_389 VGND VGND VPWR VPWR sky130_fd_sc_hd__decap_3
XFILLER_0_50_197 VGND VGND VPWR VPWR sky130_fd_sc_hd__decap_3
X_4070_ _1216_ _1220_ _1225_ VGND VGND VPWR VPWR _1226_ sky130_fd_sc_hd__a21oi_2
X_4972_ u_pe_array.u_fifo2.rd_ptr\[3\] u_pe_array.u_fifo2.rd_ptr\[2\] VGND VGND VPWR
+ VPWR _1968_ sky130_fd_sc_hd__nor2_1
X_6711_ _3333_ VGND VGND VPWR VPWR _0621_ sky130_fd_sc_hd__clkbuf_1
XANTENNA__4984__B1 _0833_ VGND VGND VPWR VPWR sky130_fd_sc_hd__diode_2
X_3923_ u_pe_array.g_pe_row\[3\].g_pe_col\[2\].u_pe.psum_out\[10\] _1009_ VGND VGND
+ VPWR VPWR _1105_ sky130_fd_sc_hd__or2_1
XFILLER_0_46_448 VGND VGND VPWR VPWR sky130_fd_sc_hd__fill_2
X_3854_ _1040_ u_pe_array.g_pe_row\[3\].g_pe_col\[2\].u_pe.psum_out\[4\] _1009_ VGND
+ VGND VPWR VPWR _1042_ sky130_fd_sc_hd__and3_1
XFILLER_0_6_501 VPWR VGND VPWR VGND sky130_ef_sc_hd__decap_12
X_6642_ _3290_ VGND VGND VPWR VPWR _0595_ sky130_fd_sc_hd__clkbuf_1
XFILLER_0_6_545 VPWR VGND VPWR VGND sky130_ef_sc_hd__decap_12
XFILLER_0_27_673 VGND VGND VPWR VPWR sky130_fd_sc_hd__fill_2
XFILLER_0_104_509 VGND VGND VPWR VPWR sky130_fd_sc_hd__decap_4
X_3785_ _0735_ _0988_ _0754_ VGND VGND VPWR VPWR _0989_ sky130_fd_sc_hd__mux2_1
XFILLER_0_61_429 VGND VGND VPWR VPWR sky130_fd_sc_hd__decap_4
XANTENNA__5119__A _2029_ VGND VGND VPWR VPWR sky130_fd_sc_hd__diode_2
XANTENNA__7274__RESET_B net814 VGND VGND VPWR VPWR sky130_fd_sc_hd__diode_2
X_6573_ net513 _1788_ _3254_ VGND VGND VPWR VPWR _3255_ sky130_fd_sc_hd__mux2_1
X_5524_ _2345_ u_pe_array.g_pe_row\[1\].g_pe_col\[1\].u_pe.psum_out\[10\] VGND VGND
+ VPWR VPWR _2441_ sky130_fd_sc_hd__or2_1
XFILLER_0_42_665 VGND VGND VPWR VPWR sky130_fd_sc_hd__fill_2
XFILLER_0_6_589 VPWR VGND VPWR VGND sky130_ef_sc_hd__decap_12
XFILLER_0_112_531 VGND VGND VPWR VPWR sky130_fd_sc_hd__fill_1
X_5455_ u_pe_array.g_pe_row\[1\].g_pe_col\[1\].u_pe.w_reg\[0\] _2345_ _2376_ u_pe_array.g_pe_row\[1\].g_pe_col\[1\].u_pe.act_val\[4\]
+ VGND VGND VPWR VPWR _2378_ sky130_fd_sc_hd__nand4_2
XANTENNA__7203__RESET_B net815 VGND VGND VPWR VPWR sky130_fd_sc_hd__diode_2
XFILLER_0_41_164 VGND VGND VPWR VPWR sky130_fd_sc_hd__fill_2
XFILLER_0_67_3 VPWR VGND VPWR VGND sky130_ef_sc_hd__decap_12
XFILLER_0_1_261 VGND VGND VPWR VPWR sky130_fd_sc_hd__decap_6
X_4406_ _1502_ _1503_ net792 _0916_ VGND VGND VPWR VPWR _0146_ sky130_fd_sc_hd__a2bb2o_1
X_5386_ u_pe_array.u_fifo1.buffer\[8\]\[4\] _2273_ _2317_ _2321_ _0819_ VGND VGND
+ VPWR VPWR _2322_ sky130_fd_sc_hd__a221o_2
X_7125_ clknet_leaf_36_clk _0194_ net76 VGND VGND VPWR VPWR u_pe_array.g_pe_row\[2\].g_pe_col\[1\].u_pe.psum_out\[2\]
+ sky130_fd_sc_hd__dfrtp_1
X_4337_ _1439_ _1440_ VGND VGND VPWR VPWR _1441_ sky130_fd_sc_hd__nor2_1
XFILLER_0_5_51 VGND VGND VPWR VPWR sky130_fd_sc_hd__decap_4
X_4268_ _1389_ VGND VGND VPWR VPWR _0122_ sky130_fd_sc_hd__clkbuf_1
X_7056_ clknet_leaf_89_clk net188 net819 VGND VGND VPWR VPWR u_pe_array.g_pe_row\[2\].g_pe_col\[2\].u_pe.move_reg\[8\]
+ sky130_fd_sc_hd__dfrtp_1
XANTENNA__5464__B2 _0875_ VGND VGND VPWR VPWR sky130_fd_sc_hd__diode_2
X_6007_ _2838_ _2839_ VGND VGND VPWR VPWR _2840_ sky130_fd_sc_hd__and2_1
X_4199_ u_pe_array.g_pe_row\[3\].g_pe_col\[0\].u_pe.act_val\[5\] VGND VGND VPWR VPWR
+ _1329_ sky130_fd_sc_hd__inv_2
XFILLER_0_96_337 VGND VGND VPWR VPWR sky130_fd_sc_hd__fill_1
XTAP_1205 VGND VPWR sky130_fd_sc_hd__tapvpwrvgnd_1
XTAP_1238 VGND VPWR sky130_fd_sc_hd__tapvpwrvgnd_1
XTAP_1227 VGND VPWR sky130_fd_sc_hd__tapvpwrvgnd_1
XTAP_1216 VGND VPWR sky130_fd_sc_hd__tapvpwrvgnd_1
XFILLER_0_49_231 VGND VGND VPWR VPWR sky130_fd_sc_hd__fill_2
X_6909_ _3438_ VGND VGND VPWR VPWR _0714_ sky130_fd_sc_hd__clkbuf_1
XTAP_1249 VGND VPWR sky130_fd_sc_hd__tapvpwrvgnd_1
XANTENNA__5728__S _2469_ VGND VGND VPWR VPWR sky130_fd_sc_hd__diode_2
XANTENNA__6716__A1 _3132_ VGND VGND VPWR VPWR sky130_fd_sc_hd__diode_2
XFILLER_0_64_245 VGND VGND VPWR VPWR sky130_fd_sc_hd__decap_4
XFILLER_0_9_372 VGND VGND VPWR VPWR sky130_fd_sc_hd__fill_2
XFILLER_0_18_640 VGND VGND VPWR VPWR sky130_fd_sc_hd__decap_4
XFILLER_0_45_470 VGND VGND VPWR VPWR sky130_fd_sc_hd__decap_3
XFILLER_0_17_172 VGND VGND VPWR VPWR sky130_fd_sc_hd__fill_2
XFILLER_0_33_610 VGND VGND VPWR VPWR sky130_fd_sc_hd__decap_4
XFILLER_0_45_492 VGND VGND VPWR VPWR sky130_fd_sc_hd__fill_1
XFILLER_0_60_462 VGND VGND VPWR VPWR sky130_fd_sc_hd__fill_2
XANTENNA__6559__S _3239_ VGND VGND VPWR VPWR sky130_fd_sc_hd__diode_2
XFILLER_0_103_597 VGND VGND VPWR VPWR sky130_fd_sc_hd__fill_2
XANTENNA__6997__RESET_B net817 VGND VGND VPWR VPWR sky130_fd_sc_hd__diode_2
Xhold290 _0397_ VGND VGND VPWR VPWR net366 sky130_fd_sc_hd__dlygate4sd3_1
XANTENNA__6926__RESET_B net815 VGND VGND VPWR VPWR sky130_fd_sc_hd__diode_2
XANTENNA__4807__S _0754_ VGND VGND VPWR VPWR sky130_fd_sc_hd__diode_2
XFILLER_0_99_164 VGND VGND VPWR VPWR sky130_fd_sc_hd__fill_2
XANTENNA__6307__B _2992_ VGND VGND VPWR VPWR sky130_fd_sc_hd__diode_2
XFILLER_0_87_315 VGND VGND VPWR VPWR sky130_fd_sc_hd__fill_1
XANTENNA__5758__A2 _2387_ VGND VGND VPWR VPWR sky130_fd_sc_hd__diode_2
XFILLER_0_83_543 VGND VGND VPWR VPWR sky130_fd_sc_hd__fill_2
XFILLER_0_55_234 VGND VGND VPWR VPWR sky130_fd_sc_hd__fill_1
XFILLER_0_7_309 VGND VGND VPWR VPWR sky130_fd_sc_hd__decap_4
XFILLER_0_28_437 VGND VGND VPWR VPWR sky130_fd_sc_hd__decap_3
XFILLER_0_83_565 VGND VGND VPWR VPWR sky130_fd_sc_hd__decap_3
XFILLER_0_15_109 VGND VGND VPWR VPWR sky130_fd_sc_hd__decap_3
XANTENNA__6183__A2 _0867_ VGND VGND VPWR VPWR sky130_fd_sc_hd__diode_2
X_3570_ _0809_ _0811_ _0779_ VGND VGND VPWR VPWR _0812_ sky130_fd_sc_hd__and3b_1
XFILLER_0_23_131 VGND VGND VPWR VPWR sky130_fd_sc_hd__decap_3
XFILLER_0_24_643 VGND VGND VPWR VPWR sky130_fd_sc_hd__fill_1
XFILLER_0_3_559 VGND VGND VPWR VPWR sky130_fd_sc_hd__fill_1
X_5240_ u_pe_array.g_pe_row\[1\].g_pe_col\[2\].u_pe.act_val\[4\] u_pe_array.g_pe_row\[1\].g_pe_col\[2\].u_pe.w_reg\[0\]
+ _2158_ _2190_ VGND VGND VPWR VPWR _2191_ sky130_fd_sc_hd__a22o_1
X_5171_ net803 VGND VGND VPWR VPWR _0275_ sky130_fd_sc_hd__clkbuf_1
X_4122_ u_pe_array.g_pe_row\[3\].g_pe_col\[3\].u_pe.psum_out\[7\] u_pe_array.g_pe_row\[3\].g_pe_col\[3\].u_pe.move_reg\[7\]
+ _0855_ VGND VGND VPWR VPWR _1264_ sky130_fd_sc_hd__mux2_1
X_4053_ _1201_ _1202_ _1205_ VGND VGND VPWR VPWR _1210_ sky130_fd_sc_hd__and3_1
Xinput3 h_in0[2] VGND VGND VPWR VPWR net3 sky130_fd_sc_hd__clkbuf_2
XANTENNA__3621__S _0819_ VGND VGND VPWR VPWR sky130_fd_sc_hd__diode_2
XFILLER_0_93_318 VGND VGND VPWR VPWR sky130_fd_sc_hd__fill_1
X_4955_ u_pe_array.g_pe_row\[2\].g_pe_col\[0\].u_pe.psum_out\[12\] _1946_ VGND VGND
+ VPWR VPWR _1954_ sky130_fd_sc_hd__xnor2_1
XANTENNA__4957__B1 _0887_ VGND VGND VPWR VPWR sky130_fd_sc_hd__diode_2
XFILLER_0_59_573 VGND VGND VPWR VPWR sky130_fd_sc_hd__fill_1
XFILLER_0_19_426 VGND VGND VPWR VPWR sky130_fd_sc_hd__decap_3
X_3906_ _1088_ _1089_ VGND VGND VPWR VPWR _1090_ sky130_fd_sc_hd__nand2_1
X_4886_ u_pe_array.g_pe_row\[2\].g_pe_col\[0\].u_pe.psum_out\[5\] _1891_ VGND VGND
+ VPWR VPWR _1892_ sky130_fd_sc_hd__xnor2_1
X_6625_ net221 _1820_ _3269_ VGND VGND VPWR VPWR _3282_ sky130_fd_sc_hd__mux2_1
X_3837_ _1022_ _1023_ _1025_ VGND VGND VPWR VPWR _1026_ sky130_fd_sc_hd__o21a_1
XFILLER_0_104_317 VGND VGND VPWR VPWR sky130_fd_sc_hd__fill_1
XANTENNA__4185__B2 _0916_ VGND VGND VPWR VPWR sky130_fd_sc_hd__diode_2
XFILLER_0_6_386 VGND VGND VPWR VPWR sky130_fd_sc_hd__fill_1
X_3768_ u_pe_array.g_pe_row\[3\].g_pe_col\[3\].u_pe.psum_out\[11\] _0976_ _0967_ VGND
+ VGND VPWR VPWR _0977_ sky130_fd_sc_hd__mux2_1
X_6556_ _3245_ VGND VGND VPWR VPWR _0554_ sky130_fd_sc_hd__clkbuf_1
X_5507_ _2424_ _2425_ VGND VGND VPWR VPWR _2426_ sky130_fd_sc_hd__or2_1
XFILLER_0_15_665 VGND VGND VPWR VPWR sky130_fd_sc_hd__decap_4
XANTENNA_load_slew6_A net76 VGND VGND VPWR VPWR sky130_fd_sc_hd__diode_2
X_6487_ _3141_ _3165_ VGND VGND VPWR VPWR _3208_ sky130_fd_sc_hd__nor2_8
X_3699_ _0902_ _0911_ _0914_ VGND VGND VPWR VPWR _0915_ sky130_fd_sc_hd__a21o_1
XFILLER_0_14_197 VGND VGND VPWR VPWR sky130_fd_sc_hd__decap_3
XFILLER_0_112_394 VPWR VGND VPWR VGND sky130_ef_sc_hd__decap_12
X_5438_ _2352_ _2358_ _2361_ VGND VGND VPWR VPWR _2362_ sky130_fd_sc_hd__a21o_1
XFILLER_0_2_581 VGND VGND VPWR VPWR sky130_fd_sc_hd__decap_6
X_5369_ u_pe_array.g_pe_row\[0\].g_pe_col\[0\].u_pe.act_val\[2\] u_pe_array.g_pe_row\[0\].g_pe_col\[0\].u_pe.psum_out\[2\]
+ _0755_ VGND VGND VPWR VPWR _2307_ sky130_fd_sc_hd__mux2_1
X_7108_ clknet_leaf_36_clk _0179_ net76 VGND VGND VPWR VPWR u_pe_array.g_pe_row\[2\].g_pe_col\[0\].u_pe.act_val\[0\]
+ sky130_fd_sc_hd__dfrtp_2
XFILLER_0_10_392 VGND VGND VPWR VPWR sky130_fd_sc_hd__fill_1
X_7039_ clknet_leaf_28_clk _0114_ net817 VGND VGND VPWR VPWR u_pe_array.g_pe_row\[3\].g_pe_col\[0\].u_pe.psum_out\[6\]
+ sky130_fd_sc_hd__dfrtp_1
XANTENNA__6634__B1 _0836_ VGND VGND VPWR VPWR sky130_fd_sc_hd__diode_2
XFILLER_0_97_668 VGND VGND VPWR VPWR sky130_fd_sc_hd__decap_4
XANTENNA__6842__S _3397_ VGND VGND VPWR VPWR sky130_fd_sc_hd__diode_2
XFILLER_0_69_337 VGND VGND VPWR VPWR sky130_fd_sc_hd__fill_2
XTAP_1013 VGND VPWR sky130_fd_sc_hd__tapvpwrvgnd_1
XTAP_1002 VGND VPWR sky130_fd_sc_hd__tapvpwrvgnd_1
XFILLER_0_96_167 VGND VGND VPWR VPWR sky130_fd_sc_hd__fill_2
XTAP_1035 VGND VPWR sky130_fd_sc_hd__tapvpwrvgnd_1
XTAP_1046 VGND VPWR sky130_fd_sc_hd__tapvpwrvgnd_1
XTAP_1024 VGND VPWR sky130_fd_sc_hd__tapvpwrvgnd_1
XFILLER_0_108_601 VPWR VGND VPWR VGND sky130_ef_sc_hd__decap_12
XFILLER_0_77_370 VGND VGND VPWR VPWR sky130_fd_sc_hd__fill_2
XTAP_1079 VGND VPWR sky130_fd_sc_hd__tapvpwrvgnd_1
XTAP_1068 VGND VPWR sky130_fd_sc_hd__tapvpwrvgnd_1
XTAP_1057 VGND VPWR sky130_fd_sc_hd__tapvpwrvgnd_1
XANTENNA__7196__RESET_B net815 VGND VGND VPWR VPWR sky130_fd_sc_hd__diode_2
XFILLER_0_37_223 VGND VGND VPWR VPWR sky130_fd_sc_hd__fill_1
XANTENNA__6143__A _2873_ VGND VGND VPWR VPWR sky130_fd_sc_hd__diode_2
XANTENNA__7125__RESET_B net76 VGND VGND VPWR VPWR sky130_fd_sc_hd__diode_2
XFILLER_0_37_256 VGND VGND VPWR VPWR sky130_fd_sc_hd__fill_2
XFILLER_0_108_645 VPWR VGND VPWR VGND sky130_ef_sc_hd__decap_12
XFILLER_0_92_362 VGND VGND VPWR VPWR sky130_fd_sc_hd__fill_2
XANTENNA__3486__B _0730_ VGND VGND VPWR VPWR sky130_fd_sc_hd__diode_2
XFILLER_0_52_215 VGND VGND VPWR VPWR sky130_fd_sc_hd__fill_2
XFILLER_0_21_602 VGND VGND VPWR VPWR sky130_fd_sc_hd__fill_2
XFILLER_0_110_309 VPWR VGND VPWR VGND sky130_ef_sc_hd__decap_12
XANTENNA__5193__S _1661_ VGND VGND VPWR VPWR sky130_fd_sc_hd__diode_2
XFILLER_0_0_529 VGND VGND VPWR VPWR sky130_fd_sc_hd__decap_3
XFILLER_0_20_101 VGND VGND VPWR VPWR sky130_fd_sc_hd__fill_2
XFILLER_0_33_484 VGND VGND VPWR VPWR sky130_fd_sc_hd__fill_2
XFILLER_0_103_361 VGND VGND VPWR VPWR sky130_fd_sc_hd__fill_2
XTAP_808 VGND VPWR sky130_fd_sc_hd__tapvpwrvgnd_1
XFILLER_0_57_39 VPWR VGND VPWR VGND sky130_ef_sc_hd__decap_12
XTAP_819 VGND VPWR sky130_fd_sc_hd__tapvpwrvgnd_1
XFILLER_0_73_27 VGND VGND VPWR VPWR sky130_fd_sc_hd__decap_6
XANTENNA__5222__A _0885_ VGND VGND VPWR VPWR sky130_fd_sc_hd__diode_2
XFILLER_0_87_178 VPWR VGND VPWR VGND sky130_ef_sc_hd__decap_12
XFILLER_0_87_167 VGND VGND VPWR VPWR sky130_fd_sc_hd__fill_1
XFILLER_0_56_521 VGND VGND VPWR VPWR sky130_fd_sc_hd__fill_1
XTAP_1591 VGND VPWR sky130_fd_sc_hd__tapvpwrvgnd_1
XFILLER_0_113_55 VGND VGND VPWR VPWR sky130_fd_sc_hd__fill_1
XTAP_1580 VGND VPWR sky130_fd_sc_hd__tapvpwrvgnd_1
X_4740_ _1772_ _1775_ _1780_ VGND VGND VPWR VPWR _1781_ sky130_fd_sc_hd__o21ai_1
XFILLER_0_56_565 VGND VGND VPWR VPWR sky130_fd_sc_hd__decap_8
XFILLER_0_22_42 VGND VGND VPWR VPWR sky130_fd_sc_hd__decap_3
XFILLER_0_71_535 VGND VGND VPWR VPWR sky130_fd_sc_hd__fill_2
X_4671_ u_pe_array.g_pe_row\[2\].g_pe_col\[1\].u_pe.psum_out\[5\] _1717_ VGND VGND
+ VPWR VPWR _1718_ sky130_fd_sc_hd__xnor2_1
X_7390_ clknet_leaf_42_clk _0443_ net817 VGND VGND VPWR VPWR u_pe_array.g_pe_row\[0\].g_pe_col\[0\].u_pe.w_buffer\[1\]
+ sky130_fd_sc_hd__dfrtp_1
X_6410_ _3168_ VGND VGND VPWR VPWR _0485_ sky130_fd_sc_hd__clkbuf_1
X_3622_ net726 _0834_ _0837_ _0849_ VGND VGND VPWR VPWR _0016_ sky130_fd_sc_hd__a22o_1
X_6341_ _3120_ net551 _3110_ VGND VGND VPWR VPWR _3121_ sky130_fd_sc_hd__mux2_1
XFILLER_0_24_473 VGND VGND VPWR VPWR sky130_fd_sc_hd__decap_3
XFILLER_0_113_169 VGND VGND VPWR VPWR sky130_fd_sc_hd__fill_2
XFILLER_0_98_79 VGND VGND VPWR VPWR sky130_fd_sc_hd__fill_2
X_3553_ _0785_ _0797_ _0798_ _0721_ VGND VGND VPWR VPWR _0799_ sky130_fd_sc_hd__a22o_1
X_6272_ _3058_ _3062_ _3047_ VGND VGND VPWR VPWR _3063_ sky130_fd_sc_hd__mux2_1
X_3484_ u_pe_array.g_pe_row\[3\].g_pe_col\[0\].u_pe.move_reg\[9\] _0730_ VGND VGND
+ VPWR VPWR _0750_ sky130_fd_sc_hd__or2_1
XFILLER_0_12_657 VPWR VGND VPWR VGND sky130_ef_sc_hd__decap_12
XANTENNA__3843__C _1009_ VGND VGND VPWR VPWR sky130_fd_sc_hd__diode_2
X_5223_ _2166_ _2170_ VGND VGND VPWR VPWR _2175_ sky130_fd_sc_hd__nor2_1
XFILLER_0_11_167 VGND VGND VPWR VPWR sky130_fd_sc_hd__fill_1
X_5154_ _2125_ _2126_ net831 _0916_ VGND VGND VPWR VPWR _0271_ sky130_fd_sc_hd__a2bb2o_1
X_4105_ net93 net77 _0828_ VGND VGND VPWR VPWR _1255_ sky130_fd_sc_hd__mux2_1
XANTENNA__4447__S _0855_ VGND VGND VPWR VPWR sky130_fd_sc_hd__diode_2
X_5085_ u_pe_array.g_pe_row\[1\].g_pe_col\[3\].u_pe.act_val\[2\] u_pe_array.g_pe_row\[1\].g_pe_col\[3\].u_pe.psum_out\[3\]
+ _2029_ VGND VGND VPWR VPWR _2064_ sky130_fd_sc_hd__and3b_1
XFILLER_0_79_635 VGND VGND VPWR VPWR sky130_fd_sc_hd__fill_1
XFILLER_0_78_101 VGND VGND VPWR VPWR sky130_fd_sc_hd__fill_2
X_4036_ _1180_ _1182_ VGND VGND VPWR VPWR _1195_ sky130_fd_sc_hd__nand2_1
XFILLER_0_2_41 VPWR VGND VPWR VGND sky130_ef_sc_hd__decap_12
XFILLER_0_2_85 VPWR VGND VPWR VGND sky130_ef_sc_hd__decap_12
XFILLER_0_94_616 VGND VGND VPWR VPWR sky130_fd_sc_hd__decap_4
XFILLER_0_78_178 VGND VGND VPWR VPWR sky130_fd_sc_hd__fill_1
XFILLER_0_66_307 VGND VGND VPWR VPWR sky130_fd_sc_hd__fill_1
XPHY_107 VGND VGND VPWR VPWR sky130_fd_sc_hd__decap_3
XPHY_129 VGND VGND VPWR VPWR sky130_fd_sc_hd__decap_3
XFILLER_0_59_381 VGND VGND VPWR VPWR sky130_fd_sc_hd__fill_2
XPHY_118 VGND VGND VPWR VPWR sky130_fd_sc_hd__decap_3
X_5987_ u_pe_array.g_pe_row\[0\].g_pe_col\[2\].u_pe.psum_out\[8\] _2743_ VGND VGND
+ VPWR VPWR _2822_ sky130_fd_sc_hd__nand2_1
XFILLER_0_47_510 VGND VGND VPWR VPWR sky130_fd_sc_hd__decap_3
XFILLER_0_19_201 VGND VGND VPWR VPWR sky130_fd_sc_hd__decap_8
XFILLER_0_19_223 VGND VGND VPWR VPWR sky130_fd_sc_hd__fill_1
X_4938_ u_pe_array.g_pe_row\[2\].g_pe_col\[0\].u_pe.psum_out\[10\] _1847_ VGND VGND
+ VPWR VPWR _1939_ sky130_fd_sc_hd__nand2_1
X_4869_ net662 _1714_ _0887_ _1876_ VGND VGND VPWR VPWR _0236_ sky130_fd_sc_hd__a22o_1
X_7657_ clknet_leaf_21_clk _0706_ VGND VGND VPWR VPWR u_pe_array.u_fifo1.buffer\[7\]\[2\]
+ sky130_fd_sc_hd__dfxtp_1
XFILLER_0_62_513 VGND VGND VPWR VPWR sky130_fd_sc_hd__fill_1
XFILLER_0_47_598 VGND VGND VPWR VPWR sky130_fd_sc_hd__fill_2
XFILLER_0_105_615 VGND VGND VPWR VPWR sky130_fd_sc_hd__fill_1
XFILLER_0_7_673 VGND VGND VPWR VPWR sky130_fd_sc_hd__decap_4
X_6608_ _3273_ VGND VGND VPWR VPWR _0578_ sky130_fd_sc_hd__clkbuf_1
X_7588_ clknet_leaf_27_clk _0637_ VGND VGND VPWR VPWR u_pe_array.u_fifo1.buffer\[1\]\[11\]
+ sky130_fd_sc_hd__dfxtp_1
X_6539_ net312 _1818_ _3224_ VGND VGND VPWR VPWR _3236_ sky130_fd_sc_hd__mux2_1
XFILLER_0_30_410 VGND VGND VPWR VPWR sky130_fd_sc_hd__fill_2
XFILLER_0_30_421 VGND VGND VPWR VPWR sky130_fd_sc_hd__fill_2
XFILLER_0_112_180 VGND VGND VPWR VPWR sky130_fd_sc_hd__fill_2
XFILLER_0_100_353 VGND VGND VPWR VPWR sky130_fd_sc_hd__decap_6
XFILLER_0_69_101 VGND VGND VPWR VPWR sky130_fd_sc_hd__fill_1
XANTENNA__7377__RESET_B net812 VGND VGND VPWR VPWR sky130_fd_sc_hd__diode_2
XPHY_9 VGND VGND VPWR VPWR sky130_fd_sc_hd__decap_3
XANTENNA__7306__RESET_B net814 VGND VGND VPWR VPWR sky130_fd_sc_hd__diode_2
XFILLER_0_84_137 VGND VGND VPWR VPWR sky130_fd_sc_hd__decap_3
XANTENNA__3497__A _0758_ VGND VGND VPWR VPWR sky130_fd_sc_hd__diode_2
XFILLER_0_25_215 VGND VGND VPWR VPWR sky130_fd_sc_hd__fill_2
XFILLER_0_108_475 VGND VGND VPWR VPWR sky130_fd_sc_hd__fill_1
XFILLER_0_80_332 VGND VGND VPWR VPWR sky130_fd_sc_hd__fill_2
XFILLER_0_80_321 VGND VGND VPWR VPWR sky130_fd_sc_hd__decap_3
XFILLER_0_4_109 VPWR VGND VPWR VGND sky130_ef_sc_hd__decap_12
XFILLER_0_80_365 VGND VGND VPWR VPWR sky130_fd_sc_hd__fill_1
XFILLER_0_25_259 VGND VGND VPWR VPWR sky130_fd_sc_hd__decap_4
XANTENNA__6941__RESET_B net815 VGND VGND VPWR VPWR sky130_fd_sc_hd__diode_2
XFILLER_0_111_629 VPWR VGND VPWR VGND sky130_ef_sc_hd__decap_12
XFILLER_0_68_27 VGND VGND VPWR VPWR sky130_fd_sc_hd__fill_1
XFILLER_0_0_315 VPWR VGND VPWR VGND sky130_ef_sc_hd__decap_12
XFILLER_0_0_337 VGND VGND VPWR VPWR sky130_fd_sc_hd__decap_6
XFILLER_0_21_454 VGND VGND VPWR VPWR sky130_fd_sc_hd__fill_2
XFILLER_0_21_498 VGND VGND VPWR VPWR sky130_fd_sc_hd__decap_4
XTAP_605 VGND VPWR sky130_fd_sc_hd__tapvpwrvgnd_1
XTAP_616 VGND VPWR sky130_fd_sc_hd__tapvpwrvgnd_1
XTAP_627 VGND VPWR sky130_fd_sc_hd__tapvpwrvgnd_1
XTAP_638 VGND VPWR sky130_fd_sc_hd__tapvpwrvgnd_1
XTAP_649 VGND VPWR sky130_fd_sc_hd__tapvpwrvgnd_1
XANTENNA__4267__S _0828_ VGND VGND VPWR VPWR sky130_fd_sc_hd__diode_2
XFILLER_0_16_9 VGND VGND VPWR VPWR sky130_fd_sc_hd__decap_4
X_5910_ u_pe_array.g_pe_row\[0\].g_pe_col\[2\].u_pe.act_val\[1\] _2743_ VGND VGND
+ VPWR VPWR _2751_ sky130_fd_sc_hd__or2b_1
X_6890_ net487 _3112_ _3427_ VGND VGND VPWR VPWR _3429_ sky130_fd_sc_hd__mux2_1
XFILLER_0_76_627 VGND VGND VPWR VPWR sky130_fd_sc_hd__fill_2
XANTENNA__7047__RESET_B net815 VGND VGND VPWR VPWR sky130_fd_sc_hd__diode_2
X_5841_ _2701_ VGND VGND VPWR VPWR _2702_ sky130_fd_sc_hd__inv_2
XFILLER_0_33_41 VGND VGND VPWR VPWR sky130_fd_sc_hd__fill_1
XFILLER_0_33_74 VGND VGND VPWR VPWR sky130_fd_sc_hd__fill_2
XANTENNA__3838__C _1009_ VGND VGND VPWR VPWR sky130_fd_sc_hd__diode_2
X_5772_ _2628_ _2639_ VGND VGND VPWR VPWR _2640_ sky130_fd_sc_hd__xor2_1
X_4723_ _1764_ VGND VGND VPWR VPWR _1765_ sky130_fd_sc_hd__inv_2
X_7511_ clknet_leaf_0_clk _0560_ VGND VGND VPWR VPWR u_pe_array.u_fifo2.buffer\[5\]\[11\]
+ sky130_fd_sc_hd__dfxtp_1
XFILLER_0_29_576 VPWR VGND VPWR VGND sky130_ef_sc_hd__decap_12
XFILLER_0_83_192 VGND VGND VPWR VPWR sky130_fd_sc_hd__decap_4
XFILLER_0_71_332 VGND VGND VPWR VPWR sky130_fd_sc_hd__fill_2
X_7442_ clknet_leaf_8_clk _0491_ VGND VGND VPWR VPWR u_pe_array.u_fifo2.buffer\[0\]\[7\]
+ sky130_fd_sc_hd__dfxtp_1
X_4654_ _1689_ _1699_ _1698_ VGND VGND VPWR VPWR _1702_ sky130_fd_sc_hd__a21oi_1
XFILLER_0_4_643 VGND VGND VPWR VPWR sky130_fd_sc_hd__fill_1
X_4585_ _1650_ VGND VGND VPWR VPWR _0178_ sky130_fd_sc_hd__clkbuf_1
X_7373_ clknet_leaf_51_clk _0428_ net812 VGND VGND VPWR VPWR u_pe_array.g_pe_row\[0\].g_pe_col\[0\].u_pe.move_reg\[12\]
+ sky130_fd_sc_hd__dfrtp_1
XFILLER_0_12_421 VGND VGND VPWR VPWR sky130_fd_sc_hd__decap_4
X_3605_ u_pe_array.g_pe_row\[2\].g_pe_col\[2\].u_pe.act_val\[0\] u_pe_array.g_pe_row\[2\].g_pe_col\[2\].u_pe.psum_out\[0\]
+ _0755_ VGND VGND VPWR VPWR _0838_ sky130_fd_sc_hd__mux2_1
XFILLER_0_31_229 VGND VGND VPWR VPWR sky130_fd_sc_hd__fill_1
XFILLER_0_114_489 VPWR VGND VPWR VGND sky130_ef_sc_hd__decap_12
X_6324_ _1789_ _3108_ VGND VGND VPWR VPWR _3109_ sky130_fd_sc_hd__or2_1
X_3536_ _0718_ _0723_ VGND VGND VPWR VPWR _0783_ sky130_fd_sc_hd__nand2_2
X_6255_ _3046_ u_pe_array.g_pe_row\[0\].g_pe_col\[0\].u_pe.psum_out\[6\] _2992_ VGND
+ VGND VPWR VPWR _3047_ sky130_fd_sc_hd__nand3_2
X_3467_ u_pe_array.g_pe_row\[3\].g_pe_col\[0\].u_pe.act_val\[3\] u_pe_array.g_pe_row\[3\].g_pe_col\[0\].u_pe.psum_out\[3\]
+ _0730_ VGND VGND VPWR VPWR _0739_ sky130_fd_sc_hd__mux2_1
X_5206_ _2157_ _2159_ VGND VGND VPWR VPWR _2160_ sky130_fd_sc_hd__xor2_1
X_6186_ net28 u_pe_array.g_pe_row\[0\].g_pe_col\[0\].u_pe.w_buffer\[1\] _0827_ VGND
+ VGND VPWR VPWR _2987_ sky130_fd_sc_hd__mux2_1
XFILLER_0_58_93 VGND VGND VPWR VPWR sky130_fd_sc_hd__fill_2
XANTENNA__3520__C1 _0754_ VGND VGND VPWR VPWR sky130_fd_sc_hd__diode_2
X_5137_ _2110_ _2111_ net708 _0916_ VGND VGND VPWR VPWR _0269_ sky130_fd_sc_hd__a2bb2o_1
XANTENNA__6065__A1 _2740_ VGND VGND VPWR VPWR sky130_fd_sc_hd__diode_2
X_5068_ u_pe_array.g_pe_row\[1\].g_pe_col\[3\].u_pe.w_reg\[0\] u_pe_array.g_pe_row\[1\].g_pe_col\[3\].u_pe.act_val\[2\]
+ _2038_ VGND VGND VPWR VPWR _2048_ sky130_fd_sc_hd__and3_1
XANTENNA__4615__A2 _1666_ VGND VGND VPWR VPWR sky130_fd_sc_hd__diode_2
X_4019_ u_pe_array.g_pe_row\[3\].g_pe_col\[1\].u_pe.w_reg\[0\] u_pe_array.g_pe_row\[3\].g_pe_col\[1\].u_pe.act_val\[4\]
+ _1176_ _1177_ VGND VGND VPWR VPWR _1179_ sky130_fd_sc_hd__o2bb2a_1
XANTENNA__5812__A1 _2258_ VGND VGND VPWR VPWR sky130_fd_sc_hd__diode_2
XFILLER_0_94_424 VGND VGND VPWR VPWR sky130_fd_sc_hd__fill_2
XFILLER_0_67_649 VGND VGND VPWR VPWR sky130_fd_sc_hd__fill_1
XFILLER_0_109_206 VGND VGND VPWR VPWR sky130_fd_sc_hd__fill_2
XFILLER_0_90_652 VGND VGND VPWR VPWR sky130_fd_sc_hd__fill_2
XFILLER_0_90_630 VGND VGND VPWR VPWR sky130_fd_sc_hd__fill_2
XFILLER_0_90_674 VGND VGND VPWR VPWR sky130_fd_sc_hd__fill_1
XFILLER_0_62_365 VGND VGND VPWR VPWR sky130_fd_sc_hd__decap_3
XFILLER_0_50_516 VGND VGND VPWR VPWR sky130_fd_sc_hd__fill_2
XFILLER_0_35_579 VGND VGND VPWR VPWR sky130_fd_sc_hd__fill_2
XFILLER_0_105_445 VGND VGND VPWR VPWR sky130_fd_sc_hd__decap_3
XANTENNA__4000__B1 _0887_ VGND VGND VPWR VPWR sky130_fd_sc_hd__diode_2
XFILLER_0_15_281 VGND VGND VPWR VPWR sky130_fd_sc_hd__decap_4
XFILLER_0_15_292 VGND VGND VPWR VPWR sky130_fd_sc_hd__fill_2
XFILLER_0_101_640 VPWR VGND VPWR VGND sky130_ef_sc_hd__decap_12
XFILLER_0_101_673 VGND VGND VPWR VPWR sky130_fd_sc_hd__decap_4
XFILLER_0_100_150 VGND VGND VPWR VPWR sky130_fd_sc_hd__fill_1
XANTENNA__6567__S _3239_ VGND VGND VPWR VPWR sky130_fd_sc_hd__diode_2
XANTENNA_input33_A w_in_flat[6] VGND VGND VPWR VPWR sky130_fd_sc_hd__diode_2
XANTENNA__4854__A2 _1714_ VGND VGND VPWR VPWR sky130_fd_sc_hd__diode_2
XANTENNA__7558__RESET_B net816 VGND VGND VPWR VPWR sky130_fd_sc_hd__diode_2
XFILLER_0_89_229 VGND VGND VPWR VPWR sky130_fd_sc_hd__fill_1
XFILLER_0_54_29 VPWR VGND VPWR VGND sky130_ef_sc_hd__decap_12
XFILLER_0_97_251 VGND VGND VPWR VPWR sky130_fd_sc_hd__fill_2
XANTENNA__4815__S _0756_ VGND VGND VPWR VPWR sky130_fd_sc_hd__diode_2
XANTENNA__5031__A2 _1666_ VGND VGND VPWR VPWR sky130_fd_sc_hd__diode_2
XFILLER_0_53_332 VGND VGND VPWR VPWR sky130_fd_sc_hd__fill_2
XFILLER_0_38_384 VGND VGND VPWR VPWR sky130_fd_sc_hd__fill_2
XFILLER_0_108_294 VGND VGND VPWR VPWR sky130_fd_sc_hd__decap_6
XFILLER_0_79_15 VGND VGND VPWR VPWR sky130_fd_sc_hd__decap_8
XFILLER_0_80_195 VGND VGND VPWR VPWR sky130_fd_sc_hd__fill_1
Xhold108 u_pe_array.g_pe_row\[3\].g_pe_col\[1\].u_pe.move_reg\[9\] VGND VGND VPWR
+ VPWR net184 sky130_fd_sc_hd__dlygate4sd3_1
XFILLER_0_111_415 VGND VGND VPWR VPWR sky130_fd_sc_hd__fill_2
XFILLER_0_1_613 VGND VGND VPWR VPWR sky130_fd_sc_hd__decap_3
X_4370_ _1462_ _1463_ _1466_ VGND VGND VPWR VPWR _1471_ sky130_fd_sc_hd__and3_1
XANTENNA__4542__A1 _1536_ VGND VGND VPWR VPWR sky130_fd_sc_hd__diode_2
Xhold119 u_pe_array.g_pe_row\[2\].g_pe_col\[3\].u_pe.move_reg\[10\] VGND VGND VPWR
+ VPWR net195 sky130_fd_sc_hd__dlygate4sd3_1
XANTENNA__4466__B1_N _1536_ VGND VGND VPWR VPWR sky130_fd_sc_hd__diode_2
XTAP_413 VGND VPWR sky130_fd_sc_hd__tapvpwrvgnd_1
XTAP_402 VGND VPWR sky130_fd_sc_hd__tapvpwrvgnd_1
XTAP_424 VGND VPWR sky130_fd_sc_hd__tapvpwrvgnd_1
X_6040_ u_pe_array.g_pe_row\[0\].g_pe_col\[1\].u_pe.psum_out\[6\] u_pe_array.g_pe_row\[0\].g_pe_col\[1\].u_pe.move_reg\[6\]
+ _2469_ VGND VGND VPWR VPWR _2862_ sky130_fd_sc_hd__mux2_1
XTAP_435 VGND VPWR sky130_fd_sc_hd__tapvpwrvgnd_1
XTAP_446 VGND VPWR sky130_fd_sc_hd__tapvpwrvgnd_1
XTAP_457 VGND VPWR sky130_fd_sc_hd__tapvpwrvgnd_1
XANTENNA__7299__RESET_B net817 VGND VGND VPWR VPWR sky130_fd_sc_hd__diode_2
XANTENNA__3648__A3 _0864_ VGND VGND VPWR VPWR sky130_fd_sc_hd__diode_2
XTAP_468 VGND VPWR sky130_fd_sc_hd__tapvpwrvgnd_1
XTAP_479 VGND VPWR sky130_fd_sc_hd__tapvpwrvgnd_1
XANTENNA__6047__B2 _0722_ VGND VGND VPWR VPWR sky130_fd_sc_hd__diode_2
XANTENNA__7228__RESET_B net813 VGND VGND VPWR VPWR sky130_fd_sc_hd__diode_2
XANTENNA__4058__B1 _1144_ VGND VGND VPWR VPWR sky130_fd_sc_hd__diode_2
XFILLER_0_76_402 VGND VGND VPWR VPWR sky130_fd_sc_hd__fill_2
XFILLER_0_44_62 VGND VGND VPWR VPWR sky130_fd_sc_hd__fill_1
X_6942_ clknet_leaf_76_clk net82 net815 VGND VGND VPWR VPWR u_pe_array.g_pe_row\[3\].g_pe_col\[3\].u_pe.w_reg\[1\]
+ sky130_fd_sc_hd__dfrtp_1
X_6873_ _3419_ VGND VGND VPWR VPWR _0697_ sky130_fd_sc_hd__clkbuf_1
XANTENNA__3660__B1_N _0869_ VGND VGND VPWR VPWR sky130_fd_sc_hd__diode_2
X_5824_ _2611_ u_pe_array.g_pe_row\[0\].g_pe_col\[3\].u_pe.psum_out\[8\] VGND VGND
+ VPWR VPWR _2687_ sky130_fd_sc_hd__nand2_1
XFILLER_0_60_83 VGND VGND VPWR VPWR sky130_fd_sc_hd__fill_1
XANTENNA__5556__S _0769_ VGND VGND VPWR VPWR sky130_fd_sc_hd__diode_2
X_5755_ _2619_ _2623_ VGND VGND VPWR VPWR _2624_ sky130_fd_sc_hd__xor2_1
XFILLER_0_97_3 VPWR VGND VPWR VGND sky130_ef_sc_hd__decap_12
X_5686_ u_pe_array.g_pe_row\[1\].g_pe_col\[0\].u_pe.psum_out\[10\] _2478_ VGND VGND
+ VPWR VPWR _2575_ sky130_fd_sc_hd__or2_1
X_4706_ _1672_ u_pe_array.g_pe_row\[2\].g_pe_col\[1\].u_pe.psum_out\[8\] VGND VGND
+ VPWR VPWR _1750_ sky130_fd_sc_hd__nand2_1
XANTENNA__4781__B2 _0747_ VGND VGND VPWR VPWR sky130_fd_sc_hd__diode_2
XANTENNA__4781__A1 _1787_ VGND VGND VPWR VPWR sky130_fd_sc_hd__diode_2
XFILLER_0_114_253 VPWR VGND VPWR VGND sky130_ef_sc_hd__decap_12
X_4637_ _1679_ _1685_ _0885_ VGND VGND VPWR VPWR _1687_ sky130_fd_sc_hd__o21a_1
XFILLER_0_71_184 VGND VGND VPWR VPWR sky130_fd_sc_hd__fill_2
X_7425_ clknet_leaf_6_clk _0474_ net74 VGND VGND VPWR VPWR u_pe_array.u_fifo2.wr_ptr\[2\]
+ sky130_fd_sc_hd__dfrtp_1
XFILLER_0_8_40 VGND VGND VPWR VPWR sky130_fd_sc_hd__fill_2
XANTENNA__4533__A1 _1273_ VGND VGND VPWR VPWR sky130_fd_sc_hd__diode_2
Xhold620 u_pe_array.g_pe_row\[0\].g_pe_col\[3\].u_pe.act_val\[4\] VGND VGND VPWR VPWR
+ net696 sky130_fd_sc_hd__dlygate4sd3_1
Xhold631 u_pe_array.g_pe_row\[2\].g_pe_col\[0\].u_pe.act_val\[1\] VGND VGND VPWR VPWR
+ net707 sky130_fd_sc_hd__dlygate4sd3_1
Xhold642 u_pe_array.g_pe_row\[0\].g_pe_col\[2\].u_pe.psum_out\[10\] VGND VGND VPWR
+ VPWR net718 sky130_fd_sc_hd__dlygate4sd3_1
X_7356_ clknet_leaf_65_clk _0411_ net818 VGND VGND VPWR VPWR u_pe_array.g_pe_row\[0\].g_pe_col\[2\].u_pe.psum_out\[10\]
+ sky130_fd_sc_hd__dfrtp_2
XFILLER_0_12_251 VGND VGND VPWR VPWR sky130_fd_sc_hd__fill_1
Xhold653 u_pe_array.g_pe_row\[3\].g_pe_col\[2\].u_pe.act_val\[4\] VGND VGND VPWR VPWR
+ net729 sky130_fd_sc_hd__dlygate4sd3_1
X_4568_ _0914_ _1636_ _1637_ _0861_ _1633_ VGND VGND VPWR VPWR _0174_ sky130_fd_sc_hd__o32ai_1
Xhold686 u_pe_array.g_pe_row\[0\].g_pe_col\[1\].u_pe.psum_out\[4\] VGND VGND VPWR
+ VPWR net762 sky130_fd_sc_hd__dlygate4sd3_1
X_6307_ u_pe_array.g_pe_row\[0\].g_pe_col\[0\].u_pe.psum_out\[11\] _2992_ VGND VGND
+ VPWR VPWR _3094_ sky130_fd_sc_hd__and2b_1
Xhold675 u_pe_array.g_pe_row\[1\].g_pe_col\[1\].u_pe.psum_out\[4\] VGND VGND VPWR
+ VPWR net751 sky130_fd_sc_hd__dlygate4sd3_1
X_3519_ u_pe_array.g_pe_row\[1\].g_pe_col\[0\].u_pe.move_reg\[8\] _0770_ VGND VGND
+ VPWR VPWR _0773_ sky130_fd_sc_hd__or2_1
X_7287_ clknet_leaf_59_clk _0346_ net813 VGND VGND VPWR VPWR u_pe_array.g_pe_row\[1\].g_pe_col\[0\].u_pe.psum_out\[1\]
+ sky130_fd_sc_hd__dfrtp_1
Xhold697 u_fsm.cnt\[3\] VGND VGND VPWR VPWR net773 sky130_fd_sc_hd__dlygate4sd3_1
Xhold664 u_pe_array.g_pe_row\[2\].g_pe_col\[2\].u_pe.act_val\[4\] VGND VGND VPWR VPWR
+ net740 sky130_fd_sc_hd__dlygate4sd3_1
X_4499_ _1573_ _1574_ VGND VGND VPWR VPWR _1575_ sky130_fd_sc_hd__or2_1
XANTENNA__3804__S _0745_ VGND VGND VPWR VPWR sky130_fd_sc_hd__diode_2
X_6238_ _3030_ _3031_ VGND VGND VPWR VPWR _3032_ sky130_fd_sc_hd__nand2_1
X_6169_ _2964_ _2966_ _2972_ VGND VGND VPWR VPWR _2974_ sky130_fd_sc_hd__a21oi_2
XTAP_980 VGND VPWR sky130_fd_sc_hd__tapvpwrvgnd_1
XFILLER_0_99_527 VGND VGND VPWR VPWR sky130_fd_sc_hd__fill_2
XTAP_991 VGND VPWR sky130_fd_sc_hd__tapvpwrvgnd_1
XFILLER_0_79_262 VGND VGND VPWR VPWR sky130_fd_sc_hd__decap_4
XANTENNA__5261__A2 _1714_ VGND VGND VPWR VPWR sky130_fd_sc_hd__diode_2
XANTENNA__6850__S _3397_ VGND VGND VPWR VPWR sky130_fd_sc_hd__diode_2
XFILLER_0_54_118 VGND VGND VPWR VPWR sky130_fd_sc_hd__decap_3
XFILLER_0_48_660 VGND VGND VPWR VPWR sky130_fd_sc_hd__decap_3
XANTENNA__5974__B _2743_ VGND VGND VPWR VPWR sky130_fd_sc_hd__diode_2
XFILLER_0_82_438 VGND VGND VPWR VPWR sky130_fd_sc_hd__fill_2
XFILLER_0_35_310 VGND VGND VPWR VPWR sky130_fd_sc_hd__fill_2
XANTENNA__6151__A _2873_ VGND VGND VPWR VPWR sky130_fd_sc_hd__diode_2
Xclkbuf_leaf_20_clk clknet_3_2__leaf_clk VGND VGND VPWR VPWR clknet_leaf_20_clk sky130_fd_sc_hd__clkbuf_16
XANTENNA__4772__B2 _0747_ VGND VGND VPWR VPWR sky130_fd_sc_hd__diode_2
XANTENNA__4772__A1 _1787_ VGND VGND VPWR VPWR sky130_fd_sc_hd__diode_2
XFILLER_0_105_253 VGND VGND VPWR VPWR sky130_fd_sc_hd__fill_2
XFILLER_0_105_220 VGND VGND VPWR VPWR sky130_fd_sc_hd__fill_2
XFILLER_0_50_313 VGND VGND VPWR VPWR sky130_fd_sc_hd__fill_1
XFILLER_0_23_549 VGND VGND VPWR VPWR sky130_fd_sc_hd__fill_2
XFILLER_0_35_387 VGND VGND VPWR VPWR sky130_fd_sc_hd__fill_2
XFILLER_0_105_264 VPWR VGND VPWR VGND sky130_ef_sc_hd__decap_12
XFILLER_0_62_195 VGND VGND VPWR VPWR sky130_fd_sc_hd__fill_1
XFILLER_0_31_593 VGND VGND VPWR VPWR sky130_fd_sc_hd__fill_2
XFILLER_0_65_39 VPWR VGND VPWR VGND sky130_ef_sc_hd__decap_12
XANTENNA__7392__RESET_B net818 VGND VGND VPWR VPWR sky130_fd_sc_hd__diode_2
XANTENNA__5214__B _2158_ VGND VGND VPWR VPWR sky130_fd_sc_hd__diode_2
Xclkbuf_leaf_87_clk clknet_3_1__leaf_clk VGND VGND VPWR VPWR clknet_leaf_87_clk sky130_fd_sc_hd__clkbuf_16
XANTENNA__7321__RESET_B net814 VGND VGND VPWR VPWR sky130_fd_sc_hd__diode_2
XFILLER_0_98_560 VGND VGND VPWR VPWR sky130_fd_sc_hd__fill_2
XFILLER_0_98_593 VGND VGND VPWR VPWR sky130_fd_sc_hd__fill_1
XFILLER_0_98_571 VPWR VGND VPWR VGND sky130_ef_sc_hd__decap_12
XFILLER_0_46_608 VGND VGND VPWR VPWR sky130_fd_sc_hd__decap_3
XFILLER_0_85_276 VGND VGND VPWR VPWR sky130_fd_sc_hd__fill_2
XFILLER_0_46_619 VGND VGND VPWR VPWR sky130_fd_sc_hd__fill_2
XFILLER_0_45_118 VGND VGND VPWR VPWR sky130_fd_sc_hd__fill_2
X_3870_ _1042_ _1043_ _1056_ VGND VGND VPWR VPWR _1057_ sky130_fd_sc_hd__o21a_1
XFILLER_0_73_449 VGND VGND VPWR VPWR sky130_fd_sc_hd__fill_2
XFILLER_0_66_490 VGND VGND VPWR VPWR sky130_fd_sc_hd__decap_8
X_5540_ u_pe_array.g_pe_row\[1\].g_pe_col\[1\].u_pe.psum_out\[9\] u_pe_array.g_pe_row\[1\].g_pe_col\[1\].u_pe.psum_out\[10\]
+ _2345_ VGND VGND VPWR VPWR _2455_ sky130_fd_sc_hd__o21a_1
Xclkbuf_leaf_11_clk clknet_3_1__leaf_clk VGND VGND VPWR VPWR clknet_leaf_11_clk sky130_fd_sc_hd__clkbuf_16
XANTENNA__4280__S _0769_ VGND VGND VPWR VPWR sky130_fd_sc_hd__diode_2
XFILLER_0_14_505 VGND VGND VPWR VPWR sky130_fd_sc_hd__fill_2
XANTENNA__4763__A1 _1787_ VGND VGND VPWR VPWR sky130_fd_sc_hd__diode_2
XANTENNA__4763__B2 _0747_ VGND VGND VPWR VPWR sky130_fd_sc_hd__diode_2
X_5471_ _2391_ _2392_ VGND VGND VPWR VPWR _2393_ sky130_fd_sc_hd__nor2_1
XFILLER_0_111_201 VGND VGND VPWR VPWR sky130_fd_sc_hd__fill_1
X_7210_ clknet_leaf_82_clk _0275_ net73 VGND VGND VPWR VPWR u_pe_array.g_pe_row\[1\].g_pe_col\[2\].u_pe.w_buffer\[1\]
+ sky130_fd_sc_hd__dfrtp_1
XFILLER_0_41_335 VGND VGND VPWR VPWR sky130_fd_sc_hd__fill_1
X_4422_ net91 u_pe_array.g_pe_row\[2\].g_pe_col\[2\].u_pe.w_buffer\[1\] _0828_ VGND
+ VGND VPWR VPWR _1516_ sky130_fd_sc_hd__mux2_1
XANTENNA__5712__B1 _2592_ VGND VGND VPWR VPWR sky130_fd_sc_hd__diode_2
XFILLER_0_111_278 VGND VGND VPWR VPWR sky130_fd_sc_hd__fill_2
X_4353_ _1441_ _1443_ VGND VGND VPWR VPWR _1456_ sky130_fd_sc_hd__nand2_1
X_7141_ clknet_leaf_9_clk _0210_ VGND VGND VPWR VPWR u_pe_array.u_fifo2.buffer\[8\]\[5\]
+ sky130_fd_sc_hd__dfxtp_1
XANTENNA__7409__RESET_B net813 VGND VGND VPWR VPWR sky130_fd_sc_hd__diode_2
XTAP_232 VGND VPWR sky130_fd_sc_hd__tapvpwrvgnd_1
X_4284_ u_pe_array.g_pe_row\[2\].g_pe_col\[3\].u_pe.psum_out\[7\] net808 _0855_ VGND
+ VGND VPWR VPWR _1398_ sky130_fd_sc_hd__mux2_1
X_7072_ clknet_leaf_88_clk _0145_ net74 VGND VGND VPWR VPWR u_pe_array.g_pe_row\[2\].g_pe_col\[3\].u_pe.psum_out\[9\]
+ sky130_fd_sc_hd__dfrtp_1
X_6023_ net438 _2387_ _2174_ _2853_ VGND VGND VPWR VPWR _0413_ sky130_fd_sc_hd__a22o_1
XANTENNA__4279__B1 _1258_ VGND VGND VPWR VPWR sky130_fd_sc_hd__diode_2
XTAP_254 VGND VPWR sky130_fd_sc_hd__tapvpwrvgnd_1
XTAP_243 VGND VPWR sky130_fd_sc_hd__tapvpwrvgnd_1
XTAP_265 VGND VPWR sky130_fd_sc_hd__tapvpwrvgnd_1
XTAP_298 VGND VPWR sky130_fd_sc_hd__tapvpwrvgnd_1
XTAP_287 VGND VPWR sky130_fd_sc_hd__tapvpwrvgnd_1
XANTENNA__7062__RESET_B net815 VGND VGND VPWR VPWR sky130_fd_sc_hd__diode_2
XTAP_276 VGND VPWR sky130_fd_sc_hd__tapvpwrvgnd_1
Xclkbuf_leaf_78_clk clknet_3_4__leaf_clk VGND VGND VPWR VPWR clknet_leaf_78_clk sky130_fd_sc_hd__clkbuf_16
XFILLER_0_55_61 VGND VGND VPWR VPWR sky130_fd_sc_hd__decap_3
XFILLER_0_96_508 VGND VGND VPWR VPWR sky130_fd_sc_hd__fill_2
XTAP_1409 VGND VPWR sky130_fd_sc_hd__tapvpwrvgnd_1
X_6925_ clknet_leaf_60_clk u_fsm.next_state\[2\] net816 VGND VGND VPWR VPWR u_fsm.state\[2\]
+ sky130_fd_sc_hd__dfrtp_1
XFILLER_0_49_413 VGND VGND VPWR VPWR sky130_fd_sc_hd__fill_2
XFILLER_0_12_3 VPWR VGND VPWR VGND sky130_ef_sc_hd__decap_12
XFILLER_0_76_243 VGND VGND VPWR VPWR sky130_fd_sc_hd__fill_2
XFILLER_0_76_232 VGND VGND VPWR VPWR sky130_fd_sc_hd__decap_3
X_6856_ net258 _3134_ _3397_ VGND VGND VPWR VPWR _3410_ sky130_fd_sc_hd__mux2_1
XFILLER_0_71_82 VGND VGND VPWR VPWR sky130_fd_sc_hd__decap_3
XFILLER_0_64_427 VGND VGND VPWR VPWR sky130_fd_sc_hd__fill_1
X_6787_ net283 _3122_ _3366_ VGND VGND VPWR VPWR _3373_ sky130_fd_sc_hd__mux2_1
X_3999_ _1159_ _1160_ VGND VGND VPWR VPWR _1161_ sky130_fd_sc_hd__xor2_1
XFILLER_0_64_438 VGND VGND VPWR VPWR sky130_fd_sc_hd__fill_2
XFILLER_0_57_490 VGND VGND VPWR VPWR sky130_fd_sc_hd__fill_2
XFILLER_0_17_321 VGND VGND VPWR VPWR sky130_fd_sc_hd__decap_4
X_5807_ _2648_ _2658_ _2659_ VGND VGND VPWR VPWR _2672_ sky130_fd_sc_hd__o21a_1
XFILLER_0_60_600 VGND VGND VPWR VPWR sky130_fd_sc_hd__decap_4
X_5738_ _2608_ VGND VGND VPWR VPWR _2609_ sky130_fd_sc_hd__inv_2
XFILLER_0_60_622 VGND VGND VPWR VPWR sky130_fd_sc_hd__decap_4
X_5669_ u_pe_array.g_pe_row\[1\].g_pe_col\[0\].u_pe.psum_out\[8\] _2545_ VGND VGND
+ VPWR VPWR _2560_ sky130_fd_sc_hd__nor2_1
XFILLER_0_102_245 VGND VGND VPWR VPWR sky130_fd_sc_hd__decap_4
XANTENNA__5703__B1 _2174_ VGND VGND VPWR VPWR sky130_fd_sc_hd__diode_2
X_7408_ clknet_leaf_40_clk _0458_ net817 VGND VGND VPWR VPWR u_pe_array.g_pe_row\[0\].g_pe_col\[0\].u_pe.psum_out\[12\]
+ sky130_fd_sc_hd__dfrtp_1
X_7339_ clknet_leaf_47_clk _0396_ net812 VGND VGND VPWR VPWR u_pe_array.g_pe_row\[0\].g_pe_col\[1\].u_pe.move_reg\[8\]
+ sky130_fd_sc_hd__dfrtp_1
XFILLER_0_13_582 VGND VGND VPWR VPWR sky130_fd_sc_hd__fill_2
Xhold450 u_pe_array.u_fifo2.buffer\[8\]\[0\] VGND VGND VPWR VPWR net526 sky130_fd_sc_hd__dlygate4sd3_1
Xhold472 u_pe_array.g_pe_row\[3\].g_pe_col\[2\].u_pe.psum_out\[11\] VGND VGND VPWR
+ VPWR net548 sky130_fd_sc_hd__dlygate4sd3_1
Xhold461 u_pe_array.u_fifo2.buffer\[7\]\[3\] VGND VGND VPWR VPWR net537 sky130_fd_sc_hd__dlygate4sd3_1
Xhold494 u_pe_array.g_pe_row\[3\].g_pe_col\[0\].u_pe.psum_out\[12\] VGND VGND VPWR
+ VPWR net570 sky130_fd_sc_hd__dlygate4sd3_1
Xhold483 u_pe_array.g_pe_row\[1\].g_pe_col\[1\].u_pe.psum_out\[1\] VGND VGND VPWR
+ VPWR net559 sky130_fd_sc_hd__dlygate4sd3_1
Xclkbuf_leaf_69_clk clknet_3_5__leaf_clk VGND VGND VPWR VPWR clknet_leaf_69_clk sky130_fd_sc_hd__clkbuf_16
XFILLER_0_99_335 VGND VGND VPWR VPWR sky130_fd_sc_hd__fill_1
XANTENNA__6431__A1 _1820_ VGND VGND VPWR VPWR sky130_fd_sc_hd__diode_2
XFILLER_0_95_541 VGND VGND VPWR VPWR sky130_fd_sc_hd__fill_2
XFILLER_0_51_19 VGND VGND VPWR VPWR sky130_fd_sc_hd__fill_1
XANTENNA__4993__A1 _0836_ VGND VGND VPWR VPWR sky130_fd_sc_hd__diode_2
XFILLER_0_27_129 VGND VGND VPWR VPWR sky130_fd_sc_hd__decap_3
XFILLER_0_70_419 VGND VGND VPWR VPWR sky130_fd_sc_hd__fill_1
XFILLER_0_23_324 VGND VGND VPWR VPWR sky130_fd_sc_hd__decap_4
XFILLER_0_106_562 VPWR VGND VPWR VGND sky130_ef_sc_hd__decap_12
XFILLER_0_23_335 VGND VGND VPWR VPWR sky130_fd_sc_hd__fill_1
XANTENNA__6498__A1 _1806_ VGND VGND VPWR VPWR sky130_fd_sc_hd__diode_2
XFILLER_0_50_187 VGND VGND VPWR VPWR sky130_fd_sc_hd__fill_2
XFILLER_0_76_27 VGND VGND VPWR VPWR sky130_fd_sc_hd__fill_1
XFILLER_0_92_26 VGND VGND VPWR VPWR sky130_fd_sc_hd__fill_2
Xclkbuf_leaf_0_clk clknet_3_0__leaf_clk VGND VGND VPWR VPWR clknet_leaf_0_clk sky130_fd_sc_hd__clkbuf_16
XANTENNA__4433__B1 _1258_ VGND VGND VPWR VPWR sky130_fd_sc_hd__diode_2
X_4971_ u_pe_array.u_fifo2.buffer\[4\]\[0\] _1965_ _1966_ u_pe_array.u_fifo2.buffer\[7\]\[0\]
+ VGND VGND VPWR VPWR _1967_ sky130_fd_sc_hd__a22o_1
X_6710_ net273 _3126_ net66 VGND VGND VPWR VPWR _3333_ sky130_fd_sc_hd__mux2_1
XANTENNA__4984__A1 _0836_ VGND VGND VPWR VPWR sky130_fd_sc_hd__diode_2
XANTENNA__6490__S _3208_ VGND VGND VPWR VPWR sky130_fd_sc_hd__diode_2
X_3922_ u_pe_array.g_pe_row\[3\].g_pe_col\[2\].u_pe.psum_out\[10\] _1009_ VGND VGND
+ VPWR VPWR _1104_ sky130_fd_sc_hd__nand2_1
XANTENNA__6186__A0 net28 VGND VGND VPWR VPWR sky130_fd_sc_hd__diode_2
XFILLER_0_46_438 VGND VGND VPWR VPWR sky130_fd_sc_hd__fill_2
X_3853_ _1040_ _1009_ u_pe_array.g_pe_row\[3\].g_pe_col\[2\].u_pe.psum_out\[4\] VGND
+ VGND VPWR VPWR _1041_ sky130_fd_sc_hd__a21oi_1
X_6641_ net650 _0833_ VGND VGND VPWR VPWR _3290_ sky130_fd_sc_hd__and2_1
XFILLER_0_61_408 VGND VGND VPWR VPWR sky130_fd_sc_hd__decap_8
XFILLER_0_6_513 VPWR VGND VPWR VGND sky130_ef_sc_hd__decap_12
XFILLER_0_73_279 VGND VGND VPWR VPWR sky130_fd_sc_hd__fill_1
X_6572_ _3253_ VGND VGND VPWR VPWR _3254_ sky130_fd_sc_hd__buf_4
XFILLER_0_42_622 VGND VGND VPWR VPWR sky130_fd_sc_hd__fill_2
XFILLER_0_6_557 VPWR VGND VPWR VGND sky130_ef_sc_hd__decap_12
XFILLER_0_26_151 VGND VGND VPWR VPWR sky130_fd_sc_hd__fill_2
X_3784_ u_pe_array.g_pe_row\[3\].g_pe_col\[2\].u_pe.psum_out\[1\] u_pe_array.g_pe_row\[3\].g_pe_col\[2\].u_pe.act_val\[1\]
+ _0745_ VGND VGND VPWR VPWR _0988_ sky130_fd_sc_hd__mux2_2
X_5523_ _2345_ u_pe_array.g_pe_row\[1\].g_pe_col\[1\].u_pe.psum_out\[10\] VGND VGND
+ VPWR VPWR _2440_ sky130_fd_sc_hd__nand2_1
XFILLER_0_26_195 VGND VGND VPWR VPWR sky130_fd_sc_hd__fill_1
X_5454_ _2345_ _2376_ u_pe_array.g_pe_row\[1\].g_pe_col\[1\].u_pe.act_val\[4\] u_pe_array.g_pe_row\[1\].g_pe_col\[1\].u_pe.w_reg\[0\]
+ VGND VGND VPWR VPWR _2377_ sky130_fd_sc_hd__a22o_1
X_5385_ u_pe_array.u_fifo1.buffer\[1\]\[4\] _2278_ _2318_ _2320_ VGND VGND VPWR VPWR
+ _2321_ sky130_fd_sc_hd__a211o_1
X_4405_ _1496_ _1501_ _0914_ VGND VGND VPWR VPWR _1503_ sky130_fd_sc_hd__a21o_1
XFILLER_0_112_587 VGND VGND VPWR VPWR sky130_fd_sc_hd__fill_1
X_7124_ clknet_leaf_35_clk _0193_ net76 VGND VGND VPWR VPWR u_pe_array.g_pe_row\[2\].g_pe_col\[1\].u_pe.psum_out\[1\]
+ sky130_fd_sc_hd__dfrtp_1
XANTENNA__7243__RESET_B net813 VGND VGND VPWR VPWR sky130_fd_sc_hd__diode_2
X_4336_ u_pe_array.g_pe_row\[2\].g_pe_col\[3\].u_pe.w_reg\[0\] u_pe_array.g_pe_row\[2\].g_pe_col\[3\].u_pe.act_val\[4\]
+ _1437_ _1438_ VGND VGND VPWR VPWR _1440_ sky130_fd_sc_hd__o2bb2a_1
XFILLER_0_1_273 VGND VGND VPWR VPWR sky130_fd_sc_hd__decap_3
X_4267_ net89 net698 _0828_ VGND VGND VPWR VPWR _1389_ sky130_fd_sc_hd__mux2_1
X_7055_ clknet_leaf_88_clk _0130_ net819 VGND VGND VPWR VPWR u_pe_array.g_pe_row\[2\].g_pe_col\[2\].u_pe.move_reg\[7\]
+ sky130_fd_sc_hd__dfrtp_1
X_4198_ u_pe_array.g_pe_row\[3\].g_pe_col\[0\].u_pe.psum_out\[5\] _1319_ _1327_ VGND
+ VGND VPWR VPWR _1328_ sky130_fd_sc_hd__a21o_1
XFILLER_0_66_93 VGND VGND VPWR VPWR sky130_fd_sc_hd__decap_3
X_6006_ u_pe_array.g_pe_row\[0\].g_pe_col\[2\].u_pe.psum_out\[10\] _2743_ VGND VGND
+ VPWR VPWR _2839_ sky130_fd_sc_hd__or2_1
XFILLER_0_96_349 VGND VGND VPWR VPWR sky130_fd_sc_hd__fill_1
XTAP_1239 VGND VPWR sky130_fd_sc_hd__tapvpwrvgnd_1
XTAP_1228 VGND VPWR sky130_fd_sc_hd__tapvpwrvgnd_1
XTAP_1217 VGND VPWR sky130_fd_sc_hd__tapvpwrvgnd_1
XTAP_1206 VGND VPWR sky130_fd_sc_hd__tapvpwrvgnd_1
XFILLER_0_49_221 VGND VGND VPWR VPWR sky130_fd_sc_hd__decap_3
X_6908_ net240 _3130_ _3427_ VGND VGND VPWR VPWR _3438_ sky130_fd_sc_hd__mux2_1
XFILLER_0_49_276 VGND VGND VPWR VPWR sky130_fd_sc_hd__fill_2
XFILLER_0_92_533 VGND VGND VPWR VPWR sky130_fd_sc_hd__fill_2
X_6839_ _3401_ VGND VGND VPWR VPWR _0681_ sky130_fd_sc_hd__clkbuf_1
XFILLER_0_64_213 VGND VGND VPWR VPWR sky130_fd_sc_hd__fill_2
XFILLER_0_9_351 VGND VGND VPWR VPWR sky130_fd_sc_hd__fill_2
XFILLER_0_37_449 VGND VGND VPWR VPWR sky130_fd_sc_hd__fill_2
XFILLER_0_45_482 VGND VGND VPWR VPWR sky130_fd_sc_hd__fill_2
XFILLER_0_33_600 VGND VGND VPWR VPWR sky130_fd_sc_hd__fill_1
XFILLER_0_72_290 VGND VGND VPWR VPWR sky130_fd_sc_hd__fill_2
XFILLER_0_60_441 VGND VGND VPWR VPWR sky130_fd_sc_hd__decap_3
XFILLER_0_17_184 VGND VGND VPWR VPWR sky130_fd_sc_hd__fill_1
XANTENNA__3950__A2 _0996_ VGND VGND VPWR VPWR sky130_fd_sc_hd__diode_2
XFILLER_0_60_452 VGND VGND VPWR VPWR sky130_fd_sc_hd__fill_1
XFILLER_0_60_485 VGND VGND VPWR VPWR sky130_fd_sc_hd__decap_4
Xhold280 u_pe_array.u_fifo1.buffer\[4\]\[9\] VGND VGND VPWR VPWR net356 sky130_fd_sc_hd__dlygate4sd3_1
XFILLER_0_1_3 VPWR VGND VPWR VGND sky130_ef_sc_hd__decap_12
Xhold291 u_pe_array.u_fifo2.buffer\[8\]\[10\] VGND VGND VPWR VPWR net367 sky130_fd_sc_hd__dlygate4sd3_1
XANTENNA__6575__S _3254_ VGND VGND VPWR VPWR sky130_fd_sc_hd__diode_2
XANTENNA__6966__RESET_B net818 VGND VGND VPWR VPWR sky130_fd_sc_hd__diode_2
XANTENNA_clkbuf_leaf_64_clk_A clknet_3_5__leaf_clk VGND VGND VPWR VPWR sky130_fd_sc_hd__diode_2
XFILLER_0_87_349 VPWR VGND VPWR VGND sky130_ef_sc_hd__decap_12
XFILLER_0_62_29 VPWR VGND VPWR VGND sky130_ef_sc_hd__decap_12
XANTENNA__4415__B1 _1407_ VGND VGND VPWR VPWR sky130_fd_sc_hd__diode_2
XFILLER_0_83_500 VGND VGND VPWR VPWR sky130_fd_sc_hd__fill_2
XFILLER_0_28_416 VGND VGND VPWR VPWR sky130_fd_sc_hd__fill_2
XFILLER_0_83_533 VGND VGND VPWR VPWR sky130_fd_sc_hd__fill_1
XFILLER_0_55_213 VGND VGND VPWR VPWR sky130_fd_sc_hd__fill_2
XANTENNA_clkbuf_leaf_79_clk_A clknet_3_4__leaf_clk VGND VGND VPWR VPWR sky130_fd_sc_hd__diode_2
XFILLER_0_36_460 VGND VGND VPWR VPWR sky130_fd_sc_hd__fill_1
XFILLER_0_70_249 VGND VGND VPWR VPWR sky130_fd_sc_hd__decap_3
XFILLER_0_3_505 VPWR VGND VPWR VGND sky130_ef_sc_hd__decap_12
XFILLER_0_23_110 VGND VGND VPWR VPWR sky130_fd_sc_hd__fill_2
XFILLER_0_87_15 VGND VGND VPWR VPWR sky130_fd_sc_hd__fill_1
XFILLER_0_11_327 VGND VGND VPWR VPWR sky130_fd_sc_hd__decap_6
XANTENNA__6340__B1 net57 VGND VGND VPWR VPWR sky130_fd_sc_hd__diode_2
XANTENNA_clkbuf_leaf_17_clk_A clknet_3_2__leaf_clk VGND VGND VPWR VPWR sky130_fd_sc_hd__diode_2
X_5170_ u_pe_array.g_pe_row\[0\].g_pe_col\[2\].u_pe.w_buffer\[1\] net802 _0828_ VGND
+ VGND VPWR VPWR _2139_ sky130_fd_sc_hd__mux2_1
X_4121_ net172 _1138_ _1263_ _1004_ VGND VGND VPWR VPWR _0101_ sky130_fd_sc_hd__a22o_1
X_4052_ net563 _1152_ _1207_ _1209_ VGND VGND VPWR VPWR _0086_ sky130_fd_sc_hd__a22o_1
Xinput4 h_in0[3] VGND VGND VPWR VPWR net4 sky130_fd_sc_hd__buf_1
XFILLER_0_59_541 VGND VGND VPWR VPWR sky130_fd_sc_hd__decap_6
X_4954_ _1938_ _1943_ _1949_ _1952_ _1948_ VGND VGND VPWR VPWR _1953_ sky130_fd_sc_hd__a32o_1
XFILLER_0_19_416 VGND VGND VPWR VPWR sky130_fd_sc_hd__fill_1
X_3905_ u_pe_array.g_pe_row\[3\].g_pe_col\[2\].u_pe.psum_out\[8\] _1009_ VGND VGND
+ VPWR VPWR _1089_ sky130_fd_sc_hd__or2_1
X_4885_ _1889_ _1890_ VGND VGND VPWR VPWR _1891_ sky130_fd_sc_hd__xnor2_1
X_6624_ _3281_ VGND VGND VPWR VPWR _0586_ sky130_fd_sc_hd__clkbuf_1
X_3836_ _1019_ _1021_ VGND VGND VPWR VPWR _1025_ sky130_fd_sc_hd__nand2_1
XFILLER_0_34_419 VGND VGND VPWR VPWR sky130_fd_sc_hd__fill_1
XFILLER_0_6_376 VGND VGND VPWR VPWR sky130_fd_sc_hd__fill_2
XFILLER_0_6_365 VGND VGND VPWR VPWR sky130_fd_sc_hd__fill_2
X_3767_ _0974_ _0975_ VGND VGND VPWR VPWR _0976_ sky130_fd_sc_hd__or2_1
X_6555_ net455 _1806_ _3239_ VGND VGND VPWR VPWR _3245_ sky130_fd_sc_hd__mux2_1
X_5506_ u_pe_array.g_pe_row\[1\].g_pe_col\[1\].u_pe.psum_out\[8\] u_pe_array.g_pe_row\[1\].g_pe_col\[1\].u_pe.psum_out\[7\]
+ _2345_ VGND VGND VPWR VPWR _2425_ sky130_fd_sc_hd__and3b_1
XANTENNA__7424__RESET_B net74 VGND VGND VPWR VPWR sky130_fd_sc_hd__diode_2
X_6486_ _3207_ VGND VGND VPWR VPWR _0522_ sky130_fd_sc_hd__clkbuf_1
X_3698_ net72 VGND VGND VPWR VPWR _0914_ sky130_fd_sc_hd__buf_12
XFILLER_0_42_485 VGND VGND VPWR VPWR sky130_fd_sc_hd__fill_2
XANTENNA__6331__B1 net54 VGND VGND VPWR VPWR sky130_fd_sc_hd__diode_2
X_5437_ _2353_ _2357_ VGND VGND VPWR VPWR _2361_ sky130_fd_sc_hd__nor2_1
XANTENNA__6882__A1 _3132_ VGND VGND VPWR VPWR sky130_fd_sc_hd__diode_2
X_5368_ u_pe_array.u_fifo1.buffer\[8\]\[2\] _2273_ _2301_ _2305_ _0819_ VGND VGND
+ VPWR VPWR _2306_ sky130_fd_sc_hd__a221o_1
X_7107_ clknet_leaf_39_clk _0178_ net813 VGND VGND VPWR VPWR u_pe_array.g_pe_row\[2\].g_pe_col\[1\].u_pe.w_buffer\[1\]
+ sky130_fd_sc_hd__dfrtp_1
X_5299_ _2242_ _2243_ VGND VGND VPWR VPWR _2245_ sky130_fd_sc_hd__nor2_1
X_4319_ _1420_ _1421_ _1423_ VGND VGND VPWR VPWR _1424_ sky130_fd_sc_hd__o21a_1
X_7038_ clknet_leaf_34_clk _0113_ net76 VGND VGND VPWR VPWR u_pe_array.g_pe_row\[3\].g_pe_col\[0\].u_pe.psum_out\[5\]
+ sky130_fd_sc_hd__dfrtp_1
XFILLER_0_93_80 VGND VGND VPWR VPWR sky130_fd_sc_hd__decap_6
XTAP_1003 VGND VPWR sky130_fd_sc_hd__tapvpwrvgnd_1
XTAP_1036 VGND VPWR sky130_fd_sc_hd__tapvpwrvgnd_1
XTAP_1047 VGND VPWR sky130_fd_sc_hd__tapvpwrvgnd_1
XTAP_1025 VGND VPWR sky130_fd_sc_hd__tapvpwrvgnd_1
XTAP_1014 VGND VPWR sky130_fd_sc_hd__tapvpwrvgnd_1
XTAP_1069 VGND VPWR sky130_fd_sc_hd__tapvpwrvgnd_1
XTAP_1058 VGND VPWR sky130_fd_sc_hd__tapvpwrvgnd_1
XFILLER_0_37_213 VGND VGND VPWR VPWR sky130_fd_sc_hd__decap_8
XFILLER_0_108_613 VPWR VGND VPWR VGND sky130_ef_sc_hd__decap_12
XFILLER_0_108_657 VPWR VGND VPWR VGND sky130_ef_sc_hd__decap_12
XFILLER_0_37_268 VGND VGND VPWR VPWR sky130_fd_sc_hd__decap_3
XFILLER_0_52_227 VGND VGND VPWR VPWR sky130_fd_sc_hd__decap_3
XANTENNA__7165__RESET_B net817 VGND VGND VPWR VPWR sky130_fd_sc_hd__diode_2
XFILLER_0_21_636 VGND VGND VPWR VPWR sky130_fd_sc_hd__fill_2
XFILLER_0_21_647 VGND VGND VPWR VPWR sky130_fd_sc_hd__fill_1
XTAP_809 VGND VPWR sky130_fd_sc_hd__tapvpwrvgnd_1
XANTENNA__5503__A _2345_ VGND VGND VPWR VPWR sky130_fd_sc_hd__diode_2
XANTENNA__6625__A1 _1820_ VGND VGND VPWR VPWR sky130_fd_sc_hd__diode_2
XFILLER_0_87_113 VGND VGND VPWR VPWR sky130_fd_sc_hd__decap_3
XFILLER_0_68_371 VGND VGND VPWR VPWR sky130_fd_sc_hd__fill_1
XTAP_1592 VGND VPWR sky130_fd_sc_hd__tapvpwrvgnd_1
XTAP_1581 VGND VPWR sky130_fd_sc_hd__tapvpwrvgnd_1
XTAP_1570 VGND VPWR sky130_fd_sc_hd__tapvpwrvgnd_1
XFILLER_0_28_246 VGND VGND VPWR VPWR sky130_fd_sc_hd__fill_2
XFILLER_0_71_503 VGND VGND VPWR VPWR sky130_fd_sc_hd__fill_1
X_4670_ _1715_ _1716_ VGND VGND VPWR VPWR _1717_ sky130_fd_sc_hd__xnor2_1
XFILLER_0_16_408 VGND VGND VPWR VPWR sky130_fd_sc_hd__decap_8
X_3621_ net26 _0848_ _0819_ VGND VGND VPWR VPWR _0849_ sky130_fd_sc_hd__mux2_1
XFILLER_0_36_290 VGND VGND VPWR VPWR sky130_fd_sc_hd__fill_2
X_6340_ _1787_ _1132_ net57 VGND VGND VPWR VPWR _3120_ sky130_fd_sc_hd__a21o_2
X_3552_ _0779_ u_fsm.cnt\[3\] net14 VGND VGND VPWR VPWR _0798_ sky130_fd_sc_hd__or3b_1
XFILLER_0_3_313 VGND VGND VPWR VPWR sky130_fd_sc_hd__decap_8
XFILLER_0_24_463 VGND VGND VPWR VPWR sky130_fd_sc_hd__fill_1
X_6271_ _3061_ VGND VGND VPWR VPWR _3062_ sky130_fd_sc_hd__inv_2
X_3483_ u_pe_array.g_pe_row\[3\].g_pe_col\[0\].u_pe.psum_out\[8\] _0745_ _0749_ _0747_
+ VGND VGND VPWR VPWR net60 sky130_fd_sc_hd__o211a_2
XANTENNA__6313__B1 _2992_ VGND VGND VPWR VPWR sky130_fd_sc_hd__diode_2
XFILLER_0_12_669 VGND VGND VPWR VPWR sky130_fd_sc_hd__decap_8
X_5222_ _0885_ VGND VGND VPWR VPWR _2174_ sky130_fd_sc_hd__buf_8
X_5153_ _2119_ _2124_ _0913_ VGND VGND VPWR VPWR _2126_ sky130_fd_sc_hd__a21o_1
X_4104_ _1254_ VGND VGND VPWR VPWR _0093_ sky130_fd_sc_hd__clkbuf_1
XFILLER_0_47_73 VGND VGND VPWR VPWR sky130_fd_sc_hd__fill_1
XANTENNA__4627__B1 _1534_ VGND VGND VPWR VPWR sky130_fd_sc_hd__diode_2
X_5084_ _2061_ _2062_ VGND VGND VPWR VPWR _2063_ sky130_fd_sc_hd__nor2_2
XFILLER_0_79_625 VGND VGND VPWR VPWR sky130_fd_sc_hd__decap_3
X_4035_ _1192_ _1193_ VGND VGND VPWR VPWR _1194_ sky130_fd_sc_hd__nor2_1
XFILLER_0_78_124 VGND VGND VPWR VPWR sky130_fd_sc_hd__decap_4
XFILLER_0_2_53 VPWR VGND VPWR VGND sky130_ef_sc_hd__decap_12
XFILLER_0_78_157 VGND VGND VPWR VPWR sky130_fd_sc_hd__fill_1
XFILLER_0_66_319 VGND VGND VPWR VPWR sky130_fd_sc_hd__fill_1
XFILLER_0_2_97 VPWR VGND VPWR VGND sky130_ef_sc_hd__decap_12
XFILLER_0_94_639 VGND VGND VPWR VPWR sky130_fd_sc_hd__fill_2
XFILLER_0_93_127 VGND VGND VPWR VPWR sky130_fd_sc_hd__fill_2
XPHY_119 VGND VGND VPWR VPWR sky130_fd_sc_hd__decap_3
XPHY_108 VGND VGND VPWR VPWR sky130_fd_sc_hd__decap_3
X_5986_ _2802_ _2812_ u_pe_array.g_pe_row\[0\].g_pe_col\[2\].u_pe.psum_out\[7\] _2798_
+ VGND VGND VPWR VPWR _2821_ sky130_fd_sc_hd__o2bb2a_1
XFILLER_0_47_533 VGND VGND VPWR VPWR sky130_fd_sc_hd__fill_2
X_4937_ _1931_ _1932_ _1937_ _1934_ _1928_ VGND VGND VPWR VPWR _1938_ sky130_fd_sc_hd__a32o_1
XFILLER_0_59_393 VGND VGND VPWR VPWR sky130_fd_sc_hd__fill_2
X_4868_ _1864_ _1875_ VGND VGND VPWR VPWR _1876_ sky130_fd_sc_hd__xor2_1
X_7656_ clknet_leaf_22_clk _0705_ VGND VGND VPWR VPWR u_pe_array.u_fifo1.buffer\[7\]\[1\]
+ sky130_fd_sc_hd__dfxtp_1
XFILLER_0_62_503 VGND VGND VPWR VPWR sky130_fd_sc_hd__fill_1
XFILLER_0_7_641 VPWR VGND VPWR VGND sky130_ef_sc_hd__decap_12
X_3819_ u_pe_array.g_pe_row\[3\].g_pe_col\[2\].u_pe.act_val\[0\] _1009_ u_pe_array.g_pe_row\[3\].g_pe_col\[2\].u_pe.psum_out\[1\]
+ VGND VGND VPWR VPWR _1010_ sky130_fd_sc_hd__a21oi_1
X_6607_ net537 _1802_ _3269_ VGND VGND VPWR VPWR _3273_ sky130_fd_sc_hd__mux2_1
X_4799_ net797 VGND VGND VPWR VPWR _0219_ sky130_fd_sc_hd__clkbuf_1
X_7587_ clknet_leaf_27_clk _0636_ VGND VGND VPWR VPWR u_pe_array.u_fifo1.buffer\[1\]\[10\]
+ sky130_fd_sc_hd__dfxtp_1
X_6538_ _3235_ VGND VGND VPWR VPWR _0546_ sky130_fd_sc_hd__clkbuf_1
XFILLER_0_113_671 VGND VGND VPWR VPWR sky130_fd_sc_hd__fill_1
XANTENNA__5307__B _2158_ VGND VGND VPWR VPWR sky130_fd_sc_hd__diode_2
X_6469_ net558 _1804_ net67 VGND VGND VPWR VPWR _3199_ sky130_fd_sc_hd__mux2_1
XFILLER_0_100_365 VGND VGND VPWR VPWR sky130_fd_sc_hd__fill_2
Xmax_cap66 _3324_ VGND VGND VPWR VPWR net66 sky130_fd_sc_hd__buf_2
XFILLER_0_85_617 VGND VGND VPWR VPWR sky130_fd_sc_hd__fill_1
XFILLER_0_69_146 VGND VGND VPWR VPWR sky130_fd_sc_hd__decap_4
XANTENNA__7346__RESET_B net13 VGND VGND VPWR VPWR sky130_fd_sc_hd__diode_2
XFILLER_0_53_569 VGND VGND VPWR VPWR sky130_fd_sc_hd__fill_1
XFILLER_0_0_305 VGND VGND VPWR VPWR sky130_fd_sc_hd__fill_1
XFILLER_0_0_327 VGND VGND VPWR VPWR sky130_fd_sc_hd__decap_8
XANTENNA__5649__A2 _2387_ VGND VGND VPWR VPWR sky130_fd_sc_hd__diode_2
XANTENNA__6981__RESET_B net74 VGND VGND VPWR VPWR sky130_fd_sc_hd__diode_2
XFILLER_0_0_349 VPWR VGND VPWR VGND sky130_ef_sc_hd__decap_12
XTAP_606 VGND VPWR sky130_fd_sc_hd__tapvpwrvgnd_1
XTAP_617 VGND VPWR sky130_fd_sc_hd__tapvpwrvgnd_1
XTAP_628 VGND VPWR sky130_fd_sc_hd__tapvpwrvgnd_1
XTAP_639 VGND VPWR sky130_fd_sc_hd__tapvpwrvgnd_1
XFILLER_0_17_54 VGND VGND VPWR VPWR sky130_fd_sc_hd__fill_2
XFILLER_0_108_89 VGND VGND VPWR VPWR sky130_fd_sc_hd__fill_1
XANTENNA__5282__B1 _2071_ VGND VGND VPWR VPWR sky130_fd_sc_hd__diode_2
XFILLER_0_88_499 VGND VGND VPWR VPWR sky130_fd_sc_hd__fill_2
XFILLER_0_75_105 VGND VGND VPWR VPWR sky130_fd_sc_hd__decap_3
X_5840_ u_pe_array.g_pe_row\[0\].g_pe_col\[3\].u_pe.psum_out\[7\] u_pe_array.g_pe_row\[0\].g_pe_col\[3\].u_pe.psum_out\[8\]
+ _2697_ _2611_ VGND VGND VPWR VPWR _2701_ sky130_fd_sc_hd__o211a_1
XFILLER_0_68_190 VGND VGND VPWR VPWR sky130_fd_sc_hd__decap_4
X_5771_ _2637_ _2638_ VGND VGND VPWR VPWR _2639_ sky130_fd_sc_hd__and2b_1
X_4722_ u_pe_array.g_pe_row\[2\].g_pe_col\[1\].u_pe.psum_out\[7\] u_pe_array.g_pe_row\[2\].g_pe_col\[1\].u_pe.psum_out\[8\]
+ _1760_ _1672_ VGND VGND VPWR VPWR _1764_ sky130_fd_sc_hd__o211a_1
XANTENNA__7087__RESET_B net816 VGND VGND VPWR VPWR sky130_fd_sc_hd__diode_2
X_7510_ clknet_leaf_0_clk _0559_ VGND VGND VPWR VPWR u_pe_array.u_fifo2.buffer\[5\]\[10\]
+ sky130_fd_sc_hd__dfxtp_1
XFILLER_0_29_588 VGND VGND VPWR VPWR sky130_fd_sc_hd__decap_8
XANTENNA__7016__RESET_B net817 VGND VGND VPWR VPWR sky130_fd_sc_hd__diode_2
XFILLER_0_99_7 VPWR VGND VPWR VGND sky130_ef_sc_hd__decap_12
XFILLER_0_44_547 VGND VGND VPWR VPWR sky130_fd_sc_hd__decap_4
X_7441_ clknet_leaf_2_clk _0490_ VGND VGND VPWR VPWR u_pe_array.u_fifo2.buffer\[0\]\[6\]
+ sky130_fd_sc_hd__dfxtp_1
X_4653_ net700 _1152_ _0887_ _1701_ VGND VGND VPWR VPWR _0195_ sky130_fd_sc_hd__a22o_1
XANTENNA__3627__S _0734_ VGND VGND VPWR VPWR sky130_fd_sc_hd__diode_2
XFILLER_0_31_208 VGND VGND VPWR VPWR sky130_fd_sc_hd__fill_2
X_4584_ u_pe_array.g_pe_row\[1\].g_pe_col\[1\].u_pe.w_buffer\[1\] net798 _0828_ VGND
+ VGND VPWR VPWR _1650_ sky130_fd_sc_hd__mux2_1
XFILLER_0_71_388 VGND VGND VPWR VPWR sky130_fd_sc_hd__fill_2
X_7372_ clknet_leaf_51_clk _0427_ net812 VGND VGND VPWR VPWR u_pe_array.g_pe_row\[0\].g_pe_col\[0\].u_pe.move_reg\[11\]
+ sky130_fd_sc_hd__dfrtp_1
X_3604_ _0836_ VGND VGND VPWR VPWR _0837_ sky130_fd_sc_hd__buf_6
XANTENNA__3854__C _1009_ VGND VGND VPWR VPWR sky130_fd_sc_hd__diode_2
X_6323_ _3105_ u_pe_array.u_fifo1.wr_ptr\[2\] u_pe_array.u_fifo1.wr_ptr\[3\] _3107_
+ VGND VGND VPWR VPWR _3108_ sky130_fd_sc_hd__or4bb_1
X_3535_ u_fsm.cnt\[3\] u_fsm.cnt\[2\] u_fsm.cnt\[0\] u_fsm.cnt\[1\] VGND VGND VPWR
+ VPWR _0782_ sky130_fd_sc_hd__or4b_1
X_6254_ u_pe_array.g_pe_row\[0\].g_pe_col\[0\].u_pe.act_val\[5\] VGND VGND VPWR VPWR
+ _3046_ sky130_fd_sc_hd__inv_2
X_3466_ _0738_ VGND VGND VPWR VPWR net54 sky130_fd_sc_hd__buf_1
XFILLER_0_58_83 VGND VGND VPWR VPWR sky130_fd_sc_hd__fill_1
X_5205_ u_pe_array.g_pe_row\[1\].g_pe_col\[2\].u_pe.act_val\[0\] _2158_ VGND VGND
+ VPWR VPWR _2159_ sky130_fd_sc_hd__nand2_1
XFILLER_0_12_499 VGND VGND VPWR VPWR sky130_fd_sc_hd__decap_3
X_6185_ _2986_ VGND VGND VPWR VPWR _0442_ sky130_fd_sc_hd__clkbuf_1
XFILLER_0_42_3 VPWR VGND VPWR VGND sky130_ef_sc_hd__decap_12
X_5136_ _2100_ _2104_ _2109_ _0913_ VGND VGND VPWR VPWR _2111_ sky130_fd_sc_hd__a31o_1
X_5067_ u_pe_array.g_pe_row\[1\].g_pe_col\[3\].u_pe.act_val\[1\] _2029_ u_pe_array.g_pe_row\[1\].g_pe_col\[3\].u_pe.psum_out\[2\]
+ VGND VGND VPWR VPWR _2047_ sky130_fd_sc_hd__and3b_1
X_4018_ _1176_ _1177_ u_pe_array.g_pe_row\[3\].g_pe_col\[1\].u_pe.w_reg\[0\] u_pe_array.g_pe_row\[3\].g_pe_col\[1\].u_pe.act_val\[4\]
+ VGND VGND VPWR VPWR _1178_ sky130_fd_sc_hd__and4bb_1
XFILLER_0_39_308 VGND VGND VPWR VPWR sky130_fd_sc_hd__fill_2
XFILLER_0_66_116 VGND VGND VPWR VPWR sky130_fd_sc_hd__fill_2
X_5969_ _2804_ _2805_ VGND VGND VPWR VPWR _2806_ sky130_fd_sc_hd__xnor2_1
XANTENNA__5576__B2 _2336_ VGND VGND VPWR VPWR sky130_fd_sc_hd__diode_2
XFILLER_0_35_503 VGND VGND VPWR VPWR sky130_fd_sc_hd__fill_1
XFILLER_0_62_322 VGND VGND VPWR VPWR sky130_fd_sc_hd__fill_2
X_7639_ clknet_leaf_25_clk _0688_ VGND VGND VPWR VPWR u_pe_array.u_fifo1.buffer\[5\]\[10\]
+ sky130_fd_sc_hd__dfxtp_1
XFILLER_0_105_413 VGND VGND VPWR VPWR sky130_fd_sc_hd__fill_2
XFILLER_0_90_664 VGND VGND VPWR VPWR sky130_fd_sc_hd__fill_2
XANTENNA__5879__A2 _2600_ VGND VGND VPWR VPWR sky130_fd_sc_hd__diode_2
XFILLER_0_50_528 VGND VGND VPWR VPWR sky130_fd_sc_hd__decap_4
XFILLER_0_15_271 VGND VGND VPWR VPWR sky130_fd_sc_hd__decap_3
XANTENNA__6848__S _3397_ VGND VGND VPWR VPWR sky130_fd_sc_hd__diode_2
XANTENNA__6828__A1 _3134_ VGND VGND VPWR VPWR sky130_fd_sc_hd__diode_2
XFILLER_0_101_652 VPWR VGND VPWR VGND sky130_ef_sc_hd__decap_12
XFILLER_0_30_285 VGND VGND VPWR VPWR sky130_fd_sc_hd__fill_1
XANTENNA__6149__A net71 VGND VGND VPWR VPWR sky130_fd_sc_hd__diode_2
XANTENNA_input26_A v_in1[5] VGND VGND VPWR VPWR sky130_fd_sc_hd__diode_2
XANTENNA__6583__S _3254_ VGND VGND VPWR VPWR sky130_fd_sc_hd__diode_2
XANTENNA__4067__A1 _1145_ VGND VGND VPWR VPWR sky130_fd_sc_hd__diode_2
XANTENNA__3814__B2 _1004_ VGND VGND VPWR VPWR sky130_fd_sc_hd__diode_2
XFILLER_0_70_29 VPWR VGND VPWR VGND sky130_ef_sc_hd__decap_12
XANTENNA__7180__RESET_B net815 VGND VGND VPWR VPWR sky130_fd_sc_hd__diode_2
XFILLER_0_38_363 VGND VGND VPWR VPWR sky130_fd_sc_hd__fill_1
XFILLER_0_38_396 VGND VGND VPWR VPWR sky130_fd_sc_hd__fill_2
XFILLER_0_111_405 VGND VGND VPWR VPWR sky130_fd_sc_hd__decap_4
Xhold109 u_pe_array.g_pe_row\[0\].g_pe_col\[2\].u_pe.move_reg\[11\] VGND VGND VPWR
+ VPWR net185 sky130_fd_sc_hd__dlygate4sd3_1
XFILLER_0_111_449 VPWR VGND VPWR VGND sky130_ef_sc_hd__decap_12
XFILLER_0_111_438 VGND VGND VPWR VPWR sky130_fd_sc_hd__decap_8
XFILLER_0_104_490 VGND VGND VPWR VPWR sky130_fd_sc_hd__decap_6
XANTENNA__3971__A _0832_ VGND VGND VPWR VPWR sky130_fd_sc_hd__diode_2
XFILLER_0_0_113 VGND VGND VPWR VPWR sky130_fd_sc_hd__decap_6
XFILLER_0_95_15 VGND VGND VPWR VPWR sky130_fd_sc_hd__fill_2
XTAP_414 VGND VPWR sky130_fd_sc_hd__tapvpwrvgnd_1
XTAP_403 VGND VPWR sky130_fd_sc_hd__tapvpwrvgnd_1
XANTENNA__4278__S _0769_ VGND VGND VPWR VPWR sky130_fd_sc_hd__diode_2
XTAP_425 VGND VPWR sky130_fd_sc_hd__tapvpwrvgnd_1
XTAP_436 VGND VPWR sky130_fd_sc_hd__tapvpwrvgnd_1
XTAP_447 VGND VPWR sky130_fd_sc_hd__tapvpwrvgnd_1
XTAP_458 VGND VPWR sky130_fd_sc_hd__tapvpwrvgnd_1
XTAP_469 VGND VPWR sky130_fd_sc_hd__tapvpwrvgnd_1
XANTENNA__6047__A2 _2738_ VGND VGND VPWR VPWR sky130_fd_sc_hd__diode_2
XANTENNA__4058__A1 _0864_ VGND VGND VPWR VPWR sky130_fd_sc_hd__diode_2
XANTENNA__3805__B2 u_fsm.psum_shift_en VGND VGND VPWR VPWR sky130_fd_sc_hd__diode_2
XFILLER_0_44_52 VGND VGND VPWR VPWR sky130_fd_sc_hd__fill_1
X_6941_ clknet_leaf_76_clk net78 net815 VGND VGND VPWR VPWR u_pe_array.g_pe_row\[3\].g_pe_col\[3\].u_pe.w_reg\[0\]
+ sky130_fd_sc_hd__dfrtp_4
X_6872_ net313 _3122_ _3412_ VGND VGND VPWR VPWR _3419_ sky130_fd_sc_hd__mux2_1
XANTENNA__7268__RESET_B net812 VGND VGND VPWR VPWR sky130_fd_sc_hd__diode_2
XFILLER_0_48_105 VGND VGND VPWR VPWR sky130_fd_sc_hd__fill_2
XFILLER_0_64_609 VGND VGND VPWR VPWR sky130_fd_sc_hd__fill_2
XFILLER_0_44_96 VGND VGND VPWR VPWR sky130_fd_sc_hd__decap_4
X_5823_ _2670_ _2677_ _2685_ VGND VGND VPWR VPWR _2686_ sky130_fd_sc_hd__a21oi_1
XFILLER_0_8_224 VGND VGND VPWR VPWR sky130_fd_sc_hd__fill_1
XFILLER_0_17_503 VGND VGND VPWR VPWR sky130_fd_sc_hd__fill_1
XFILLER_0_8_279 VGND VGND VPWR VPWR sky130_fd_sc_hd__fill_2
X_5754_ u_pe_array.g_pe_row\[0\].g_pe_col\[3\].u_pe.psum_out\[2\] _2622_ VGND VGND
+ VPWR VPWR _2623_ sky130_fd_sc_hd__xnor2_1
X_5685_ u_pe_array.g_pe_row\[1\].g_pe_col\[0\].u_pe.psum_out\[10\] _2478_ VGND VGND
+ VPWR VPWR _2574_ sky130_fd_sc_hd__nand2_1
X_4705_ _1733_ _1740_ _1748_ VGND VGND VPWR VPWR _1749_ sky130_fd_sc_hd__a21oi_1
XFILLER_0_44_355 VGND VGND VPWR VPWR sky130_fd_sc_hd__fill_2
XFILLER_0_114_221 VGND VGND VPWR VPWR sky130_fd_sc_hd__decap_3
X_4636_ _1679_ _1685_ VGND VGND VPWR VPWR _1686_ sky130_fd_sc_hd__nand2_1
X_7424_ clknet_leaf_7_clk _0473_ net74 VGND VGND VPWR VPWR u_pe_array.u_fifo2.wr_ptr\[1\]
+ sky130_fd_sc_hd__dfrtp_4
XANTENNA__5138__A _2029_ VGND VGND VPWR VPWR sky130_fd_sc_hd__diode_2
XFILLER_0_114_287 VPWR VGND VPWR VGND sky130_ef_sc_hd__decap_12
XFILLER_0_114_265 VPWR VGND VPWR VGND sky130_ef_sc_hd__decap_12
Xhold621 u_pe_array.g_pe_row\[2\].g_pe_col\[1\].u_pe.psum_out\[2\] VGND VGND VPWR
+ VPWR net697 sky130_fd_sc_hd__dlygate4sd3_1
Xhold610 u_pe_array.g_pe_row\[1\].g_pe_col\[0\].u_pe.psum_out\[7\] VGND VGND VPWR
+ VPWR net686 sky130_fd_sc_hd__dlygate4sd3_1
X_7355_ clknet_leaf_64_clk _0410_ net818 VGND VGND VPWR VPWR u_pe_array.g_pe_row\[0\].g_pe_col\[2\].u_pe.psum_out\[9\]
+ sky130_fd_sc_hd__dfrtp_1
Xhold654 u_pe_array.g_pe_row\[0\].g_pe_col\[1\].u_pe.psum_out\[8\] VGND VGND VPWR
+ VPWR net730 sky130_fd_sc_hd__dlygate4sd3_1
Xhold643 u_pe_array.g_pe_row\[0\].g_pe_col\[1\].u_pe.act_val\[4\] VGND VGND VPWR VPWR
+ net719 sky130_fd_sc_hd__dlygate4sd3_1
X_6306_ u_pe_array.g_pe_row\[0\].g_pe_col\[0\].u_pe.psum_out\[10\] _3079_ _3086_ _3090_
+ VGND VGND VPWR VPWR _3093_ sky130_fd_sc_hd__a2bb2o_1
XFILLER_0_12_241 VGND VGND VPWR VPWR sky130_fd_sc_hd__fill_2
Xhold632 u_pe_array.g_pe_row\[1\].g_pe_col\[3\].u_pe.psum_out\[8\] VGND VGND VPWR
+ VPWR net708 sky130_fd_sc_hd__dlygate4sd3_1
X_4567_ _1627_ _1629_ _1635_ VGND VGND VPWR VPWR _1637_ sky130_fd_sc_hd__a21oi_2
Xhold665 u_pe_array.g_pe_row\[0\].g_pe_col\[0\].u_pe.act_val\[0\] VGND VGND VPWR VPWR
+ net741 sky130_fd_sc_hd__dlygate4sd3_1
X_3518_ u_pe_array.g_pe_row\[1\].g_pe_col\[0\].u_pe.psum_out\[7\] _0769_ _0772_ _0754_
+ VGND VGND VPWR VPWR net46 sky130_fd_sc_hd__o211a_1
Xhold687 u_pe_array.g_pe_row\[3\].g_pe_col\[1\].u_pe.act_val\[0\] VGND VGND VPWR VPWR
+ net763 sky130_fd_sc_hd__dlygate4sd3_1
X_7286_ clknet_leaf_58_clk _0345_ net813 VGND VGND VPWR VPWR u_pe_array.g_pe_row\[1\].g_pe_col\[0\].u_pe.psum_out\[0\]
+ sky130_fd_sc_hd__dfrtp_1
X_4498_ _1570_ _1571_ _1572_ VGND VGND VPWR VPWR _1574_ sky130_fd_sc_hd__a21oi_1
Xhold676 u_pe_array.g_pe_row\[1\].g_pe_col\[3\].u_pe.act_val\[0\] VGND VGND VPWR VPWR
+ net752 sky130_fd_sc_hd__dlygate4sd3_1
X_6237_ _3028_ _3029_ VGND VGND VPWR VPWR _3031_ sky130_fd_sc_hd__or2_1
Xhold698 _0813_ VGND VGND VPWR VPWR net774 sky130_fd_sc_hd__dlygate4sd3_1
X_3449_ _0717_ _0718_ _0723_ VGND VGND VPWR VPWR _0724_ sky130_fd_sc_hd__and3_1
X_6168_ _2964_ _2966_ _2972_ VGND VGND VPWR VPWR _2973_ sky130_fd_sc_hd__and3_1
XTAP_970 VGND VPWR sky130_fd_sc_hd__tapvpwrvgnd_1
XFILLER_0_85_81 VGND VGND VPWR VPWR sky130_fd_sc_hd__decap_4
XTAP_992 VGND VPWR sky130_fd_sc_hd__tapvpwrvgnd_1
XTAP_981 VGND VPWR sky130_fd_sc_hd__tapvpwrvgnd_1
X_5119_ _2029_ u_pe_array.g_pe_row\[1\].g_pe_col\[3\].u_pe.psum_out\[7\] VGND VGND
+ VPWR VPWR _2095_ sky130_fd_sc_hd__xor2_1
X_6099_ _2907_ _2908_ _2909_ VGND VGND VPWR VPWR _2910_ sky130_fd_sc_hd__and3_1
XFILLER_0_79_285 VGND VGND VPWR VPWR sky130_fd_sc_hd__fill_1
XFILLER_0_62_141 VGND VGND VPWR VPWR sky130_fd_sc_hd__fill_2
XFILLER_0_90_472 VGND VGND VPWR VPWR sky130_fd_sc_hd__fill_2
XFILLER_0_62_174 VPWR VGND VPWR VGND sky130_ef_sc_hd__decap_12
XFILLER_0_62_163 VGND VGND VPWR VPWR sky130_fd_sc_hd__fill_1
XFILLER_0_105_276 VGND VGND VPWR VPWR sky130_fd_sc_hd__decap_4
XFILLER_0_31_561 VPWR VGND VPWR VGND sky130_ef_sc_hd__decap_12
XANTENNA__4288__B2 _1399_ VGND VGND VPWR VPWR sky130_fd_sc_hd__diode_2
XANTENNA__6029__A2 _2738_ VGND VGND VPWR VPWR sky130_fd_sc_hd__diode_2
XANTENNA__5237__B1 _2174_ VGND VGND VPWR VPWR sky130_fd_sc_hd__diode_2
XFILLER_0_98_583 VGND VGND VPWR VPWR sky130_fd_sc_hd__decap_4
XANTENNA__7361__RESET_B net75 VGND VGND VPWR VPWR sky130_fd_sc_hd__diode_2
XANTENNA__3799__B1 _0837_ VGND VGND VPWR VPWR sky130_fd_sc_hd__diode_2
XFILLER_0_105_57 VGND VGND VPWR VPWR sky130_fd_sc_hd__decap_3
XFILLER_0_85_244 VGND VGND VPWR VPWR sky130_fd_sc_hd__fill_2
XFILLER_0_85_233 VGND VGND VPWR VPWR sky130_fd_sc_hd__fill_1
XFILLER_0_66_480 VGND VGND VPWR VPWR sky130_fd_sc_hd__fill_2
XFILLER_0_26_322 VGND VGND VPWR VPWR sky130_fd_sc_hd__decap_4
XFILLER_0_54_642 VGND VGND VPWR VPWR sky130_fd_sc_hd__fill_2
XFILLER_0_26_333 VGND VGND VPWR VPWR sky130_fd_sc_hd__decap_4
X_5470_ u_pe_array.g_pe_row\[1\].g_pe_col\[1\].u_pe.psum_out\[4\] _2377_ _2378_ VGND
+ VGND VPWR VPWR _2392_ sky130_fd_sc_hd__a21boi_1
XANTENNA__6488__S _3208_ VGND VGND VPWR VPWR sky130_fd_sc_hd__diode_2
X_4421_ _1515_ VGND VGND VPWR VPWR _0149_ sky130_fd_sc_hd__clkbuf_1
XFILLER_0_22_572 VGND VGND VPWR VPWR sky130_fd_sc_hd__fill_2
X_4352_ _1453_ _1454_ VGND VGND VPWR VPWR _1455_ sky130_fd_sc_hd__nor2_1
XFILLER_0_22_594 VGND VGND VPWR VPWR sky130_fd_sc_hd__fill_2
X_7140_ clknet_leaf_92_clk _0209_ VGND VGND VPWR VPWR u_pe_array.u_fifo2.buffer\[8\]\[4\]
+ sky130_fd_sc_hd__dfxtp_1
XTAP_233 VGND VPWR sky130_fd_sc_hd__tapvpwrvgnd_1
X_7071_ clknet_leaf_89_clk _0144_ net819 VGND VGND VPWR VPWR u_pe_array.g_pe_row\[2\].g_pe_col\[3\].u_pe.psum_out\[8\]
+ sky130_fd_sc_hd__dfrtp_2
X_4283_ net150 _1392_ _1397_ _1004_ VGND VGND VPWR VPWR _0129_ sky130_fd_sc_hd__a22o_1
X_6022_ _2851_ _2852_ VGND VGND VPWR VPWR _2853_ sky130_fd_sc_hd__xnor2_1
XTAP_255 VGND VPWR sky130_fd_sc_hd__tapvpwrvgnd_1
XTAP_244 VGND VPWR sky130_fd_sc_hd__tapvpwrvgnd_1
XTAP_266 VGND VPWR sky130_fd_sc_hd__tapvpwrvgnd_1
XANTENNA__3487__C1 _0728_ VGND VGND VPWR VPWR sky130_fd_sc_hd__diode_2
XTAP_299 VGND VPWR sky130_fd_sc_hd__tapvpwrvgnd_1
XTAP_288 VGND VPWR sky130_fd_sc_hd__tapvpwrvgnd_1
XTAP_277 VGND VPWR sky130_fd_sc_hd__tapvpwrvgnd_1
XFILLER_0_55_51 VGND VGND VPWR VPWR sky130_fd_sc_hd__decap_4
X_6924_ clknet_leaf_59_clk u_fsm.next_state\[1\] net813 VGND VGND VPWR VPWR u_fsm.state\[1\]
+ sky130_fd_sc_hd__dfrtp_1
XANTENNA__7031__RESET_B net817 VGND VGND VPWR VPWR sky130_fd_sc_hd__diode_2
X_6855_ _3409_ VGND VGND VPWR VPWR _0689_ sky130_fd_sc_hd__clkbuf_1
XFILLER_0_64_406 VPWR VGND VPWR VGND sky130_ef_sc_hd__decap_12
XANTENNA__5567__S _2469_ VGND VGND VPWR VPWR sky130_fd_sc_hd__diode_2
XFILLER_0_107_508 VGND VGND VPWR VPWR sky130_fd_sc_hd__fill_2
XFILLER_0_91_225 VGND VGND VPWR VPWR sky130_fd_sc_hd__fill_2
X_6786_ _3372_ VGND VGND VPWR VPWR _0657_ sky130_fd_sc_hd__clkbuf_1
X_3998_ _1148_ _1151_ VGND VGND VPWR VPWR _1160_ sky130_fd_sc_hd__and2_1
X_5806_ _2669_ _2670_ VGND VGND VPWR VPWR _2671_ sky130_fd_sc_hd__nor2_1
XFILLER_0_44_141 VGND VGND VPWR VPWR sky130_fd_sc_hd__decap_4
X_5737_ u_pe_array.g_pe_row\[0\].g_pe_col\[3\].u_pe.w_reg\[0\] u_pe_array.g_pe_row\[0\].g_pe_col\[3\].u_pe.act_val\[0\]
+ u_pe_array.g_pe_row\[0\].g_pe_col\[3\].u_pe.psum_out\[0\] VGND VGND VPWR VPWR _2608_
+ sky130_fd_sc_hd__and3_1
XANTENNA__3962__B1 _0837_ VGND VGND VPWR VPWR sky130_fd_sc_hd__diode_2
XFILLER_0_17_388 VGND VGND VPWR VPWR sky130_fd_sc_hd__fill_2
X_7407_ clknet_leaf_45_clk _0457_ net817 VGND VGND VPWR VPWR u_pe_array.g_pe_row\[0\].g_pe_col\[0\].u_pe.psum_out\[11\]
+ sky130_fd_sc_hd__dfrtp_2
X_5668_ _2557_ _2558_ VGND VGND VPWR VPWR _2559_ sky130_fd_sc_hd__nand2_1
XFILLER_0_60_645 VGND VGND VPWR VPWR sky130_fd_sc_hd__decap_3
X_4619_ _1273_ _1668_ _1670_ _1534_ net372 VGND VGND VPWR VPWR _0192_ sky130_fd_sc_hd__a32o_1
X_5599_ _2491_ _2492_ _2494_ VGND VGND VPWR VPWR _2495_ sky130_fd_sc_hd__o21a_1
XFILLER_0_4_271 VPWR VGND VPWR VGND sky130_ef_sc_hd__decap_12
XFILLER_0_13_550 VGND VGND VPWR VPWR sky130_fd_sc_hd__decap_8
XFILLER_0_13_561 VGND VGND VPWR VPWR sky130_fd_sc_hd__decap_3
X_7338_ clknet_leaf_49_clk _0395_ net812 VGND VGND VPWR VPWR u_pe_array.g_pe_row\[0\].g_pe_col\[1\].u_pe.move_reg\[7\]
+ sky130_fd_sc_hd__dfrtp_1
Xhold440 u_pe_array.u_fifo1.buffer\[5\]\[2\] VGND VGND VPWR VPWR net516 sky130_fd_sc_hd__dlygate4sd3_1
Xhold462 u_pe_array.u_fifo2.buffer\[6\]\[2\] VGND VGND VPWR VPWR net538 sky130_fd_sc_hd__dlygate4sd3_1
Xhold451 u_pe_array.u_fifo2.buffer\[5\]\[0\] VGND VGND VPWR VPWR net527 sky130_fd_sc_hd__dlygate4sd3_1
X_7269_ clknet_leaf_42_clk _0330_ net813 VGND VGND VPWR VPWR u_pe_array.g_pe_row\[1\].g_pe_col\[0\].u_pe.w_buffer\[0\]
+ sky130_fd_sc_hd__dfrtp_1
Xhold495 u_pe_array.g_pe_row\[1\].g_pe_col\[0\].u_pe.act_val\[5\] VGND VGND VPWR VPWR
+ net571 sky130_fd_sc_hd__dlygate4sd3_1
Xhold473 u_pe_array.u_fifo1.buffer\[2\]\[2\] VGND VGND VPWR VPWR net549 sky130_fd_sc_hd__dlygate4sd3_1
XANTENNA__5315__B _2158_ VGND VGND VPWR VPWR sky130_fd_sc_hd__diode_2
Xhold484 u_pe_array.g_pe_row\[2\].g_pe_col\[2\].u_pe.psum_out\[1\] VGND VGND VPWR
+ VPWR net560 sky130_fd_sc_hd__dlygate4sd3_1
XANTENNA_fanout76_A net13 VGND VGND VPWR VPWR sky130_fd_sc_hd__diode_2
XANTENNA__7119__RESET_B net76 VGND VGND VPWR VPWR sky130_fd_sc_hd__diode_2
XFILLER_0_67_200 VGND VGND VPWR VPWR sky130_fd_sc_hd__decap_3
XANTENNA__4442__B2 _1399_ VGND VGND VPWR VPWR sky130_fd_sc_hd__diode_2
XANTENNA__4993__A2 _1985_ VGND VGND VPWR VPWR sky130_fd_sc_hd__diode_2
XANTENNA__6162__A _2873_ VGND VGND VPWR VPWR sky130_fd_sc_hd__diode_2
XANTENNA__3953__B1 _0837_ VGND VGND VPWR VPWR sky130_fd_sc_hd__diode_2
XFILLER_0_63_461 VGND VGND VPWR VPWR sky130_fd_sc_hd__fill_2
XFILLER_0_36_675 VGND VGND VPWR VPWR sky130_fd_sc_hd__fill_2
XFILLER_0_106_574 VGND VGND VPWR VPWR sky130_fd_sc_hd__fill_1
XFILLER_0_51_645 VGND VGND VPWR VPWR sky130_fd_sc_hd__decap_3
XFILLER_0_23_369 VGND VGND VPWR VPWR sky130_fd_sc_hd__fill_1
XFILLER_0_31_391 VGND VGND VPWR VPWR sky130_fd_sc_hd__fill_1
XANTENNA_output57_A net57 VGND VGND VPWR VPWR sky130_fd_sc_hd__diode_2
XANTENNA__7542__RESET_B net818 VGND VGND VPWR VPWR sky130_fd_sc_hd__diode_2
XFILLER_0_25_10 VGND VGND VPWR VPWR sky130_fd_sc_hd__decap_3
XFILLER_0_25_54 VGND VGND VPWR VPWR sky130_fd_sc_hd__fill_2
XFILLER_0_86_531 VGND VGND VPWR VPWR sky130_fd_sc_hd__fill_1
X_4970_ u_pe_array.u_fifo2.rd_ptr\[1\] u_pe_array.u_fifo2.rd_ptr\[0\] _1958_ u_pe_array.u_fifo2.rd_ptr\[2\]
+ VGND VGND VPWR VPWR _1966_ sky130_fd_sc_hd__and4_2
XANTENNA__5387__S _0755_ VGND VGND VPWR VPWR sky130_fd_sc_hd__diode_2
XANTENNA__4984__A2 _1977_ VGND VGND VPWR VPWR sky130_fd_sc_hd__diode_2
X_3921_ _1096_ _1097_ _1102_ _1099_ _1094_ VGND VGND VPWR VPWR _1103_ sky130_fd_sc_hd__a32o_1
XFILLER_0_73_236 VGND VGND VPWR VPWR sky130_fd_sc_hd__decap_3
XFILLER_0_73_214 VGND VGND VPWR VPWR sky130_fd_sc_hd__fill_2
XFILLER_0_58_277 VGND VGND VPWR VPWR sky130_fd_sc_hd__fill_2
X_3852_ u_pe_array.g_pe_row\[3\].g_pe_col\[2\].u_pe.act_val\[3\] VGND VGND VPWR VPWR
+ _1040_ sky130_fd_sc_hd__inv_2
X_6640_ _3289_ VGND VGND VPWR VPWR _0594_ sky130_fd_sc_hd__clkbuf_1
XANTENNA__4291__S _0855_ VGND VGND VPWR VPWR sky130_fd_sc_hd__diode_2
XFILLER_0_39_480 VGND VGND VPWR VPWR sky130_fd_sc_hd__fill_2
X_6571_ _1792_ u_pe_array.u_fifo2.wr_ptr\[1\] _3222_ VGND VGND VPWR VPWR _3253_ sky130_fd_sc_hd__and3b_1
XFILLER_0_6_525 VGND VGND VPWR VPWR sky130_fd_sc_hd__decap_6
X_5522_ _2418_ _2421_ _2426_ _2438_ VGND VGND VPWR VPWR _2439_ sky130_fd_sc_hd__a211o_1
X_3783_ net763 _0834_ _0837_ _0987_ VGND VGND VPWR VPWR _0039_ sky130_fd_sc_hd__a22o_1
XFILLER_0_6_569 VPWR VGND VPWR VGND sky130_ef_sc_hd__decap_12
XFILLER_0_41_97 VGND VGND VPWR VPWR sky130_fd_sc_hd__decap_4
XFILLER_0_112_533 VPWR VGND VPWR VGND sky130_ef_sc_hd__decap_12
X_5453_ u_pe_array.g_pe_row\[1\].g_pe_col\[1\].u_pe.act_val\[3\] VGND VGND VPWR VPWR
+ _2376_ sky130_fd_sc_hd__inv_2
XFILLER_0_14_369 VGND VGND VPWR VPWR sky130_fd_sc_hd__decap_3
X_5384_ u_pe_array.u_fifo1.buffer\[3\]\[4\] _2282_ _2283_ u_pe_array.u_fifo1.buffer\[2\]\[4\]
+ _2319_ VGND VGND VPWR VPWR _2320_ sky130_fd_sc_hd__a221o_1
X_4404_ _1496_ _1501_ VGND VGND VPWR VPWR _1502_ sky130_fd_sc_hd__nor2_1
XFILLER_0_41_199 VGND VGND VPWR VPWR sky130_fd_sc_hd__decap_8
X_7123_ clknet_leaf_35_clk _0192_ net816 VGND VGND VPWR VPWR u_pe_array.g_pe_row\[2\].g_pe_col\[1\].u_pe.psum_out\[0\]
+ sky130_fd_sc_hd__dfrtp_1
XFILLER_0_10_531 VGND VGND VPWR VPWR sky130_fd_sc_hd__fill_1
X_4335_ _1437_ _1438_ u_pe_array.g_pe_row\[2\].g_pe_col\[3\].u_pe.w_reg\[0\] u_pe_array.g_pe_row\[2\].g_pe_col\[3\].u_pe.act_val\[4\]
+ VGND VGND VPWR VPWR _1439_ sky130_fd_sc_hd__and4bb_1
X_4266_ net801 VGND VGND VPWR VPWR _0121_ sky130_fd_sc_hd__clkbuf_1
X_7054_ clknet_leaf_89_clk net151 net819 VGND VGND VPWR VPWR u_pe_array.g_pe_row\[2\].g_pe_col\[2\].u_pe.move_reg\[6\]
+ sky130_fd_sc_hd__dfrtp_1
X_4197_ u_pe_array.g_pe_row\[3\].g_pe_col\[0\].u_pe.w_reg\[0\] u_pe_array.g_pe_row\[3\].g_pe_col\[0\].u_pe.act_val\[5\]
+ _1318_ VGND VGND VPWR VPWR _1327_ sky130_fd_sc_hd__and3_1
XFILLER_0_66_83 VGND VGND VPWR VPWR sky130_fd_sc_hd__fill_1
X_6005_ u_pe_array.g_pe_row\[0\].g_pe_col\[2\].u_pe.psum_out\[10\] _2743_ VGND VGND
+ VPWR VPWR _2838_ sky130_fd_sc_hd__nand2_1
XANTENNA__7283__RESET_B net814 VGND VGND VPWR VPWR sky130_fd_sc_hd__diode_2
XANTENNA__7212__RESET_B net75 VGND VGND VPWR VPWR sky130_fd_sc_hd__diode_2
XFILLER_0_96_306 VGND VGND VPWR VPWR sky130_fd_sc_hd__fill_2
XTAP_1229 VGND VPWR sky130_fd_sc_hd__tapvpwrvgnd_1
XTAP_1218 VGND VPWR sky130_fd_sc_hd__tapvpwrvgnd_1
XTAP_1207 VGND VPWR sky130_fd_sc_hd__tapvpwrvgnd_1
X_6907_ _3437_ VGND VGND VPWR VPWR _0713_ sky130_fd_sc_hd__clkbuf_1
X_6838_ net427 _3116_ _3397_ VGND VGND VPWR VPWR _3401_ sky130_fd_sc_hd__mux2_1
XFILLER_0_9_341 VGND VGND VPWR VPWR sky130_fd_sc_hd__fill_2
XFILLER_0_92_556 VGND VGND VPWR VPWR sky130_fd_sc_hd__fill_2
XFILLER_0_92_545 VGND VGND VPWR VPWR sky130_fd_sc_hd__fill_2
XFILLER_0_64_269 VGND VGND VPWR VPWR sky130_fd_sc_hd__decap_6
X_6769_ _3363_ VGND VGND VPWR VPWR _0649_ sky130_fd_sc_hd__clkbuf_1
XFILLER_0_92_589 VGND VGND VPWR VPWR sky130_fd_sc_hd__fill_2
XFILLER_0_17_163 VGND VGND VPWR VPWR sky130_fd_sc_hd__fill_2
XANTENNA__3935__B1 _0887_ VGND VGND VPWR VPWR sky130_fd_sc_hd__diode_2
XANTENNA__4230__A net72 VGND VGND VPWR VPWR sky130_fd_sc_hd__diode_2
XANTENNA__6856__S _3397_ VGND VGND VPWR VPWR sky130_fd_sc_hd__diode_2
Xhold270 u_pe_array.u_fifo2.buffer\[5\]\[10\] VGND VGND VPWR VPWR net346 sky130_fd_sc_hd__dlygate4sd3_1
Xhold292 u_pe_array.u_fifo2.buffer\[8\]\[6\] VGND VGND VPWR VPWR net368 sky130_fd_sc_hd__dlygate4sd3_1
Xhold281 u_pe_array.u_fifo2.buffer\[8\]\[11\] VGND VGND VPWR VPWR net357 sky130_fd_sc_hd__dlygate4sd3_1
XANTENNA__5860__B1 _2571_ VGND VGND VPWR VPWR sky130_fd_sc_hd__diode_2
XFILLER_0_99_155 VGND VGND VPWR VPWR sky130_fd_sc_hd__fill_2
XANTENNA__6591__S _3254_ VGND VGND VPWR VPWR sky130_fd_sc_hd__diode_2
XFILLER_0_68_542 VGND VGND VPWR VPWR sky130_fd_sc_hd__fill_2
XANTENNA__6935__RESET_B net74 VGND VGND VPWR VPWR sky130_fd_sc_hd__diode_2
XANTENNA__5000__S _0756_ VGND VGND VPWR VPWR sky130_fd_sc_hd__diode_2
XFILLER_0_51_420 VGND VGND VPWR VPWR sky130_fd_sc_hd__decap_3
XFILLER_0_3_517 VPWR VGND VPWR VGND sky130_ef_sc_hd__decap_12
XFILLER_0_24_645 VGND VGND VPWR VPWR sky130_fd_sc_hd__decap_3
XFILLER_0_23_166 VGND VGND VPWR VPWR sky130_fd_sc_hd__fill_2
XANTENNA__6340__A1 _1787_ VGND VGND VPWR VPWR sky130_fd_sc_hd__diode_2
XFILLER_0_51_486 VGND VGND VPWR VPWR sky130_fd_sc_hd__fill_1
XFILLER_0_23_177 VGND VGND VPWR VPWR sky130_fd_sc_hd__fill_2
X_4120_ u_pe_array.g_pe_row\[3\].g_pe_col\[3\].u_pe.psum_out\[6\] u_pe_array.g_pe_row\[3\].g_pe_col\[3\].u_pe.move_reg\[6\]
+ _0855_ VGND VGND VPWR VPWR _1263_ sky130_fd_sc_hd__mux2_1
X_4051_ _0914_ _1208_ VGND VGND VPWR VPWR _1209_ sky130_fd_sc_hd__nor2_1
Xinput5 h_in0[4] VGND VGND VPWR VPWR net5 sky130_fd_sc_hd__clkbuf_2
XFILLER_0_78_317 VGND VGND VPWR VPWR sky130_fd_sc_hd__decap_3
XANTENNA__4406__B2 _0916_ VGND VGND VPWR VPWR sky130_fd_sc_hd__diode_2
X_4953_ u_pe_array.g_pe_row\[2\].g_pe_col\[0\].u_pe.psum_out\[9\] u_pe_array.g_pe_row\[2\].g_pe_col\[0\].u_pe.psum_out\[10\]
+ _1847_ VGND VGND VPWR VPWR _1952_ sky130_fd_sc_hd__o21a_1
XFILLER_0_86_350 VGND VGND VPWR VPWR sky130_fd_sc_hd__fill_2
XANTENNA__4957__A2 _1714_ VGND VGND VPWR VPWR sky130_fd_sc_hd__diode_2
XFILLER_0_59_553 VGND VGND VPWR VPWR sky130_fd_sc_hd__fill_1
XANTENNA__6514__B net74 VGND VGND VPWR VPWR sky130_fd_sc_hd__diode_2
XFILLER_0_86_383 VGND VGND VPWR VPWR sky130_fd_sc_hd__fill_2
XFILLER_0_74_523 VGND VGND VPWR VPWR sky130_fd_sc_hd__fill_2
XFILLER_0_74_501 VGND VGND VPWR VPWR sky130_fd_sc_hd__decap_4
XFILLER_0_46_203 VGND VGND VPWR VPWR sky130_fd_sc_hd__fill_2
X_3904_ u_pe_array.g_pe_row\[3\].g_pe_col\[2\].u_pe.psum_out\[8\] _1009_ VGND VGND
+ VPWR VPWR _1088_ sky130_fd_sc_hd__nand2_1
X_4884_ u_pe_array.g_pe_row\[2\].g_pe_col\[0\].u_pe.act_val\[5\] u_pe_array.g_pe_row\[2\].g_pe_col\[0\].u_pe.w_reg\[0\]
+ VGND VGND VPWR VPWR _1890_ sky130_fd_sc_hd__nand2_1
X_6623_ net373 _1818_ _3269_ VGND VGND VPWR VPWR _3281_ sky130_fd_sc_hd__mux2_1
XFILLER_0_74_589 VGND VGND VPWR VPWR sky130_fd_sc_hd__fill_2
XFILLER_0_27_461 VGND VGND VPWR VPWR sky130_fd_sc_hd__fill_2
X_3835_ net637 _0875_ _0887_ _1024_ VGND VGND VPWR VPWR _0054_ sky130_fd_sc_hd__a22o_1
X_6554_ _3244_ VGND VGND VPWR VPWR _0553_ sky130_fd_sc_hd__clkbuf_1
XFILLER_0_27_494 VGND VGND VPWR VPWR sky130_fd_sc_hd__fill_1
X_3766_ _0869_ u_pe_array.g_pe_row\[3\].g_pe_col\[3\].u_pe.psum_out\[11\] VGND VGND
+ VPWR VPWR _0975_ sky130_fd_sc_hd__and2b_1
X_5505_ _2345_ u_pe_array.g_pe_row\[1\].g_pe_col\[1\].u_pe.psum_out\[7\] _2422_ _2423_
+ VGND VGND VPWR VPWR _2424_ sky130_fd_sc_hd__a22oi_1
X_6485_ net224 _1820_ _3194_ VGND VGND VPWR VPWR _3207_ sky130_fd_sc_hd__mux2_1
XFILLER_0_14_133 VGND VGND VPWR VPWR sky130_fd_sc_hd__fill_2
XFILLER_0_14_155 VGND VGND VPWR VPWR sky130_fd_sc_hd__decap_3
XFILLER_0_42_464 VGND VGND VPWR VPWR sky130_fd_sc_hd__fill_1
X_5436_ net418 _1714_ _2359_ _2360_ VGND VGND VPWR VPWR _0319_ sky130_fd_sc_hd__a22o_1
XFILLER_0_72_3 VPWR VGND VPWR VGND sky130_ef_sc_hd__decap_12
X_3697_ _0717_ _0783_ _0861_ VGND VGND VPWR VPWR _0913_ sky130_fd_sc_hd__o21ai_4
XFILLER_0_14_166 VGND VGND VPWR VPWR sky130_fd_sc_hd__decap_3
XFILLER_0_30_626 VGND VGND VPWR VPWR sky130_fd_sc_hd__fill_2
XFILLER_0_42_497 VGND VGND VPWR VPWR sky130_fd_sc_hd__fill_2
XFILLER_0_112_363 VGND VGND VPWR VPWR sky130_fd_sc_hd__fill_1
XANTENNA__6331__A1 _1787_ VGND VGND VPWR VPWR sky130_fd_sc_hd__diode_2
X_5367_ u_pe_array.u_fifo1.buffer\[1\]\[2\] _2278_ _2302_ _2304_ VGND VGND VPWR VPWR
+ _2305_ sky130_fd_sc_hd__a211o_1
XFILLER_0_100_569 VGND VGND VPWR VPWR sky130_fd_sc_hd__decap_3
X_7106_ clknet_leaf_38_clk _0177_ net813 VGND VGND VPWR VPWR u_pe_array.g_pe_row\[2\].g_pe_col\[1\].u_pe.w_buffer\[0\]
+ sky130_fd_sc_hd__dfrtp_1
X_5298_ u_pe_array.g_pe_row\[1\].g_pe_col\[2\].u_pe.psum_out\[9\] _2158_ VGND VGND
+ VPWR VPWR _2244_ sky130_fd_sc_hd__or2_1
X_4318_ _1417_ _1419_ VGND VGND VPWR VPWR _1423_ sky130_fd_sc_hd__nand2_1
X_4249_ _1366_ _1368_ _1374_ VGND VGND VPWR VPWR _1375_ sky130_fd_sc_hd__and3_1
X_7037_ clknet_leaf_28_clk _0112_ net817 VGND VGND VPWR VPWR u_pe_array.g_pe_row\[3\].g_pe_col\[0\].u_pe.psum_out\[4\]
+ sky130_fd_sc_hd__dfrtp_1
XANTENNA__6634__A2 _2738_ VGND VGND VPWR VPWR sky130_fd_sc_hd__diode_2
XFILLER_0_97_615 VGND VGND VPWR VPWR sky130_fd_sc_hd__fill_1
XFILLER_0_96_125 VGND VGND VPWR VPWR sky130_fd_sc_hd__fill_2
XTAP_1004 VGND VPWR sky130_fd_sc_hd__tapvpwrvgnd_1
XFILLER_0_84_309 VGND VGND VPWR VPWR sky130_fd_sc_hd__decap_4
XTAP_1037 VGND VPWR sky130_fd_sc_hd__tapvpwrvgnd_1
XTAP_1026 VGND VPWR sky130_fd_sc_hd__tapvpwrvgnd_1
XTAP_1015 VGND VPWR sky130_fd_sc_hd__tapvpwrvgnd_1
XTAP_1059 VGND VPWR sky130_fd_sc_hd__tapvpwrvgnd_1
XTAP_1048 VGND VPWR sky130_fd_sc_hd__tapvpwrvgnd_1
XFILLER_0_37_225 VGND VGND VPWR VPWR sky130_fd_sc_hd__fill_2
XFILLER_0_108_625 VPWR VGND VPWR VGND sky130_ef_sc_hd__decap_12
XFILLER_0_9_160 VGND VGND VPWR VPWR sky130_fd_sc_hd__decap_8
XFILLER_0_37_236 VGND VGND VPWR VPWR sky130_fd_sc_hd__fill_1
XFILLER_0_108_669 VGND VGND VPWR VPWR sky130_fd_sc_hd__decap_8
XFILLER_0_107_113 VGND VGND VPWR VPWR sky130_fd_sc_hd__fill_2
XFILLER_0_80_515 VGND VGND VPWR VPWR sky130_fd_sc_hd__fill_2
XFILLER_0_18_461 VGND VGND VPWR VPWR sky130_fd_sc_hd__fill_1
XFILLER_0_18_472 VGND VGND VPWR VPWR sky130_fd_sc_hd__fill_2
XANTENNA__4581__B1 _0887_ VGND VGND VPWR VPWR sky130_fd_sc_hd__diode_2
XFILLER_0_33_453 VGND VGND VPWR VPWR sky130_fd_sc_hd__decap_4
XFILLER_0_103_330 VGND VGND VPWR VPWR sky130_fd_sc_hd__decap_6
XANTENNA__7134__RESET_B net76 VGND VGND VPWR VPWR sky130_fd_sc_hd__diode_2
XFILLER_0_87_125 VGND VGND VPWR VPWR sky130_fd_sc_hd__decap_3
XFILLER_0_87_169 VGND VGND VPWR VPWR sky130_fd_sc_hd__decap_6
XTAP_1560 VGND VPWR sky130_fd_sc_hd__tapvpwrvgnd_1
XANTENNA__4135__A u_pe_array.g_pe_row\[3\].g_pe_col\[0\].u_pe.w_reg\[0\] VGND VGND
+ VPWR VPWR sky130_fd_sc_hd__diode_2
XFILLER_0_68_383 VGND VGND VPWR VPWR sky130_fd_sc_hd__fill_1
XTAP_1593 VGND VPWR sky130_fd_sc_hd__tapvpwrvgnd_1
XTAP_1582 VGND VPWR sky130_fd_sc_hd__tapvpwrvgnd_1
XTAP_1571 VGND VPWR sky130_fd_sc_hd__tapvpwrvgnd_1
XFILLER_0_113_57 VPWR VGND VPWR VGND sky130_ef_sc_hd__decap_12
XFILLER_0_71_526 VGND VGND VPWR VPWR sky130_fd_sc_hd__fill_1
XFILLER_0_43_217 VGND VGND VPWR VPWR sky130_fd_sc_hd__fill_1
XFILLER_0_114_617 VPWR VGND VPWR VGND sky130_ef_sc_hd__decap_12
XFILLER_0_98_15 VPWR VGND VPWR VGND sky130_ef_sc_hd__decap_12
XFILLER_0_71_548 VGND VGND VPWR VPWR sky130_fd_sc_hd__fill_2
XANTENNA__6561__A1 _1812_ VGND VGND VPWR VPWR sky130_fd_sc_hd__diode_2
X_3620_ u_pe_array.g_pe_row\[2\].g_pe_col\[2\].u_pe.act_val\[5\] u_pe_array.g_pe_row\[2\].g_pe_col\[2\].u_pe.psum_out\[5\]
+ _0755_ VGND VGND VPWR VPWR _0848_ sky130_fd_sc_hd__mux2_1
XFILLER_0_113_105 VGND VGND VPWR VPWR sky130_fd_sc_hd__fill_2
XFILLER_0_98_59 VGND VGND VPWR VPWR sky130_fd_sc_hd__fill_1
X_3551_ _0794_ u_fsm.v_cnt\[1\] u_fsm.v_cnt\[2\] _0795_ _0796_ VGND VGND VPWR VPWR
+ _0797_ sky130_fd_sc_hd__a311o_1
XFILLER_0_3_325 VGND VGND VPWR VPWR sky130_fd_sc_hd__decap_8
XFILLER_0_24_442 VGND VGND VPWR VPWR sky130_fd_sc_hd__fill_1
X_6270_ _3059_ _3060_ VGND VGND VPWR VPWR _3061_ sky130_fd_sc_hd__and2_1
X_3482_ u_pe_array.g_pe_row\[3\].g_pe_col\[0\].u_pe.move_reg\[8\] _0730_ VGND VGND
+ VPWR VPWR _0749_ sky130_fd_sc_hd__or2_1
X_5221_ net644 _1714_ _2172_ _2173_ VGND VGND VPWR VPWR _0291_ sky130_fd_sc_hd__a22o_1
XFILLER_0_11_169 VGND VGND VPWR VPWR sky130_fd_sc_hd__fill_1
XANTENNA__6496__S _3208_ VGND VGND VPWR VPWR sky130_fd_sc_hd__diode_2
X_5152_ _2119_ _2124_ VGND VGND VPWR VPWR _2125_ sky130_fd_sc_hd__nor2_1
X_4103_ net95 net84 _0828_ VGND VGND VPWR VPWR _1254_ sky130_fd_sc_hd__mux2_1
XANTENNA__4627__A1 _1273_ VGND VGND VPWR VPWR sky130_fd_sc_hd__diode_2
XFILLER_0_47_96 VGND VGND VPWR VPWR sky130_fd_sc_hd__decap_8
X_5083_ u_pe_array.g_pe_row\[1\].g_pe_col\[3\].u_pe.w_reg\[0\] u_pe_array.g_pe_row\[1\].g_pe_col\[3\].u_pe.act_val\[4\]
+ _2059_ _2060_ VGND VGND VPWR VPWR _2062_ sky130_fd_sc_hd__o2bb2a_1
X_4034_ _1177_ _1178_ _1191_ VGND VGND VPWR VPWR _1193_ sky130_fd_sc_hd__nor3_2
XFILLER_0_63_51 VGND VGND VPWR VPWR sky130_fd_sc_hd__decap_4
XFILLER_0_2_65 VPWR VGND VPWR VGND sky130_ef_sc_hd__decap_12
XFILLER_0_66_309 VGND VGND VPWR VPWR sky130_fd_sc_hd__decap_4
XFILLER_0_59_350 VGND VGND VPWR VPWR sky130_fd_sc_hd__fill_2
XANTENNA__6244__B _2992_ VGND VGND VPWR VPWR sky130_fd_sc_hd__diode_2
XFILLER_0_59_372 VGND VGND VPWR VPWR sky130_fd_sc_hd__decap_3
XPHY_109 VGND VGND VPWR VPWR sky130_fd_sc_hd__decap_3
X_5985_ _2792_ _2804_ _2814_ _2819_ VGND VGND VPWR VPWR _2820_ sky130_fd_sc_hd__or4_1
X_4936_ u_pe_array.g_pe_row\[2\].g_pe_col\[0\].u_pe.psum_out\[7\] u_pe_array.g_pe_row\[2\].g_pe_col\[0\].u_pe.psum_out\[8\]
+ _1847_ VGND VGND VPWR VPWR _1937_ sky130_fd_sc_hd__o21a_1
XFILLER_0_47_545 VGND VGND VPWR VPWR sky130_fd_sc_hd__fill_1
X_4867_ _1873_ _1874_ VGND VGND VPWR VPWR _1875_ sky130_fd_sc_hd__and2b_1
X_7655_ clknet_leaf_20_clk _0704_ VGND VGND VPWR VPWR u_pe_array.u_fifo1.buffer\[7\]\[0\]
+ sky130_fd_sc_hd__dfxtp_1
XANTENNA__5575__S _2469_ VGND VGND VPWR VPWR sky130_fd_sc_hd__diode_2
XFILLER_0_34_206 VGND VGND VPWR VPWR sky130_fd_sc_hd__fill_2
XFILLER_0_105_617 VPWR VGND VPWR VGND sky130_ef_sc_hd__decap_12
X_7586_ clknet_leaf_26_clk _0635_ VGND VGND VPWR VPWR u_pe_array.u_fifo1.buffer\[1\]\[9\]
+ sky130_fd_sc_hd__dfxtp_1
XFILLER_0_62_548 VGND VGND VPWR VPWR sky130_fd_sc_hd__fill_1
XFILLER_0_7_653 VPWR VGND VPWR VGND sky130_ef_sc_hd__decap_12
XFILLER_0_6_141 VPWR VGND VPWR VGND sky130_ef_sc_hd__decap_12
X_6606_ _3272_ VGND VGND VPWR VPWR _0577_ sky130_fd_sc_hd__clkbuf_1
X_3818_ u_pe_array.g_pe_row\[3\].g_pe_col\[2\].u_pe.w_reg\[1\] VGND VGND VPWR VPWR
+ _1009_ sky130_fd_sc_hd__buf_6
X_4798_ u_pe_array.g_pe_row\[1\].g_pe_col\[0\].u_pe.w_buffer\[1\] net796 _0828_ VGND
+ VGND VPWR VPWR _1823_ sky130_fd_sc_hd__mux2_1
X_6537_ net299 _1816_ _3224_ VGND VGND VPWR VPWR _3235_ sky130_fd_sc_hd__mux2_1
XFILLER_0_15_497 VGND VGND VPWR VPWR sky130_fd_sc_hd__decap_6
X_3749_ u_pe_array.g_pe_row\[3\].g_pe_col\[3\].u_pe.psum_out\[9\] _0869_ VGND VGND
+ VPWR VPWR _0960_ sky130_fd_sc_hd__or2_1
XFILLER_0_42_261 VGND VGND VPWR VPWR sky130_fd_sc_hd__fill_2
X_6468_ _3198_ VGND VGND VPWR VPWR _0513_ sky130_fd_sc_hd__clkbuf_1
XANTENNA_clkbuf_leaf_63_clk_A clknet_3_5__leaf_clk VGND VGND VPWR VPWR sky130_fd_sc_hd__diode_2
XFILLER_0_112_193 VGND VGND VPWR VPWR sky130_fd_sc_hd__decap_3
X_5419_ u_pe_array.g_pe_row\[1\].g_pe_col\[1\].u_pe.w_reg\[1\] VGND VGND VPWR VPWR
+ _2345_ sky130_fd_sc_hd__clkbuf_8
X_6399_ _3154_ _3158_ _3159_ _3160_ net669 VGND VGND VPWR VPWR _0482_ sky130_fd_sc_hd__a32o_1
XANTENNA__3675__A_N u_pe_array.g_pe_row\[3\].g_pe_col\[3\].u_pe.act_val\[2\] VGND
+ VGND VPWR VPWR sky130_fd_sc_hd__diode_2
XANTENNA__3669__A2 _0875_ VGND VGND VPWR VPWR sky130_fd_sc_hd__diode_2
XANTENNA_clkbuf_leaf_78_clk_A clknet_3_4__leaf_clk VGND VGND VPWR VPWR sky130_fd_sc_hd__diode_2
XFILLER_0_97_489 VGND VGND VPWR VPWR sky130_fd_sc_hd__fill_2
XANTENNA__5043__B2 _1665_ VGND VGND VPWR VPWR sky130_fd_sc_hd__diode_2
XANTENNA__6791__A1 _3126_ VGND VGND VPWR VPWR sky130_fd_sc_hd__diode_2
XFILLER_0_108_433 VGND VGND VPWR VPWR sky130_fd_sc_hd__fill_1
XFILLER_0_93_673 VGND VGND VPWR VPWR sky130_fd_sc_hd__decap_4
XFILLER_0_92_161 VGND VGND VPWR VPWR sky130_fd_sc_hd__fill_2
XANTENNA_clkbuf_leaf_16_clk_A clknet_3_2__leaf_clk VGND VGND VPWR VPWR sky130_fd_sc_hd__diode_2
XFILLER_0_65_353 VGND VGND VPWR VPWR sky130_fd_sc_hd__fill_2
XFILLER_0_38_589 VGND VGND VPWR VPWR sky130_fd_sc_hd__decap_3
XFILLER_0_92_172 VGND VGND VPWR VPWR sky130_fd_sc_hd__fill_2
XANTENNA__7386__RESET_B net13 VGND VGND VPWR VPWR sky130_fd_sc_hd__diode_2
XFILLER_0_53_559 VGND VGND VPWR VPWR sky130_fd_sc_hd__fill_1
XFILLER_0_111_609 VGND VGND VPWR VPWR sky130_fd_sc_hd__decap_6
XFILLER_0_61_581 VGND VGND VPWR VPWR sky130_fd_sc_hd__fill_2
XFILLER_0_33_261 VGND VGND VPWR VPWR sky130_fd_sc_hd__decap_3
XFILLER_0_68_29 VPWR VGND VPWR VGND sky130_ef_sc_hd__decap_12
XANTENNA__7315__RESET_B net814 VGND VGND VPWR VPWR sky130_fd_sc_hd__diode_2
XTAP_607 VGND VPWR sky130_fd_sc_hd__tapvpwrvgnd_1
XTAP_618 VGND VPWR sky130_fd_sc_hd__tapvpwrvgnd_1
XTAP_629 VGND VPWR sky130_fd_sc_hd__tapvpwrvgnd_1
XANTENNA__4609__B2 _1399_ VGND VGND VPWR VPWR sky130_fd_sc_hd__diode_2
XANTENNA__6950__RESET_B net815 VGND VGND VPWR VPWR sky130_fd_sc_hd__diode_2
XANTENNA__5282__A1 _1725_ VGND VGND VPWR VPWR sky130_fd_sc_hd__diode_2
XFILLER_0_17_77 VGND VGND VPWR VPWR sky130_fd_sc_hd__decap_3
XFILLER_0_88_445 VGND VGND VPWR VPWR sky130_fd_sc_hd__fill_2
XFILLER_0_88_489 VGND VGND VPWR VPWR sky130_fd_sc_hd__decap_3
XFILLER_0_29_512 VGND VGND VPWR VPWR sky130_fd_sc_hd__fill_2
XANTENNA__5585__A2 u_pe_array.g_pe_row\[1\].g_pe_col\[0\].u_pe.w_reg\[0\] VGND VGND
+ VPWR VPWR sky130_fd_sc_hd__diode_2
XFILLER_0_8_417 VGND VGND VPWR VPWR sky130_fd_sc_hd__decap_3
XFILLER_0_29_545 VGND VGND VPWR VPWR sky130_fd_sc_hd__fill_2
XFILLER_0_33_54 VGND VGND VPWR VPWR sky130_fd_sc_hd__fill_2
X_5770_ _2634_ _2636_ VGND VGND VPWR VPWR _2638_ sky130_fd_sc_hd__nand2_1
XTAP_1390 VGND VPWR sky130_fd_sc_hd__tapvpwrvgnd_1
X_4721_ _1725_ _1762_ _1763_ _1534_ net687 VGND VGND VPWR VPWR _0201_ sky130_fd_sc_hd__a32o_1
XFILLER_0_56_375 VGND VGND VPWR VPWR sky130_fd_sc_hd__fill_1
XFILLER_0_8_439 VGND VGND VPWR VPWR sky130_fd_sc_hd__fill_1
X_4652_ _1689_ _1700_ VGND VGND VPWR VPWR _1701_ sky130_fd_sc_hd__xor2_1
XFILLER_0_71_323 VGND VGND VPWR VPWR sky130_fd_sc_hd__decap_6
XFILLER_0_4_601 VPWR VGND VPWR VGND sky130_ef_sc_hd__decap_12
X_7440_ clknet_leaf_3_clk _0489_ VGND VGND VPWR VPWR u_pe_array.u_fifo2.buffer\[0\]\[5\]
+ sky130_fd_sc_hd__dfxtp_1
Xinput30 w_in_flat[3] VGND VGND VPWR VPWR net30 sky130_fd_sc_hd__buf_1
XFILLER_0_71_356 VGND VGND VPWR VPWR sky130_fd_sc_hd__decap_3
X_3603_ _0835_ VGND VGND VPWR VPWR _0836_ sky130_fd_sc_hd__buf_8
XFILLER_0_3_111 VGND VGND VPWR VPWR sky130_fd_sc_hd__fill_1
XFILLER_0_114_469 VGND VGND VPWR VPWR sky130_fd_sc_hd__decap_6
XFILLER_0_114_447 VGND VGND VPWR VPWR sky130_fd_sc_hd__fill_1
X_7371_ clknet_leaf_47_clk _0426_ net812 VGND VGND VPWR VPWR u_pe_array.g_pe_row\[0\].g_pe_col\[0\].u_pe.move_reg\[10\]
+ sky130_fd_sc_hd__dfrtp_1
X_4583_ _1649_ VGND VGND VPWR VPWR _0177_ sky130_fd_sc_hd__clkbuf_1
XFILLER_0_4_645 VPWR VGND VPWR VGND sky130_ef_sc_hd__decap_12
X_6322_ _3106_ u_pe_array.u_fifo1.wr_ptr\[1\] VGND VGND VPWR VPWR _3107_ sky130_fd_sc_hd__nor2_1
X_3534_ _0718_ u_fsm.state\[1\] VGND VGND VPWR VPWR _0781_ sky130_fd_sc_hd__nand2_1
XANTENNA__7056__RESET_B net819 VGND VGND VPWR VPWR sky130_fd_sc_hd__diode_2
X_6253_ net772 _0867_ _3044_ _3045_ VGND VGND VPWR VPWR _0451_ sky130_fd_sc_hd__a22o_1
X_3465_ _0728_ _0737_ VGND VGND VPWR VPWR _0738_ sky130_fd_sc_hd__and2_1
XFILLER_0_3_199 VGND VGND VPWR VPWR sky130_fd_sc_hd__fill_1
X_5204_ u_pe_array.g_pe_row\[1\].g_pe_col\[2\].u_pe.w_reg\[1\] VGND VGND VPWR VPWR
+ _2158_ sky130_fd_sc_hd__clkbuf_8
X_6184_ net27 u_pe_array.g_pe_row\[0\].g_pe_col\[0\].u_pe.w_buffer\[0\] _0827_ VGND
+ VGND VPWR VPWR _2986_ sky130_fd_sc_hd__mux2_1
X_5135_ _2100_ _2104_ _2109_ VGND VGND VPWR VPWR _2110_ sky130_fd_sc_hd__a21oi_2
XFILLER_0_35_3 VGND VGND VPWR VPWR sky130_fd_sc_hd__fill_2
XFILLER_0_79_401 VGND VGND VPWR VPWR sky130_fd_sc_hd__decap_3
X_5066_ _2042_ _2043_ _2045_ VGND VGND VPWR VPWR _2046_ sky130_fd_sc_hd__o21a_1
XFILLER_0_74_72 VPWR VGND VPWR VGND sky130_ef_sc_hd__decap_12
X_4017_ _1145_ _1175_ u_pe_array.g_pe_row\[3\].g_pe_col\[1\].u_pe.psum_out\[4\] VGND
+ VGND VPWR VPWR _1177_ sky130_fd_sc_hd__and3_1
XANTENNA__3598__B _0729_ VGND VGND VPWR VPWR sky130_fd_sc_hd__diode_2
XFILLER_0_90_60 VGND VGND VPWR VPWR sky130_fd_sc_hd__decap_4
XFILLER_0_66_128 VGND VGND VPWR VPWR sky130_fd_sc_hd__fill_1
X_5968_ _2791_ _2794_ _2792_ VGND VGND VPWR VPWR _2805_ sky130_fd_sc_hd__o21ba_1
XANTENNA__5576__A2 _2463_ VGND VGND VPWR VPWR sky130_fd_sc_hd__diode_2
X_4919_ _1911_ _1914_ _1921_ VGND VGND VPWR VPWR _1922_ sky130_fd_sc_hd__a21oi_1
XFILLER_0_75_673 VGND VGND VPWR VPWR sky130_fd_sc_hd__fill_2
XFILLER_0_47_397 VGND VGND VPWR VPWR sky130_fd_sc_hd__fill_2
X_5899_ u_pe_array.g_pe_row\[0\].g_pe_col\[2\].u_pe.act_val\[0\] u_pe_array.g_pe_row\[0\].g_pe_col\[2\].u_pe.psum_out\[0\]
+ u_pe_array.g_pe_row\[0\].g_pe_col\[2\].u_pe.w_reg\[0\] VGND VGND VPWR VPWR _2742_
+ sky130_fd_sc_hd__nand3_1
X_7638_ clknet_leaf_24_clk _0687_ VGND VGND VPWR VPWR u_pe_array.u_fifo1.buffer\[5\]\[9\]
+ sky130_fd_sc_hd__dfxtp_1
XFILLER_0_105_425 VGND VGND VPWR VPWR sky130_fd_sc_hd__fill_2
XFILLER_0_105_469 VGND VGND VPWR VPWR sky130_fd_sc_hd__fill_1
X_7569_ clknet_leaf_28_clk _0618_ VGND VGND VPWR VPWR u_pe_array.u_fifo1.buffer\[0\]\[5\]
+ sky130_fd_sc_hd__dfxtp_1
XANTENNA__4000__A2 _1152_ VGND VGND VPWR VPWR sky130_fd_sc_hd__diode_2
XFILLER_0_30_253 VGND VGND VPWR VPWR sky130_fd_sc_hd__decap_4
XFILLER_0_101_664 VGND VGND VPWR VPWR sky130_fd_sc_hd__decap_8
XANTENNA__6864__S _3412_ VGND VGND VPWR VPWR sky130_fd_sc_hd__diode_2
XANTENNA__5988__B _2743_ VGND VGND VPWR VPWR sky130_fd_sc_hd__diode_2
XANTENNA_input19_A v_in0[4] VGND VGND VPWR VPWR sky130_fd_sc_hd__diode_2
XFILLER_0_97_220 VGND VGND VPWR VPWR sky130_fd_sc_hd__fill_2
XANTENNA__3814__A2 _0996_ VGND VGND VPWR VPWR sky130_fd_sc_hd__diode_2
XANTENNA__6764__A1 _3126_ VGND VGND VPWR VPWR sky130_fd_sc_hd__diode_2
XFILLER_0_108_230 VGND VGND VPWR VPWR sky130_fd_sc_hd__decap_3
XFILLER_0_93_492 VGND VGND VPWR VPWR sky130_fd_sc_hd__fill_2
XFILLER_0_111_428 VGND VGND VPWR VPWR sky130_fd_sc_hd__fill_2
XFILLER_0_80_197 VGND VGND VPWR VPWR sky130_fd_sc_hd__fill_2
XFILLER_0_0_169 VPWR VGND VPWR VGND sky130_ef_sc_hd__decap_12
XTAP_415 VGND VPWR sky130_fd_sc_hd__tapvpwrvgnd_1
XTAP_404 VGND VPWR sky130_fd_sc_hd__tapvpwrvgnd_1
XFILLER_0_95_49 VGND VGND VPWR VPWR sky130_fd_sc_hd__fill_2
XTAP_426 VGND VPWR sky130_fd_sc_hd__tapvpwrvgnd_1
XTAP_437 VGND VPWR sky130_fd_sc_hd__tapvpwrvgnd_1
XTAP_448 VGND VPWR sky130_fd_sc_hd__tapvpwrvgnd_1
XTAP_459 VGND VPWR sky130_fd_sc_hd__tapvpwrvgnd_1
X_6940_ clknet_leaf_81_clk _0023_ net74 VGND VGND VPWR VPWR u_pe_array.g_pe_row\[3\].g_pe_col\[2\].u_pe.move_reg\[12\]
+ sky130_fd_sc_hd__dfrtp_1
XFILLER_0_88_242 VGND VGND VPWR VPWR sky130_fd_sc_hd__fill_2
XANTENNA__3805__A2 _0996_ VGND VGND VPWR VPWR sky130_fd_sc_hd__diode_2
X_6871_ _3418_ VGND VGND VPWR VPWR _0696_ sky130_fd_sc_hd__clkbuf_1
XFILLER_0_76_426 VGND VGND VPWR VPWR sky130_fd_sc_hd__fill_1
XFILLER_0_88_297 VGND VGND VPWR VPWR sky130_fd_sc_hd__fill_2
X_5822_ _2671_ _2672_ _2678_ _2666_ _2684_ VGND VGND VPWR VPWR _2685_ sky130_fd_sc_hd__a32o_1
XFILLER_0_57_673 VGND VGND VPWR VPWR sky130_fd_sc_hd__fill_2
X_5753_ _2620_ _2621_ VGND VGND VPWR VPWR _2622_ sky130_fd_sc_hd__xnor2_1
XANTENNA__4766__B1 _0992_ VGND VGND VPWR VPWR sky130_fd_sc_hd__diode_2
X_4704_ _1734_ _1735_ _1741_ _1729_ _1747_ VGND VGND VPWR VPWR _1748_ sky130_fd_sc_hd__a32o_1
XFILLER_0_60_41 VPWR VGND VPWR VGND sky130_ef_sc_hd__decap_12
XFILLER_0_17_515 VGND VGND VPWR VPWR sky130_fd_sc_hd__fill_1
XFILLER_0_17_537 VGND VGND VPWR VPWR sky130_fd_sc_hd__fill_1
XFILLER_0_29_375 VGND VGND VPWR VPWR sky130_fd_sc_hd__fill_2
X_5684_ _2565_ _2566_ _2572_ _2568_ _2563_ VGND VGND VPWR VPWR _2573_ sky130_fd_sc_hd__a32o_1
XANTENNA__7237__RESET_B net812 VGND VGND VPWR VPWR sky130_fd_sc_hd__diode_2
XFILLER_0_56_194 VGND VGND VPWR VPWR sky130_fd_sc_hd__fill_2
XFILLER_0_17_559 VGND VGND VPWR VPWR sky130_fd_sc_hd__fill_1
XFILLER_0_114_244 VGND VGND VPWR VPWR sky130_fd_sc_hd__decap_8
X_4635_ _1680_ _1684_ VGND VGND VPWR VPWR _1685_ sky130_fd_sc_hd__xor2_1
X_7423_ clknet_leaf_7_clk _0472_ net74 VGND VGND VPWR VPWR u_pe_array.u_fifo2.wr_ptr\[0\]
+ sky130_fd_sc_hd__dfrtp_1
XFILLER_0_114_277 VGND VGND VPWR VPWR sky130_fd_sc_hd__decap_3
Xhold611 u_pe_array.g_pe_row\[2\].g_pe_col\[1\].u_pe.psum_out\[9\] VGND VGND VPWR
+ VPWR net687 sky130_fd_sc_hd__dlygate4sd3_1
Xhold600 u_pe_array.g_pe_row\[1\].g_pe_col\[2\].u_pe.act_val\[5\] VGND VGND VPWR VPWR
+ net676 sky130_fd_sc_hd__dlygate4sd3_1
X_7354_ clknet_leaf_64_clk _0409_ net818 VGND VGND VPWR VPWR u_pe_array.g_pe_row\[0\].g_pe_col\[2\].u_pe.psum_out\[8\]
+ sky130_fd_sc_hd__dfrtp_2
XFILLER_0_4_475 VGND VGND VPWR VPWR sky130_fd_sc_hd__fill_1
X_4566_ _1627_ _1629_ _1635_ VGND VGND VPWR VPWR _1636_ sky130_fd_sc_hd__and3_1
XFILLER_0_114_299 VGND VGND VPWR VPWR sky130_fd_sc_hd__decap_8
Xhold633 u_pe_array.g_pe_row\[0\].g_pe_col\[0\].u_pe.psum_out\[8\] VGND VGND VPWR
+ VPWR net709 sky130_fd_sc_hd__dlygate4sd3_1
X_6305_ _2740_ _3091_ _3092_ _0866_ net750 VGND VGND VPWR VPWR _0456_ sky130_fd_sc_hd__a32o_1
X_3517_ u_pe_array.g_pe_row\[1\].g_pe_col\[0\].u_pe.move_reg\[7\] _0770_ VGND VGND
+ VPWR VPWR _0772_ sky130_fd_sc_hd__or2_1
Xhold622 u_pe_array.g_pe_row\[2\].g_pe_col\[3\].u_pe.w_buffer\[1\] VGND VGND VPWR
+ VPWR net698 sky130_fd_sc_hd__dlygate4sd3_1
Xhold644 u_pe_array.g_pe_row\[3\].g_pe_col\[3\].u_pe.psum_out\[4\] VGND VGND VPWR
+ VPWR net720 sky130_fd_sc_hd__dlygate4sd3_1
X_7285_ clknet_leaf_42_clk net101 net75 VGND VGND VPWR VPWR u_pe_array.g_pe_row\[1\].g_pe_col\[0\].u_pe.w_reg\[1\]
+ sky130_fd_sc_hd__dfrtp_1
Xhold666 u_pe_array.g_pe_row\[2\].g_pe_col\[0\].u_pe.psum_out\[9\] VGND VGND VPWR
+ VPWR net742 sky130_fd_sc_hd__dlygate4sd3_1
Xhold655 u_pe_array.u_fifo2.count\[0\] VGND VGND VPWR VPWR net731 sky130_fd_sc_hd__dlygate4sd3_1
X_4497_ _1570_ _1571_ _1572_ VGND VGND VPWR VPWR _1573_ sky130_fd_sc_hd__and3_1
Xhold688 u_pe_array.g_pe_row\[3\].g_pe_col\[2\].u_pe.act_val\[0\] VGND VGND VPWR VPWR
+ net764 sky130_fd_sc_hd__dlygate4sd3_1
Xhold677 u_pe_array.g_pe_row\[0\].g_pe_col\[2\].u_pe.act_val\[4\] VGND VGND VPWR VPWR
+ net753 sky130_fd_sc_hd__dlygate4sd3_1
XFILLER_0_110_483 VPWR VGND VPWR VGND sky130_ef_sc_hd__decap_12
X_6236_ _3028_ _3029_ VGND VGND VPWR VPWR _3030_ sky130_fd_sc_hd__nand2_1
X_3448_ u_fsm.state\[1\] VGND VGND VPWR VPWR _0723_ sky130_fd_sc_hd__inv_2
Xhold699 u_pe_array.g_pe_row\[1\].g_pe_col\[3\].u_pe.act_val\[2\] VGND VGND VPWR VPWR
+ net775 sky130_fd_sc_hd__dlygate4sd3_1
X_6167_ _2969_ _2971_ VGND VGND VPWR VPWR _2972_ sky130_fd_sc_hd__or2_1
XTAP_960 VGND VPWR sky130_fd_sc_hd__tapvpwrvgnd_1
XTAP_971 VGND VPWR sky130_fd_sc_hd__tapvpwrvgnd_1
XTAP_993 VGND VPWR sky130_fd_sc_hd__tapvpwrvgnd_1
XTAP_982 VGND VPWR sky130_fd_sc_hd__tapvpwrvgnd_1
X_5118_ _2085_ _2086_ _2089_ VGND VGND VPWR VPWR _2094_ sky130_fd_sc_hd__and3_1
X_6098_ u_pe_array.g_pe_row\[0\].g_pe_col\[1\].u_pe.psum_out\[3\] _2892_ _2893_ VGND
+ VGND VPWR VPWR _2909_ sky130_fd_sc_hd__a21o_1
XANTENNA__5601__B u_pe_array.g_pe_row\[1\].g_pe_col\[0\].u_pe.w_reg\[0\] VGND VGND
+ VPWR VPWR sky130_fd_sc_hd__diode_2
X_5049_ u_pe_array.g_pe_row\[1\].g_pe_col\[3\].u_pe.act_val\[0\] _2029_ u_pe_array.g_pe_row\[1\].g_pe_col\[3\].u_pe.psum_out\[1\]
+ VGND VGND VPWR VPWR _2031_ sky130_fd_sc_hd__and3_1
XANTENNA__5797__A2 _2387_ VGND VGND VPWR VPWR sky130_fd_sc_hd__diode_2
XFILLER_0_82_418 VGND VGND VPWR VPWR sky130_fd_sc_hd__fill_2
XFILLER_0_94_289 VGND VGND VPWR VPWR sky130_fd_sc_hd__fill_2
XFILLER_0_35_323 VGND VGND VPWR VPWR sky130_fd_sc_hd__fill_2
XANTENNA__4233__A _1275_ VGND VGND VPWR VPWR sky130_fd_sc_hd__diode_2
XFILLER_0_35_345 VGND VGND VPWR VPWR sky130_fd_sc_hd__decap_6
XFILLER_0_62_153 VGND VGND VPWR VPWR sky130_fd_sc_hd__fill_2
XANTENNA__5182__B1 _1655_ VGND VGND VPWR VPWR sky130_fd_sc_hd__diode_2
XFILLER_0_62_197 VGND VGND VPWR VPWR sky130_fd_sc_hd__fill_2
XFILLER_0_62_186 VGND VGND VPWR VPWR sky130_fd_sc_hd__decap_3
XFILLER_0_16_581 VGND VGND VPWR VPWR sky130_fd_sc_hd__fill_1
XFILLER_0_31_540 VGND VGND VPWR VPWR sky130_fd_sc_hd__decap_3
XFILLER_0_31_551 VGND VGND VPWR VPWR sky130_fd_sc_hd__fill_1
XFILLER_0_31_573 VPWR VGND VPWR VGND sky130_ef_sc_hd__decap_12
XFILLER_0_101_461 VGND VGND VPWR VPWR sky130_fd_sc_hd__fill_2
XANTENNA__4288__A2 _1392_ VGND VGND VPWR VPWR sky130_fd_sc_hd__diode_2
XANTENNA__6737__A1 _3126_ VGND VGND VPWR VPWR sky130_fd_sc_hd__diode_2
XFILLER_0_105_69 VGND VGND VPWR VPWR sky130_fd_sc_hd__fill_1
XFILLER_0_73_429 VGND VGND VPWR VPWR sky130_fd_sc_hd__decap_3
XFILLER_0_39_673 VGND VGND VPWR VPWR sky130_fd_sc_hd__fill_1
XFILLER_0_109_561 VPWR VGND VPWR VGND sky130_ef_sc_hd__decap_12
XFILLER_0_26_356 VGND VGND VPWR VPWR sky130_fd_sc_hd__decap_4
XANTENNA__7330__RESET_B net13 VGND VGND VPWR VPWR sky130_fd_sc_hd__diode_2
XFILLER_0_81_462 VGND VGND VPWR VPWR sky130_fd_sc_hd__fill_2
XFILLER_0_14_529 VGND VGND VPWR VPWR sky130_fd_sc_hd__decap_3
XFILLER_0_81_495 VGND VGND VPWR VPWR sky130_fd_sc_hd__fill_2
XANTENNA__5173__B1 _1655_ VGND VGND VPWR VPWR sky130_fd_sc_hd__diode_2
XFILLER_0_30_77 VGND VGND VPWR VPWR sky130_fd_sc_hd__decap_4
X_4420_ net92 u_pe_array.g_pe_row\[2\].g_pe_col\[2\].u_pe.w_buffer\[0\] _0828_ VGND
+ VGND VPWR VPWR _1515_ sky130_fd_sc_hd__mux2_1
XFILLER_0_41_337 VGND VGND VPWR VPWR sky130_fd_sc_hd__fill_2
XANTENNA__5712__A2 _2463_ VGND VGND VPWR VPWR sky130_fd_sc_hd__diode_2
X_4351_ _1438_ _1439_ _1452_ VGND VGND VPWR VPWR _1454_ sky130_fd_sc_hd__nor3_2
XANTENNA__4289__S _0855_ VGND VGND VPWR VPWR sky130_fd_sc_hd__diode_2
X_7070_ clknet_leaf_90_clk _0143_ net819 VGND VGND VPWR VPWR u_pe_array.g_pe_row\[2\].g_pe_col\[3\].u_pe.psum_out\[7\]
+ sky130_fd_sc_hd__dfrtp_4
X_4282_ u_pe_array.g_pe_row\[2\].g_pe_col\[3\].u_pe.psum_out\[6\] u_pe_array.g_pe_row\[2\].g_pe_col\[3\].u_pe.move_reg\[6\]
+ _0855_ VGND VGND VPWR VPWR _1397_ sky130_fd_sc_hd__mux2_1
XANTENNA_clkbuf_3_3__f_clk_A clknet_0_clk VGND VGND VPWR VPWR sky130_fd_sc_hd__diode_2
X_6021_ u_pe_array.g_pe_row\[0\].g_pe_col\[2\].u_pe.psum_out\[12\] _2845_ VGND VGND
+ VPWR VPWR _2852_ sky130_fd_sc_hd__xnor2_1
XANTENNA__4279__A2 _1392_ VGND VGND VPWR VPWR sky130_fd_sc_hd__diode_2
XTAP_256 VGND VPWR sky130_fd_sc_hd__tapvpwrvgnd_1
XTAP_234 VGND VPWR sky130_fd_sc_hd__tapvpwrvgnd_1
XTAP_245 VGND VPWR sky130_fd_sc_hd__tapvpwrvgnd_1
XANTENNA_hold27_A u_pe_array.g_pe_row\[2\].g_pe_col\[2\].u_pe.w_buffer\[0\] VGND VGND
+ VPWR VPWR sky130_fd_sc_hd__diode_2
XTAP_289 VGND VPWR sky130_fd_sc_hd__tapvpwrvgnd_1
XTAP_267 VGND VPWR sky130_fd_sc_hd__tapvpwrvgnd_1
XTAP_278 VGND VPWR sky130_fd_sc_hd__tapvpwrvgnd_1
XFILLER_0_55_96 VGND VGND VPWR VPWR sky130_fd_sc_hd__fill_1
X_6923_ clknet_leaf_59_clk u_fsm.next_state\[0\] net813 VGND VGND VPWR VPWR u_fsm.state\[0\]
+ sky130_fd_sc_hd__dfrtp_1
X_6854_ net197 _3132_ _3397_ VGND VGND VPWR VPWR _3409_ sky130_fd_sc_hd__mux2_1
XFILLER_0_91_237 VGND VGND VPWR VPWR sky130_fd_sc_hd__decap_8
X_6785_ net518 _3120_ _3366_ VGND VGND VPWR VPWR _3372_ sky130_fd_sc_hd__mux2_1
X_3997_ _1156_ _1158_ VGND VGND VPWR VPWR _1159_ sky130_fd_sc_hd__xnor2_2
XFILLER_0_57_481 VGND VGND VPWR VPWR sky130_fd_sc_hd__fill_2
XFILLER_0_45_621 VGND VGND VPWR VPWR sky130_fd_sc_hd__fill_2
X_5805_ _2668_ _2664_ VGND VGND VPWR VPWR _2670_ sky130_fd_sc_hd__and2b_1
XANTENNA__5400__B2 _1665_ VGND VGND VPWR VPWR sky130_fd_sc_hd__diode_2
XFILLER_0_44_131 VGND VGND VPWR VPWR sky130_fd_sc_hd__decap_3
XANTENNA__7071__RESET_B net819 VGND VGND VPWR VPWR sky130_fd_sc_hd__diode_2
X_5736_ u_pe_array.g_pe_row\[0\].g_pe_col\[3\].u_pe.w_reg\[0\] u_pe_array.g_pe_row\[0\].g_pe_col\[3\].u_pe.act_val\[0\]
+ u_pe_array.g_pe_row\[0\].g_pe_col\[3\].u_pe.psum_out\[0\] VGND VGND VPWR VPWR _2607_
+ sky130_fd_sc_hd__a21o_1
XANTENNA__7000__RESET_B net76 VGND VGND VPWR VPWR sky130_fd_sc_hd__diode_2
X_5667_ u_pe_array.g_pe_row\[1\].g_pe_col\[0\].u_pe.psum_out\[8\] _2478_ VGND VGND
+ VPWR VPWR _2558_ sky130_fd_sc_hd__or2_1
XFILLER_0_72_473 VGND VGND VPWR VPWR sky130_fd_sc_hd__decap_3
X_7406_ clknet_leaf_40_clk _0456_ net817 VGND VGND VPWR VPWR u_pe_array.g_pe_row\[0\].g_pe_col\[0\].u_pe.psum_out\[10\]
+ sky130_fd_sc_hd__dfrtp_2
X_4618_ _1669_ VGND VGND VPWR VPWR _1670_ sky130_fd_sc_hd__inv_2
XFILLER_0_44_197 VGND VGND VPWR VPWR sky130_fd_sc_hd__decap_3
XANTENNA__5703__A2 _2387_ VGND VGND VPWR VPWR sky130_fd_sc_hd__diode_2
X_5598_ _2488_ _2490_ VGND VGND VPWR VPWR _2494_ sky130_fd_sc_hd__nand2_1
XFILLER_0_4_283 VGND VGND VPWR VPWR sky130_fd_sc_hd__decap_3
Xhold441 u_pe_array.g_pe_row\[2\].g_pe_col\[0\].u_pe.psum_out\[1\] VGND VGND VPWR
+ VPWR net517 sky130_fd_sc_hd__dlygate4sd3_1
Xhold430 u_pe_array.u_fifo1.buffer\[0\]\[1\] VGND VGND VPWR VPWR net506 sky130_fd_sc_hd__dlygate4sd3_1
X_7337_ clknet_leaf_48_clk _0394_ net812 VGND VGND VPWR VPWR u_pe_array.g_pe_row\[0\].g_pe_col\[1\].u_pe.move_reg\[6\]
+ sky130_fd_sc_hd__dfrtp_1
Xhold452 u_pe_array.u_fifo2.buffer\[3\]\[4\] VGND VGND VPWR VPWR net528 sky130_fd_sc_hd__dlygate4sd3_1
X_4549_ _1536_ u_pe_array.g_pe_row\[2\].g_pe_col\[2\].u_pe.psum_out\[9\] VGND VGND
+ VPWR VPWR _1620_ sky130_fd_sc_hd__and2_1
Xhold463 u_pe_array.u_fifo2.buffer\[7\]\[0\] VGND VGND VPWR VPWR net539 sky130_fd_sc_hd__dlygate4sd3_1
X_7268_ clknet_leaf_51_clk _0329_ net812 VGND VGND VPWR VPWR u_pe_array.g_pe_row\[1\].g_pe_col\[1\].u_pe.psum_out\[12\]
+ sky130_fd_sc_hd__dfrtp_1
Xhold496 u_pe_array.g_pe_row\[1\].g_pe_col\[0\].u_pe.psum_out\[1\] VGND VGND VPWR
+ VPWR net572 sky130_fd_sc_hd__dlygate4sd3_1
Xhold474 u_pe_array.g_pe_row\[1\].g_pe_col\[2\].u_pe.psum_out\[12\] VGND VGND VPWR
+ VPWR net550 sky130_fd_sc_hd__dlygate4sd3_1
Xhold485 u_pe_array.u_fifo2.buffer\[3\]\[1\] VGND VGND VPWR VPWR net561 sky130_fd_sc_hd__dlygate4sd3_1
XFILLER_0_110_280 VPWR VGND VPWR VGND sky130_ef_sc_hd__decap_12
X_6219_ _3013_ _2992_ u_pe_array.g_pe_row\[0\].g_pe_col\[0\].u_pe.psum_out\[3\] VGND
+ VGND VPWR VPWR _3014_ sky130_fd_sc_hd__a21oi_1
X_7199_ clknet_leaf_75_clk _0264_ net815 VGND VGND VPWR VPWR u_pe_array.g_pe_row\[1\].g_pe_col\[3\].u_pe.psum_out\[3\]
+ sky130_fd_sc_hd__dfrtp_1
XFILLER_0_99_337 VGND VGND VPWR VPWR sky130_fd_sc_hd__fill_2
XANTENNA__4873__D _1847_ VGND VGND VPWR VPWR sky130_fd_sc_hd__diode_2
XTAP_790 VGND VPWR sky130_fd_sc_hd__tapvpwrvgnd_1
XFILLER_0_95_532 VGND VGND VPWR VPWR sky130_fd_sc_hd__fill_2
XFILLER_0_67_223 VGND VGND VPWR VPWR sky130_fd_sc_hd__fill_1
XANTENNA__4442__A2 _1524_ VGND VGND VPWR VPWR sky130_fd_sc_hd__diode_2
XANTENNA__7159__RESET_B net814 VGND VGND VPWR VPWR sky130_fd_sc_hd__diode_2
XFILLER_0_82_204 VGND VGND VPWR VPWR sky130_fd_sc_hd__decap_8
XFILLER_0_36_643 VGND VGND VPWR VPWR sky130_fd_sc_hd__fill_1
XFILLER_0_63_473 VGND VGND VPWR VPWR sky130_fd_sc_hd__decap_4
XANTENNA__6589__S _3254_ VGND VGND VPWR VPWR sky130_fd_sc_hd__diode_2
XFILLER_0_63_495 VGND VGND VPWR VPWR sky130_fd_sc_hd__decap_3
XFILLER_0_50_134 VGND VGND VPWR VPWR sky130_fd_sc_hd__decap_4
XFILLER_0_2_209 VPWR VGND VPWR VGND sky130_ef_sc_hd__decap_12
XFILLER_0_106_586 VGND VGND VPWR VPWR sky130_fd_sc_hd__fill_2
XFILLER_0_76_29 VGND VGND VPWR VPWR sky130_fd_sc_hd__decap_8
XFILLER_0_98_381 VGND VGND VPWR VPWR sky130_fd_sc_hd__fill_2
XANTENNA__4433__A2 _1392_ VGND VGND VPWR VPWR sky130_fd_sc_hd__diode_2
X_3920_ u_pe_array.g_pe_row\[3\].g_pe_col\[2\].u_pe.psum_out\[7\] u_pe_array.g_pe_row\[3\].g_pe_col\[2\].u_pe.psum_out\[8\]
+ _1009_ VGND VGND VPWR VPWR _1102_ sky130_fd_sc_hd__o21a_1
XFILLER_0_86_554 VGND VGND VPWR VPWR sky130_fd_sc_hd__fill_2
XFILLER_0_46_418 VGND VGND VPWR VPWR sky130_fd_sc_hd__fill_2
X_3851_ _0864_ _1038_ _1039_ _0867_ net389 VGND VGND VPWR VPWR _0055_ sky130_fd_sc_hd__a32o_1
X_3782_ _0731_ _0986_ _0754_ VGND VGND VPWR VPWR _0987_ sky130_fd_sc_hd__mux2_1
X_6570_ _3252_ VGND VGND VPWR VPWR _0561_ sky130_fd_sc_hd__clkbuf_1
XFILLER_0_39_492 VGND VGND VPWR VPWR sky130_fd_sc_hd__fill_2
XFILLER_0_41_54 VGND VGND VPWR VPWR sky130_fd_sc_hd__fill_2
XFILLER_0_109_391 VGND VGND VPWR VPWR sky130_fd_sc_hd__fill_1
X_5521_ _2433_ VGND VGND VPWR VPWR _2438_ sky130_fd_sc_hd__inv_2
XFILLER_0_41_87 VGND VGND VPWR VPWR sky130_fd_sc_hd__fill_1
XFILLER_0_112_501 VPWR VGND VPWR VGND sky130_ef_sc_hd__decap_12
XFILLER_0_81_281 VGND VGND VPWR VPWR sky130_fd_sc_hd__decap_3
XFILLER_0_54_495 VGND VGND VPWR VPWR sky130_fd_sc_hd__decap_6
XFILLER_0_41_101 VGND VGND VPWR VPWR sky130_fd_sc_hd__fill_1
X_5452_ _2362_ _2372_ _2371_ VGND VGND VPWR VPWR _2375_ sky130_fd_sc_hd__a21oi_1
XFILLER_0_41_134 VGND VGND VPWR VPWR sky130_fd_sc_hd__fill_1
XFILLER_0_112_545 VPWR VGND VPWR VGND sky130_ef_sc_hd__decap_12
X_5383_ u_pe_array.u_fifo1.buffer\[5\]\[4\] _2284_ _2285_ u_pe_array.u_fifo1.buffer\[6\]\[4\]
+ _2286_ VGND VGND VPWR VPWR _2319_ sky130_fd_sc_hd__a221o_1
XANTENNA__4320__B _1407_ VGND VGND VPWR VPWR sky130_fd_sc_hd__diode_2
X_4403_ _1499_ _1500_ VGND VGND VPWR VPWR _1501_ sky130_fd_sc_hd__or2_1
XFILLER_0_112_589 VPWR VGND VPWR VGND sky130_ef_sc_hd__decap_12
X_7122_ clknet_leaf_38_clk net88 net76 VGND VGND VPWR VPWR u_pe_array.g_pe_row\[2\].g_pe_col\[1\].u_pe.w_reg\[1\]
+ sky130_fd_sc_hd__dfrtp_1
X_4334_ _1407_ _1436_ u_pe_array.g_pe_row\[2\].g_pe_col\[3\].u_pe.psum_out\[4\] VGND
+ VGND VPWR VPWR _1438_ sky130_fd_sc_hd__and3_1
X_7053_ clknet_leaf_90_clk _0128_ net819 VGND VGND VPWR VPWR u_pe_array.g_pe_row\[2\].g_pe_col\[2\].u_pe.act_val\[5\]
+ sky130_fd_sc_hd__dfrtp_2
XFILLER_0_10_587 VGND VGND VPWR VPWR sky130_fd_sc_hd__fill_1
X_6004_ _2830_ _2831_ _2836_ _2833_ _2828_ VGND VGND VPWR VPWR _2837_ sky130_fd_sc_hd__a32o_1
X_4265_ u_pe_array.g_pe_row\[1\].g_pe_col\[3\].u_pe.w_buffer\[0\] net800 _0828_ VGND
+ VGND VPWR VPWR _1388_ sky130_fd_sc_hd__mux2_1
X_4196_ net659 _1152_ _1325_ _1326_ VGND VGND VPWR VPWR _0113_ sky130_fd_sc_hd__a22o_1
XANTENNA__4121__B2 _1004_ VGND VGND VPWR VPWR sky130_fd_sc_hd__diode_2
XFILLER_0_89_370 VGND VGND VPWR VPWR sky130_fd_sc_hd__fill_1
XFILLER_0_82_83 VGND VGND VPWR VPWR sky130_fd_sc_hd__fill_1
XTAP_1219 VGND VPWR sky130_fd_sc_hd__tapvpwrvgnd_1
XTAP_1208 VGND VPWR sky130_fd_sc_hd__tapvpwrvgnd_1
XFILLER_0_49_212 VGND VGND VPWR VPWR sky130_fd_sc_hd__fill_1
X_6906_ net320 _3128_ _3427_ VGND VGND VPWR VPWR _3437_ sky130_fd_sc_hd__mux2_1
XFILLER_0_77_543 VGND VGND VPWR VPWR sky130_fd_sc_hd__decap_3
XANTENNA__7252__RESET_B net75 VGND VGND VPWR VPWR sky130_fd_sc_hd__diode_2
XFILLER_0_77_598 VGND VGND VPWR VPWR sky130_fd_sc_hd__decap_4
XFILLER_0_77_587 VGND VGND VPWR VPWR sky130_fd_sc_hd__fill_1
X_6837_ _3400_ VGND VGND VPWR VPWR _0680_ sky130_fd_sc_hd__clkbuf_1
XFILLER_0_64_259 VGND VGND VPWR VPWR sky130_fd_sc_hd__fill_2
XFILLER_0_64_237 VGND VGND VPWR VPWR sky130_fd_sc_hd__fill_2
XFILLER_0_17_131 VGND VGND VPWR VPWR sky130_fd_sc_hd__fill_2
X_6768_ net340 _3130_ net62 VGND VGND VPWR VPWR _3363_ sky130_fd_sc_hd__mux2_1
X_6699_ _3327_ VGND VGND VPWR VPWR _0615_ sky130_fd_sc_hd__clkbuf_1
XFILLER_0_60_421 VGND VGND VPWR VPWR sky130_fd_sc_hd__fill_2
X_5719_ u_pe_array.g_pe_row\[0\].g_pe_col\[3\].u_pe.act_val\[5\] u_pe_array.g_pe_row\[0\].g_pe_col\[3\].u_pe.psum_out\[5\]
+ _0770_ VGND VGND VPWR VPWR _2598_ sky130_fd_sc_hd__mux2_1
XFILLER_0_103_501 VGND VGND VPWR VPWR sky130_fd_sc_hd__fill_1
XANTENNA__3699__B1 _0914_ VGND VGND VPWR VPWR sky130_fd_sc_hd__diode_2
XFILLER_0_20_307 VGND VGND VPWR VPWR sky130_fd_sc_hd__fill_1
XFILLER_0_20_329 VGND VGND VPWR VPWR sky130_fd_sc_hd__fill_2
Xhold271 u_pe_array.u_fifo1.buffer\[7\]\[7\] VGND VGND VPWR VPWR net347 sky130_fd_sc_hd__dlygate4sd3_1
Xhold260 u_pe_array.u_fifo1.buffer\[3\]\[10\] VGND VGND VPWR VPWR net336 sky130_fd_sc_hd__dlygate4sd3_1
XFILLER_0_103_589 VGND VGND VPWR VPWR sky130_fd_sc_hd__fill_1
XFILLER_0_103_578 VGND VGND VPWR VPWR sky130_fd_sc_hd__fill_1
XFILLER_0_13_381 VGND VGND VPWR VPWR sky130_fd_sc_hd__decap_8
Xhold293 u_pe_array.u_fifo1.count\[3\] VGND VGND VPWR VPWR net369 sky130_fd_sc_hd__dlygate4sd3_1
Xhold282 u_pe_array.g_pe_row\[3\].g_pe_col\[3\].u_pe.psum_out\[0\] VGND VGND VPWR
+ VPWR net358 sky130_fd_sc_hd__dlygate4sd3_1
XANTENNA__4112__A1 u_pe_array.g_pe_row\[3\].g_pe_col\[3\].u_pe.act_val\[2\] VGND VGND
+ VPWR VPWR sky130_fd_sc_hd__diode_2
XANTENNA__6872__S _3412_ VGND VGND VPWR VPWR sky130_fd_sc_hd__diode_2
XANTENNA__5860__A1 _2258_ VGND VGND VPWR VPWR sky130_fd_sc_hd__diode_2
XFILLER_0_99_178 VGND VGND VPWR VPWR sky130_fd_sc_hd__decap_3
XFILLER_0_87_307 VGND VGND VPWR VPWR sky130_fd_sc_hd__fill_2
XANTENNA__5996__B _2743_ VGND VGND VPWR VPWR sky130_fd_sc_hd__diode_2
XFILLER_0_95_351 VGND VGND VPWR VPWR sky130_fd_sc_hd__fill_1
XFILLER_0_95_362 VGND VGND VPWR VPWR sky130_fd_sc_hd__fill_1
XFILLER_0_68_587 VGND VGND VPWR VPWR sky130_fd_sc_hd__fill_1
XFILLER_0_83_557 VGND VGND VPWR VPWR sky130_fd_sc_hd__decap_3
XFILLER_0_102_15 VPWR VGND VPWR VGND sky130_ef_sc_hd__decap_12
XFILLER_0_70_218 VGND VGND VPWR VPWR sky130_fd_sc_hd__fill_2
XANTENNA__6975__RESET_B net819 VGND VGND VPWR VPWR sky130_fd_sc_hd__diode_2
XFILLER_0_36_473 VGND VGND VPWR VPWR sky130_fd_sc_hd__decap_3
XFILLER_0_63_292 VGND VGND VPWR VPWR sky130_fd_sc_hd__decap_4
XFILLER_0_11_57 VGND VGND VPWR VPWR sky130_fd_sc_hd__fill_2
XFILLER_0_24_635 VGND VGND VPWR VPWR sky130_fd_sc_hd__fill_2
XFILLER_0_11_79 VGND VGND VPWR VPWR sky130_fd_sc_hd__decap_4
XFILLER_0_3_529 VPWR VGND VPWR VGND sky130_ef_sc_hd__decap_12
XFILLER_0_11_318 VGND VGND VPWR VPWR sky130_fd_sc_hd__decap_3
XANTENNA__6308__A_N _2992_ VGND VGND VPWR VPWR sky130_fd_sc_hd__diode_2
XANTENNA__6628__B1 _2592_ VGND VGND VPWR VPWR sky130_fd_sc_hd__diode_2
X_4050_ _1193_ _1206_ _1199_ VGND VGND VPWR VPWR _1208_ sky130_fd_sc_hd__nor3_1
Xinput6 h_in0[5] VGND VGND VPWR VPWR net6 sky130_fd_sc_hd__clkbuf_2
XFILLER_0_36_65 VGND VGND VPWR VPWR sky130_fd_sc_hd__decap_3
X_4952_ _1725_ _1950_ _1951_ _1534_ net488 VGND VGND VPWR VPWR _0244_ sky130_fd_sc_hd__a32o_1
X_4883_ u_pe_array.g_pe_row\[2\].g_pe_col\[0\].u_pe.act_val\[4\] _1847_ VGND VGND
+ VPWR VPWR _1889_ sky130_fd_sc_hd__and2b_1
XFILLER_0_59_598 VGND VGND VPWR VPWR sky130_fd_sc_hd__decap_8
XFILLER_0_52_64 VPWR VGND VPWR VGND sky130_ef_sc_hd__decap_12
XFILLER_0_46_215 VGND VGND VPWR VPWR sky130_fd_sc_hd__fill_2
X_3903_ _1068_ _1078_ u_pe_array.g_pe_row\[3\].g_pe_col\[2\].u_pe.psum_out\[7\] _1064_
+ VGND VGND VPWR VPWR _1087_ sky130_fd_sc_hd__o2bb2a_1
XFILLER_0_46_248 VGND VGND VPWR VPWR sky130_fd_sc_hd__fill_2
X_6622_ _3280_ VGND VGND VPWR VPWR _0585_ sky130_fd_sc_hd__clkbuf_1
X_3834_ _1022_ _1023_ VGND VGND VPWR VPWR _1024_ sky130_fd_sc_hd__xor2_1
XFILLER_0_15_613 VGND VGND VPWR VPWR sky130_fd_sc_hd__decap_3
XFILLER_0_6_345 VGND VGND VPWR VPWR sky130_fd_sc_hd__decap_4
X_6553_ net540 _1804_ _3239_ VGND VGND VPWR VPWR _3244_ sky130_fd_sc_hd__mux2_1
X_3765_ u_pe_array.g_pe_row\[3\].g_pe_col\[3\].u_pe.psum_out\[11\] _0869_ VGND VGND
+ VPWR VPWR _0974_ sky130_fd_sc_hd__and2b_1
X_5504_ _2345_ u_pe_array.g_pe_row\[1\].g_pe_col\[1\].u_pe.psum_out\[8\] VGND VGND
+ VPWR VPWR _2423_ sky130_fd_sc_hd__or2_1
X_3696_ _0902_ _0911_ VGND VGND VPWR VPWR _0912_ sky130_fd_sc_hd__nor2_1
X_6484_ _3206_ VGND VGND VPWR VPWR _0521_ sky130_fd_sc_hd__clkbuf_1
X_5435_ _2352_ _2358_ _0885_ VGND VGND VPWR VPWR _2360_ sky130_fd_sc_hd__o21a_1
XFILLER_0_100_526 VGND VGND VPWR VPWR sky130_fd_sc_hd__fill_2
XFILLER_0_100_515 VGND VGND VPWR VPWR sky130_fd_sc_hd__decap_3
XANTENNA__6331__A2 _1126_ VGND VGND VPWR VPWR sky130_fd_sc_hd__diode_2
XFILLER_0_65_3 VPWR VGND VPWR VGND sky130_ef_sc_hd__decap_12
XFILLER_0_100_548 VGND VGND VPWR VPWR sky130_fd_sc_hd__fill_2
XANTENNA__4893__A2 _1714_ VGND VGND VPWR VPWR sky130_fd_sc_hd__diode_2
X_5366_ u_pe_array.u_fifo1.buffer\[3\]\[2\] _2282_ _2283_ u_pe_array.u_fifo1.buffer\[2\]\[2\]
+ _2303_ VGND VGND VPWR VPWR _2304_ sky130_fd_sc_hd__a221o_1
XFILLER_0_10_362 VGND VGND VPWR VPWR sky130_fd_sc_hd__fill_2
X_5297_ u_pe_array.g_pe_row\[1\].g_pe_col\[2\].u_pe.psum_out\[9\] _2158_ VGND VGND
+ VPWR VPWR _2243_ sky130_fd_sc_hd__nand2_2
X_4317_ net587 _1152_ _0887_ _1422_ VGND VGND VPWR VPWR _0138_ sky130_fd_sc_hd__a22o_1
X_7105_ clknet_leaf_85_clk _0176_ net74 VGND VGND VPWR VPWR u_pe_array.g_pe_row\[2\].g_pe_col\[2\].u_pe.psum_out\[12\]
+ sky130_fd_sc_hd__dfrtp_1
X_4248_ _1371_ _1373_ VGND VGND VPWR VPWR _1374_ sky130_fd_sc_hd__or2_1
X_7036_ clknet_leaf_35_clk _0111_ net816 VGND VGND VPWR VPWR u_pe_array.g_pe_row\[3\].g_pe_col\[0\].u_pe.psum_out\[3\]
+ sky130_fd_sc_hd__dfrtp_1
XANTENNA__7433__RESET_B net816 VGND VGND VPWR VPWR sky130_fd_sc_hd__diode_2
X_4179_ u_pe_array.g_pe_row\[3\].g_pe_col\[0\].u_pe.psum_out\[3\] _1294_ _1295_ VGND
+ VGND VPWR VPWR _1311_ sky130_fd_sc_hd__a21o_1
XFILLER_0_96_115 VGND VGND VPWR VPWR sky130_fd_sc_hd__fill_2
XTAP_1038 VGND VPWR sky130_fd_sc_hd__tapvpwrvgnd_1
XTAP_1027 VGND VPWR sky130_fd_sc_hd__tapvpwrvgnd_1
XTAP_1016 VGND VPWR sky130_fd_sc_hd__tapvpwrvgnd_1
XTAP_1005 VGND VPWR sky130_fd_sc_hd__tapvpwrvgnd_1
XFILLER_0_77_362 VGND VGND VPWR VPWR sky130_fd_sc_hd__decap_8
XTAP_1049 VGND VPWR sky130_fd_sc_hd__tapvpwrvgnd_1
XFILLER_0_65_502 VGND VGND VPWR VPWR sky130_fd_sc_hd__fill_2
XFILLER_0_37_204 VGND VGND VPWR VPWR sky130_fd_sc_hd__fill_2
XFILLER_0_92_321 VGND VGND VPWR VPWR sky130_fd_sc_hd__decap_4
XFILLER_0_108_637 VGND VGND VPWR VPWR sky130_fd_sc_hd__decap_6
XFILLER_0_92_354 VGND VGND VPWR VPWR sky130_fd_sc_hd__decap_8
Xclkbuf_3_3__f_clk clknet_0_clk VGND VGND VPWR VPWR clknet_3_3__leaf_clk sky130_fd_sc_hd__clkbuf_16
XFILLER_0_107_147 VGND VGND VPWR VPWR sky130_fd_sc_hd__decap_4
XFILLER_0_80_549 VGND VGND VPWR VPWR sky130_fd_sc_hd__fill_2
XFILLER_0_45_281 VGND VGND VPWR VPWR sky130_fd_sc_hd__fill_2
XFILLER_0_33_421 VGND VGND VPWR VPWR sky130_fd_sc_hd__fill_2
XFILLER_0_33_498 VGND VGND VPWR VPWR sky130_fd_sc_hd__decap_6
XANTENNA__4333__A1 _1407_ VGND VGND VPWR VPWR sky130_fd_sc_hd__diode_2
XANTENNA__7174__RESET_B net813 VGND VGND VPWR VPWR sky130_fd_sc_hd__diode_2
XANTENNA__4097__B1 _1144_ VGND VGND VPWR VPWR sky130_fd_sc_hd__diode_2
XFILLER_0_88_649 VGND VGND VPWR VPWR sky130_fd_sc_hd__decap_4
XANTENNA__7103__RESET_B net74 VGND VGND VPWR VPWR sky130_fd_sc_hd__diode_2
XFILLER_0_87_148 VGND VGND VPWR VPWR sky130_fd_sc_hd__fill_1
XANTENNA__5597__B1 _2174_ VGND VGND VPWR VPWR sky130_fd_sc_hd__diode_2
XTAP_1550 VGND VPWR sky130_fd_sc_hd__tapvpwrvgnd_1
XFILLER_0_68_351 VGND VGND VPWR VPWR sky130_fd_sc_hd__fill_2
XFILLER_0_56_502 VGND VGND VPWR VPWR sky130_fd_sc_hd__decap_6
XTAP_1594 VGND VPWR sky130_fd_sc_hd__tapvpwrvgnd_1
XTAP_1583 VGND VPWR sky130_fd_sc_hd__tapvpwrvgnd_1
XTAP_1572 VGND VPWR sky130_fd_sc_hd__tapvpwrvgnd_1
XTAP_1561 VGND VPWR sky130_fd_sc_hd__tapvpwrvgnd_1
XFILLER_0_95_181 VGND VGND VPWR VPWR sky130_fd_sc_hd__fill_1
XPHY_90 VGND VGND VPWR VPWR sky130_fd_sc_hd__decap_3
XFILLER_0_7_109 VGND VGND VPWR VPWR sky130_fd_sc_hd__decap_3
XFILLER_0_113_69 VPWR VGND VPWR VGND sky130_ef_sc_hd__decap_12
XFILLER_0_83_365 VGND VGND VPWR VPWR sky130_fd_sc_hd__decap_3
XFILLER_0_71_505 VGND VGND VPWR VPWR sky130_fd_sc_hd__fill_1
XFILLER_0_22_56 VGND VGND VPWR VPWR sky130_fd_sc_hd__decap_6
XFILLER_0_28_259 VGND VGND VPWR VPWR sky130_fd_sc_hd__fill_2
XFILLER_0_24_421 VGND VGND VPWR VPWR sky130_fd_sc_hd__fill_2
XFILLER_0_114_629 VPWR VGND VPWR VGND sky130_ef_sc_hd__decap_12
XFILLER_0_98_27 VGND VGND VPWR VPWR sky130_fd_sc_hd__fill_1
X_3550_ u_fsm.v_cnt\[0\] u_fsm.v_cnt\[1\] u_fsm.v_cnt\[2\] u_fsm.h_cnt\[1\] VGND VGND
+ VPWR VPWR _0796_ sky130_fd_sc_hd__nor4_1
XFILLER_0_106_191 VGND VGND VPWR VPWR sky130_fd_sc_hd__decap_3
XANTENNA__6777__S _3366_ VGND VGND VPWR VPWR sky130_fd_sc_hd__diode_2
XFILLER_0_51_273 VGND VGND VPWR VPWR sky130_fd_sc_hd__decap_4
XFILLER_0_3_337 VGND VGND VPWR VPWR sky130_fd_sc_hd__decap_3
X_3481_ u_pe_array.g_pe_row\[3\].g_pe_col\[0\].u_pe.psum_out\[7\] _0745_ _0748_ _0747_
+ VGND VGND VPWR VPWR net59 sky130_fd_sc_hd__o211a_1
XANTENNA__3990__A _0866_ VGND VGND VPWR VPWR sky130_fd_sc_hd__diode_2
X_5220_ _2165_ _2171_ _0885_ VGND VGND VPWR VPWR _2173_ sky130_fd_sc_hd__o21a_1
XFILLER_0_11_159 VGND VGND VPWR VPWR sky130_fd_sc_hd__fill_2
X_5151_ _2122_ _2123_ VGND VGND VPWR VPWR _2124_ sky130_fd_sc_hd__or2_1
X_4102_ net436 _1152_ _0887_ _1253_ VGND VGND VPWR VPWR _0092_ sky130_fd_sc_hd__a22o_1
X_5082_ _2059_ _2060_ u_pe_array.g_pe_row\[1\].g_pe_col\[3\].u_pe.w_reg\[0\] u_pe_array.g_pe_row\[1\].g_pe_col\[3\].u_pe.act_val\[4\]
+ VGND VGND VPWR VPWR _2061_ sky130_fd_sc_hd__and4bb_1
X_4033_ _1177_ _1178_ _1191_ VGND VGND VPWR VPWR _1192_ sky130_fd_sc_hd__o21a_1
XANTENNA__4088__B1 _0914_ VGND VGND VPWR VPWR sky130_fd_sc_hd__diode_2
XANTENNA__3835__B1 _0887_ VGND VGND VPWR VPWR sky130_fd_sc_hd__diode_2
XFILLER_0_78_115 VGND VGND VPWR VPWR sky130_fd_sc_hd__fill_1
XFILLER_0_2_77 VGND VGND VPWR VPWR sky130_fd_sc_hd__decap_6
XFILLER_0_59_362 VGND VGND VPWR VPWR sky130_fd_sc_hd__fill_2
X_5984_ _2779_ _2780_ _2791_ VGND VGND VPWR VPWR _2819_ sky130_fd_sc_hd__a21oi_1
X_4935_ net742 _1714_ _1935_ _1936_ VGND VGND VPWR VPWR _0242_ sky130_fd_sc_hd__a22o_1
XANTENNA__4260__B1 _1275_ VGND VGND VPWR VPWR sky130_fd_sc_hd__diode_2
XFILLER_0_47_557 VGND VGND VPWR VPWR sky130_fd_sc_hd__decap_3
X_7654_ clknet_leaf_26_clk _0703_ VGND VGND VPWR VPWR u_pe_array.u_fifo1.buffer\[6\]\[12\]
+ sky130_fd_sc_hd__dfxtp_1
X_4866_ _1870_ _1872_ VGND VGND VPWR VPWR _1874_ sky130_fd_sc_hd__nand2_1
XFILLER_0_105_607 VGND VGND VPWR VPWR sky130_fd_sc_hd__decap_8
X_4797_ _1822_ VGND VGND VPWR VPWR _0218_ sky130_fd_sc_hd__clkbuf_1
X_7585_ clknet_leaf_26_clk _0634_ VGND VGND VPWR VPWR u_pe_array.u_fifo1.buffer\[1\]\[8\]
+ sky130_fd_sc_hd__dfxtp_1
XFILLER_0_74_387 VGND VGND VPWR VPWR sky130_fd_sc_hd__fill_2
XFILLER_0_62_527 VGND VGND VPWR VPWR sky130_fd_sc_hd__fill_2
XFILLER_0_7_665 VGND VGND VPWR VPWR sky130_fd_sc_hd__decap_6
XFILLER_0_6_153 VPWR VGND VPWR VGND sky130_ef_sc_hd__decap_12
XFILLER_0_15_410 VPWR VGND VPWR VGND sky130_ef_sc_hd__decap_12
X_3817_ _0864_ _1007_ _1008_ _0867_ net420 VGND VGND VPWR VPWR _0052_ sky130_fd_sc_hd__a32o_1
XFILLER_0_27_281 VGND VGND VPWR VPWR sky130_fd_sc_hd__fill_1
X_6605_ net491 _1800_ _3269_ VGND VGND VPWR VPWR _3272_ sky130_fd_sc_hd__mux2_1
XFILLER_0_105_629 VPWR VGND VPWR VGND sky130_ef_sc_hd__decap_12
X_6536_ _3234_ VGND VGND VPWR VPWR _0545_ sky130_fd_sc_hd__clkbuf_1
X_3748_ u_pe_array.g_pe_row\[3\].g_pe_col\[3\].u_pe.psum_out\[9\] _0869_ VGND VGND
+ VPWR VPWR _0959_ sky130_fd_sc_hd__nand2_2
XFILLER_0_42_251 VGND VGND VPWR VPWR sky130_fd_sc_hd__fill_1
XFILLER_0_113_673 VGND VGND VPWR VPWR sky130_fd_sc_hd__decap_4
XFILLER_0_112_150 VGND VGND VPWR VPWR sky130_fd_sc_hd__fill_2
XANTENNA_load_slew4_A net73 VGND VGND VPWR VPWR sky130_fd_sc_hd__diode_2
X_6467_ net484 _1802_ _3194_ VGND VGND VPWR VPWR _3198_ sky130_fd_sc_hd__mux2_1
X_3679_ u_pe_array.g_pe_row\[3\].g_pe_col\[3\].u_pe.act_val\[2\] u_pe_array.g_pe_row\[3\].g_pe_col\[3\].u_pe.w_reg\[0\]
+ _0880_ VGND VGND VPWR VPWR _0896_ sky130_fd_sc_hd__and3_1
XFILLER_0_30_446 VGND VGND VPWR VPWR sky130_fd_sc_hd__decap_3
XFILLER_0_112_161 VGND VGND VPWR VPWR sky130_fd_sc_hd__decap_3
X_5418_ u_pe_array.g_pe_row\[1\].g_pe_col\[1\].u_pe.w_reg\[0\] u_pe_array.g_pe_row\[1\].g_pe_col\[1\].u_pe.act_val\[1\]
+ VGND VGND VPWR VPWR _2344_ sky130_fd_sc_hd__nand2_1
X_6398_ _1791_ _3146_ VGND VGND VPWR VPWR _3160_ sky130_fd_sc_hd__or2_1
XFILLER_0_2_381 VGND VGND VPWR VPWR sky130_fd_sc_hd__fill_2
X_5349_ u_pe_array.u_fifo1.buffer\[1\]\[0\] _2278_ _2281_ _2288_ VGND VGND VPWR VPWR
+ _2289_ sky130_fd_sc_hd__a211o_1
XFILLER_0_11_671 VGND VGND VPWR VPWR sky130_fd_sc_hd__fill_1
XANTENNA__4079__B1 _1144_ VGND VGND VPWR VPWR sky130_fd_sc_hd__diode_2
X_7019_ clknet_leaf_88_clk _0096_ net819 VGND VGND VPWR VPWR u_pe_array.g_pe_row\[2\].g_pe_col\[3\].u_pe.act_val\[1\]
+ sky130_fd_sc_hd__dfrtp_2
XFILLER_0_97_413 VGND VGND VPWR VPWR sky130_fd_sc_hd__fill_1
XFILLER_0_85_608 VGND VGND VPWR VPWR sky130_fd_sc_hd__fill_2
XANTENNA__5579__B1 _2071_ VGND VGND VPWR VPWR sky130_fd_sc_hd__diode_2
Xmax_cap68 net69 VGND VGND VPWR VPWR net68 sky130_fd_sc_hd__buf_2
XANTENNA__5043__A2 _1666_ VGND VGND VPWR VPWR sky130_fd_sc_hd__diode_2
XFILLER_0_38_502 VGND VGND VPWR VPWR sky130_fd_sc_hd__fill_2
XANTENNA__4251__B1 _0861_ VGND VGND VPWR VPWR sky130_fd_sc_hd__diode_2
XFILLER_0_93_652 VGND VGND VPWR VPWR sky130_fd_sc_hd__fill_2
Xclkbuf_leaf_50_clk clknet_3_7__leaf_clk VGND VGND VPWR VPWR clknet_leaf_50_clk sky130_fd_sc_hd__clkbuf_16
XFILLER_0_108_456 VGND VGND VPWR VPWR sky130_fd_sc_hd__decap_4
XFILLER_0_18_281 VGND VGND VPWR VPWR sky130_fd_sc_hd__fill_2
XFILLER_0_21_402 VGND VGND VPWR VPWR sky130_fd_sc_hd__fill_1
XANTENNA__6597__S _3254_ VGND VGND VPWR VPWR sky130_fd_sc_hd__diode_2
XFILLER_0_21_446 VGND VGND VPWR VPWR sky130_fd_sc_hd__fill_2
XFILLER_0_21_479 VGND VGND VPWR VPWR sky130_fd_sc_hd__decap_4
XANTENNA__7355__RESET_B net818 VGND VGND VPWR VPWR sky130_fd_sc_hd__diode_2
XTAP_608 VGND VPWR sky130_fd_sc_hd__tapvpwrvgnd_1
XTAP_619 VGND VPWR sky130_fd_sc_hd__tapvpwrvgnd_1
XFILLER_0_84_18 VGND VGND VPWR VPWR sky130_fd_sc_hd__decap_6
XANTENNA__4609__A2 _1524_ VGND VGND VPWR VPWR sky130_fd_sc_hd__diode_2
XANTENNA__3817__B1 _0867_ VGND VGND VPWR VPWR sky130_fd_sc_hd__diode_2
XFILLER_0_88_457 VGND VGND VPWR VPWR sky130_fd_sc_hd__fill_2
XANTENNA__6990__RESET_B net816 VGND VGND VPWR VPWR sky130_fd_sc_hd__diode_2
XFILLER_0_76_619 VGND VGND VPWR VPWR sky130_fd_sc_hd__fill_2
XFILLER_0_33_22 VGND VGND VPWR VPWR sky130_fd_sc_hd__decap_3
XTAP_1391 VGND VPWR sky130_fd_sc_hd__tapvpwrvgnd_1
XTAP_1380 VGND VPWR sky130_fd_sc_hd__tapvpwrvgnd_1
Xclkbuf_leaf_41_clk clknet_3_6__leaf_clk VGND VGND VPWR VPWR clknet_leaf_41_clk sky130_fd_sc_hd__clkbuf_16
XFILLER_0_83_151 VGND VGND VPWR VPWR sky130_fd_sc_hd__fill_2
X_4720_ _1753_ _1756_ _1761_ VGND VGND VPWR VPWR _1763_ sky130_fd_sc_hd__or3_1
XFILLER_0_56_365 VGND VGND VPWR VPWR sky130_fd_sc_hd__fill_1
X_4651_ _1698_ _1699_ VGND VGND VPWR VPWR _1700_ sky130_fd_sc_hd__and2b_1
Xinput20 v_in0[5] VGND VGND VPWR VPWR net20 sky130_fd_sc_hd__clkbuf_1
X_3602_ _0729_ _0781_ _0786_ _0717_ VGND VGND VPWR VPWR _0835_ sky130_fd_sc_hd__o2bb2a_2
XFILLER_0_4_613 VPWR VGND VPWR VGND sky130_ef_sc_hd__decap_12
Xinput31 w_in_flat[4] VGND VGND VPWR VPWR net31 sky130_fd_sc_hd__buf_1
X_7370_ clknet_leaf_47_clk _0425_ net812 VGND VGND VPWR VPWR u_pe_array.g_pe_row\[0\].g_pe_col\[0\].u_pe.move_reg\[9\]
+ sky130_fd_sc_hd__dfrtp_1
X_4582_ u_pe_array.g_pe_row\[1\].g_pe_col\[1\].u_pe.w_buffer\[0\] net806 _0828_ VGND
+ VGND VPWR VPWR _1649_ sky130_fd_sc_hd__mux2_1
XFILLER_0_4_657 VPWR VGND VPWR VGND sky130_ef_sc_hd__decap_12
XFILLER_0_101_109 VGND VGND VPWR VPWR sky130_fd_sc_hd__decap_3
X_3533_ _0720_ _0780_ VGND VGND VPWR VPWR net35 sky130_fd_sc_hd__nor2_1
X_6321_ u_pe_array.u_fifo1.wr_ptr\[0\] VGND VGND VPWR VPWR _3106_ sky130_fd_sc_hd__clkbuf_4
XFILLER_0_3_167 VGND VGND VPWR VPWR sky130_fd_sc_hd__fill_1
X_6252_ _3042_ _3043_ _0885_ VGND VGND VPWR VPWR _3045_ sky130_fd_sc_hd__o21a_1
X_3464_ u_pe_array.g_pe_row\[3\].g_pe_col\[0\].u_pe.act_val\[2\] u_pe_array.g_pe_row\[3\].g_pe_col\[0\].u_pe.psum_out\[2\]
+ _0730_ VGND VGND VPWR VPWR _0737_ sky130_fd_sc_hd__mux2_1
XFILLER_0_110_643 VGND VGND VPWR VPWR sky130_fd_sc_hd__fill_1
X_6183_ net749 _0867_ _2174_ _2985_ VGND VGND VPWR VPWR _0441_ sky130_fd_sc_hd__a22o_1
XFILLER_0_58_41 VPWR VGND VPWR VGND sky130_ef_sc_hd__decap_12
X_5203_ u_pe_array.g_pe_row\[1\].g_pe_col\[2\].u_pe.act_val\[1\] u_pe_array.g_pe_row\[1\].g_pe_col\[2\].u_pe.w_reg\[0\]
+ VGND VGND VPWR VPWR _2157_ sky130_fd_sc_hd__nand2_1
XANTENNA__7096__RESET_B net819 VGND VGND VPWR VPWR sky130_fd_sc_hd__diode_2
X_5134_ _2107_ _2108_ VGND VGND VPWR VPWR _2109_ sky130_fd_sc_hd__or2_1
XFILLER_0_20_490 VGND VGND VPWR VPWR sky130_fd_sc_hd__fill_1
XANTENNA__3520__A2 _0769_ VGND VGND VPWR VPWR sky130_fd_sc_hd__diode_2
XANTENNA__7025__RESET_B net74 VGND VGND VPWR VPWR sky130_fd_sc_hd__diode_2
X_5065_ _2039_ _2041_ VGND VGND VPWR VPWR _2045_ sky130_fd_sc_hd__nand2_1
XFILLER_0_79_424 VGND VGND VPWR VPWR sky130_fd_sc_hd__decap_3
XFILLER_0_79_413 VGND VGND VPWR VPWR sky130_fd_sc_hd__fill_1
X_4016_ _1145_ _1175_ u_pe_array.g_pe_row\[3\].g_pe_col\[1\].u_pe.psum_out\[4\] VGND
+ VGND VPWR VPWR _1176_ sky130_fd_sc_hd__a21oi_1
XFILLER_0_28_3 VGND VGND VPWR VPWR sky130_fd_sc_hd__fill_2
XFILLER_0_79_468 VGND VGND VPWR VPWR sky130_fd_sc_hd__fill_1
XFILLER_0_94_416 VGND VGND VPWR VPWR sky130_fd_sc_hd__fill_2
X_5967_ _2802_ _2803_ VGND VGND VPWR VPWR _2804_ sky130_fd_sc_hd__or2_2
Xclkbuf_leaf_32_clk clknet_3_3__leaf_clk VGND VGND VPWR VPWR clknet_leaf_32_clk sky130_fd_sc_hd__clkbuf_16
X_4918_ _1920_ _1900_ _1906_ _1918_ VGND VGND VPWR VPWR _1921_ sky130_fd_sc_hd__a22o_1
XFILLER_0_90_83 VGND VGND VPWR VPWR sky130_fd_sc_hd__fill_1
XFILLER_0_75_652 VGND VGND VPWR VPWR sky130_fd_sc_hd__fill_1
XANTENNA__5981__B1 _2571_ VGND VGND VPWR VPWR sky130_fd_sc_hd__diode_2
XFILLER_0_47_365 VGND VGND VPWR VPWR sky130_fd_sc_hd__fill_2
XANTENNA__4784__A1 _1787_ VGND VGND VPWR VPWR sky130_fd_sc_hd__diode_2
XANTENNA__4784__B2 _0747_ VGND VGND VPWR VPWR sky130_fd_sc_hd__diode_2
XFILLER_0_35_505 VGND VGND VPWR VPWR sky130_fd_sc_hd__decap_8
X_7637_ clknet_leaf_26_clk _0686_ VGND VGND VPWR VPWR u_pe_array.u_fifo1.buffer\[5\]\[8\]
+ sky130_fd_sc_hd__dfxtp_1
X_5898_ u_pe_array.g_pe_row\[0\].g_pe_col\[2\].u_pe.act_val\[0\] u_pe_array.g_pe_row\[0\].g_pe_col\[2\].u_pe.w_reg\[0\]
+ u_pe_array.g_pe_row\[0\].g_pe_col\[2\].u_pe.psum_out\[0\] VGND VGND VPWR VPWR _2741_
+ sky130_fd_sc_hd__a21o_1
XFILLER_0_35_538 VGND VGND VPWR VPWR sky130_fd_sc_hd__decap_6
X_4849_ _1856_ _1857_ VGND VGND VPWR VPWR _1858_ sky130_fd_sc_hd__xnor2_1
XFILLER_0_74_195 VGND VGND VPWR VPWR sky130_fd_sc_hd__fill_1
XANTENNA__4503__B _1536_ VGND VGND VPWR VPWR sky130_fd_sc_hd__diode_2
X_7568_ clknet_leaf_27_clk _0617_ VGND VGND VPWR VPWR u_pe_array.u_fifo1.buffer\[0\]\[4\]
+ sky130_fd_sc_hd__dfxtp_1
XFILLER_0_62_379 VGND VGND VPWR VPWR sky130_fd_sc_hd__fill_1
XFILLER_0_15_251 VGND VGND VPWR VPWR sky130_fd_sc_hd__decap_3
X_7499_ clknet_leaf_5_clk _0548_ VGND VGND VPWR VPWR u_pe_array.u_fifo2.buffer\[4\]\[12\]
+ sky130_fd_sc_hd__dfxtp_1
X_6519_ net600 _1798_ _3224_ VGND VGND VPWR VPWR _3226_ sky130_fd_sc_hd__mux2_1
XFILLER_0_30_210 VGND VGND VPWR VPWR sky130_fd_sc_hd__fill_2
XANTENNA__6289__B2 _0875_ VGND VGND VPWR VPWR sky130_fd_sc_hd__diode_2
XFILLER_0_100_197 VGND VGND VPWR VPWR sky130_fd_sc_hd__fill_2
XANTENNA__5264__A2 _2158_ VGND VGND VPWR VPWR sky130_fd_sc_hd__diode_2
XANTENNA__6880__S _3412_ VGND VGND VPWR VPWR sky130_fd_sc_hd__diode_2
XFILLER_0_97_243 VGND VGND VPWR VPWR sky130_fd_sc_hd__fill_2
Xclkbuf_leaf_23_clk clknet_3_2__leaf_clk VGND VGND VPWR VPWR clknet_leaf_23_clk sky130_fd_sc_hd__clkbuf_16
XANTENNA__4775__A1 _1787_ VGND VGND VPWR VPWR sky130_fd_sc_hd__diode_2
XANTENNA__4775__B2 _0747_ VGND VGND VPWR VPWR sky130_fd_sc_hd__diode_2
XFILLER_0_38_365 VGND VGND VPWR VPWR sky130_fd_sc_hd__fill_2
XFILLER_0_108_253 VGND VGND VPWR VPWR sky130_fd_sc_hd__decap_3
XFILLER_0_26_549 VGND VGND VPWR VPWR sky130_fd_sc_hd__fill_2
XFILLER_0_110_15 VPWR VGND VPWR VGND sky130_ef_sc_hd__decap_12
XFILLER_0_53_368 VGND VGND VPWR VPWR sky130_fd_sc_hd__fill_2
XFILLER_0_34_560 VPWR VGND VPWR VGND sky130_ef_sc_hd__decap_12
XFILLER_0_80_187 VGND VGND VPWR VPWR sky130_fd_sc_hd__fill_2
XFILLER_0_61_390 VGND VGND VPWR VPWR sky130_fd_sc_hd__fill_2
XFILLER_0_1_605 VGND VGND VPWR VPWR sky130_fd_sc_hd__decap_8
XFILLER_0_21_221 VGND VGND VPWR VPWR sky130_fd_sc_hd__decap_3
XFILLER_0_34_582 VGND VGND VPWR VPWR sky130_fd_sc_hd__decap_6
XFILLER_0_0_126 VPWR VGND VPWR VGND sky130_ef_sc_hd__decap_12
XFILLER_0_21_254 VGND VGND VPWR VPWR sky130_fd_sc_hd__fill_1
XTAP_405 VGND VPWR sky130_fd_sc_hd__tapvpwrvgnd_1
XTAP_416 VGND VPWR sky130_fd_sc_hd__tapvpwrvgnd_1
XTAP_427 VGND VPWR sky130_fd_sc_hd__tapvpwrvgnd_1
XTAP_438 VGND VPWR sky130_fd_sc_hd__tapvpwrvgnd_1
XTAP_449 VGND VPWR sky130_fd_sc_hd__tapvpwrvgnd_1
XFILLER_0_88_210 VGND VGND VPWR VPWR sky130_fd_sc_hd__fill_2
XANTENNA__6452__A1 _1814_ VGND VGND VPWR VPWR sky130_fd_sc_hd__diode_2
XFILLER_0_44_32 VGND VGND VPWR VPWR sky130_fd_sc_hd__fill_2
XANTENNA__4463__B1 _1534_ VGND VGND VPWR VPWR sky130_fd_sc_hd__diode_2
X_6870_ net463 _3120_ _3412_ VGND VGND VPWR VPWR _3418_ sky130_fd_sc_hd__mux2_1
XANTENNA_clkbuf_leaf_62_clk_A clknet_3_4__leaf_clk VGND VGND VPWR VPWR sky130_fd_sc_hd__diode_2
XFILLER_0_48_129 VGND VGND VPWR VPWR sky130_fd_sc_hd__decap_3
X_5821_ u_pe_array.g_pe_row\[0\].g_pe_col\[3\].u_pe.psum_out\[7\] VGND VGND VPWR VPWR
+ _2684_ sky130_fd_sc_hd__inv_2
XANTENNA__4766__A1 _1787_ VGND VGND VPWR VPWR sky130_fd_sc_hd__diode_2
XFILLER_0_17_505 VGND VGND VPWR VPWR sky130_fd_sc_hd__fill_2
XFILLER_0_29_332 VGND VGND VPWR VPWR sky130_fd_sc_hd__fill_2
XFILLER_0_29_354 VGND VGND VPWR VPWR sky130_fd_sc_hd__fill_1
X_5752_ u_pe_array.g_pe_row\[0\].g_pe_col\[3\].u_pe.w_reg\[0\] u_pe_array.g_pe_row\[0\].g_pe_col\[3\].u_pe.act_val\[2\]
+ VGND VGND VPWR VPWR _2621_ sky130_fd_sc_hd__nand2_1
XANTENNA__4766__B2 _0747_ VGND VGND VPWR VPWR sky130_fd_sc_hd__diode_2
X_4703_ u_pe_array.g_pe_row\[2\].g_pe_col\[1\].u_pe.psum_out\[7\] VGND VGND VPWR VPWR
+ _1747_ sky130_fd_sc_hd__inv_2
Xclkbuf_leaf_14_clk clknet_3_3__leaf_clk VGND VGND VPWR VPWR clknet_leaf_14_clk sky130_fd_sc_hd__clkbuf_16
XFILLER_0_60_53 VPWR VGND VPWR VGND sky130_ef_sc_hd__decap_12
X_5683_ u_pe_array.g_pe_row\[1\].g_pe_col\[0\].u_pe.psum_out\[7\] u_pe_array.g_pe_row\[1\].g_pe_col\[0\].u_pe.psum_out\[8\]
+ _2478_ VGND VGND VPWR VPWR _2572_ sky130_fd_sc_hd__o21a_1
XANTENNA_clkbuf_leaf_77_clk_A clknet_3_4__leaf_clk VGND VGND VPWR VPWR sky130_fd_sc_hd__diode_2
X_7422_ clknet_leaf_30_clk _0471_ VGND VGND VPWR VPWR u_pe_array.u_fifo1.buffer\[8\]\[12\]
+ sky130_fd_sc_hd__dfxtp_1
X_4634_ u_pe_array.g_pe_row\[2\].g_pe_col\[1\].u_pe.psum_out\[2\] _1683_ VGND VGND
+ VPWR VPWR _1684_ sky130_fd_sc_hd__xnor2_1
XFILLER_0_71_165 VGND VGND VPWR VPWR sky130_fd_sc_hd__decap_3
XFILLER_0_4_421 VGND VGND VPWR VPWR sky130_fd_sc_hd__fill_2
XANTENNA__4518__A1 _1536_ VGND VGND VPWR VPWR sky130_fd_sc_hd__diode_2
XFILLER_0_71_198 VGND VGND VPWR VPWR sky130_fd_sc_hd__fill_2
X_7353_ clknet_leaf_64_clk _0408_ net818 VGND VGND VPWR VPWR u_pe_array.g_pe_row\[0\].g_pe_col\[2\].u_pe.psum_out\[7\]
+ sky130_fd_sc_hd__dfrtp_2
XFILLER_0_8_65 VGND VGND VPWR VPWR sky130_fd_sc_hd__fill_2
Xhold601 u_pe_array.g_pe_row\[2\].g_pe_col\[2\].u_pe.act_val\[2\] VGND VGND VPWR VPWR
+ net677 sky130_fd_sc_hd__dlygate4sd3_1
X_4565_ _1632_ _1634_ VGND VGND VPWR VPWR _1635_ sky130_fd_sc_hd__or2_1
XANTENNA__7277__RESET_B net814 VGND VGND VPWR VPWR sky130_fd_sc_hd__diode_2
Xhold612 u_pe_array.g_pe_row\[0\].g_pe_col\[2\].u_pe.act_val\[5\] VGND VGND VPWR VPWR
+ net688 sky130_fd_sc_hd__dlygate4sd3_1
XANTENNA__6030__S _0745_ VGND VGND VPWR VPWR sky130_fd_sc_hd__diode_2
X_6304_ _3086_ _3090_ VGND VGND VPWR VPWR _3092_ sky130_fd_sc_hd__nand2_1
Xhold634 u_pe_array.g_pe_row\[3\].g_pe_col\[0\].u_pe.act_val\[4\] VGND VGND VPWR VPWR
+ net710 sky130_fd_sc_hd__dlygate4sd3_1
X_3516_ u_pe_array.g_pe_row\[1\].g_pe_col\[0\].u_pe.psum_out\[6\] _0769_ _0771_ _0754_
+ VGND VGND VPWR VPWR net45 sky130_fd_sc_hd__o211a_2
XANTENNA__7206__RESET_B net815 VGND VGND VPWR VPWR sky130_fd_sc_hd__diode_2
Xhold623 u_pe_array.g_pe_row\[3\].g_pe_col\[3\].u_pe.act_val\[0\] VGND VGND VPWR VPWR
+ net699 sky130_fd_sc_hd__dlygate4sd3_1
Xhold645 u_pe_array.g_pe_row\[0\].g_pe_col\[3\].u_pe.psum_out\[5\] VGND VGND VPWR
+ VPWR net721 sky130_fd_sc_hd__dlygate4sd3_1
X_7284_ clknet_leaf_42_clk net98 net75 VGND VGND VPWR VPWR u_pe_array.g_pe_row\[1\].g_pe_col\[0\].u_pe.w_reg\[0\]
+ sky130_fd_sc_hd__dfrtp_4
Xhold667 u_pe_array.g_pe_row\[3\].g_pe_col\[0\].u_pe.psum_out\[4\] VGND VGND VPWR
+ VPWR net743 sky130_fd_sc_hd__dlygate4sd3_1
Xhold656 u_pe_array.g_pe_row\[2\].g_pe_col\[1\].u_pe.psum_out\[5\] VGND VGND VPWR
+ VPWR net732 sky130_fd_sc_hd__dlygate4sd3_1
Xhold678 u_pe_array.g_pe_row\[0\].g_pe_col\[2\].u_pe.psum_out\[5\] VGND VGND VPWR
+ VPWR net754 sky130_fd_sc_hd__dlygate4sd3_1
XFILLER_0_12_276 VGND VGND VPWR VPWR sky130_fd_sc_hd__decap_3
X_4496_ u_pe_array.g_pe_row\[2\].g_pe_col\[2\].u_pe.psum_out\[3\] _1555_ _1556_ VGND
+ VGND VPWR VPWR _1572_ sky130_fd_sc_hd__a21o_1
X_6235_ u_pe_array.g_pe_row\[0\].g_pe_col\[0\].u_pe.act_val\[3\] u_pe_array.g_pe_row\[0\].g_pe_col\[0\].u_pe.w_reg\[0\]
+ _3016_ _3015_ VGND VGND VPWR VPWR _3029_ sky130_fd_sc_hd__a31o_1
X_3447_ _0722_ VGND VGND VPWR VPWR u_fsm.psum_shift_en sky130_fd_sc_hd__clkbuf_4
Xhold689 u_pe_array.g_pe_row\[2\].g_pe_col\[2\].u_pe.act_val\[3\] VGND VGND VPWR VPWR
+ net765 sky130_fd_sc_hd__dlygate4sd3_1
XFILLER_0_0_671 VGND VGND VPWR VPWR sky130_fd_sc_hd__fill_1
XFILLER_0_110_495 VPWR VGND VPWR VGND sky130_ef_sc_hd__decap_12
X_6166_ _2873_ u_pe_array.g_pe_row\[0\].g_pe_col\[1\].u_pe.psum_out\[9\] _2970_ VGND
+ VGND VPWR VPWR _2971_ sky130_fd_sc_hd__and3_1
XANTENNA_clkbuf_leaf_15_clk_A clknet_3_3__leaf_clk VGND VGND VPWR VPWR sky130_fd_sc_hd__diode_2
XTAP_961 VGND VPWR sky130_fd_sc_hd__tapvpwrvgnd_1
XTAP_950 VGND VPWR sky130_fd_sc_hd__tapvpwrvgnd_1
X_6097_ _2905_ _2906_ u_pe_array.g_pe_row\[0\].g_pe_col\[1\].u_pe.psum_out\[4\] VGND
+ VGND VPWR VPWR _2908_ sky130_fd_sc_hd__a21o_1
XFILLER_0_99_508 VGND VGND VPWR VPWR sky130_fd_sc_hd__fill_2
XTAP_994 VGND VPWR sky130_fd_sc_hd__tapvpwrvgnd_1
XTAP_983 VGND VPWR sky130_fd_sc_hd__tapvpwrvgnd_1
XTAP_972 VGND VPWR sky130_fd_sc_hd__tapvpwrvgnd_1
X_5117_ net760 _1714_ _2091_ _2093_ VGND VGND VPWR VPWR _0267_ sky130_fd_sc_hd__a22o_1
X_5048_ u_pe_array.g_pe_row\[1\].g_pe_col\[3\].u_pe.act_val\[0\] _2029_ u_pe_array.g_pe_row\[1\].g_pe_col\[3\].u_pe.psum_out\[1\]
+ VGND VGND VPWR VPWR _2030_ sky130_fd_sc_hd__a21oi_1
XFILLER_0_39_107 VGND VGND VPWR VPWR sky130_fd_sc_hd__decap_4
XFILLER_0_67_449 VGND VGND VPWR VPWR sky130_fd_sc_hd__fill_1
XFILLER_0_67_438 VGND VGND VPWR VPWR sky130_fd_sc_hd__fill_2
XFILLER_0_39_129 VPWR VGND VPWR VGND sky130_ef_sc_hd__decap_12
X_6999_ clknet_leaf_36_clk _0078_ net76 VGND VGND VPWR VPWR u_pe_array.g_pe_row\[3\].g_pe_col\[0\].u_pe.move_reg\[11\]
+ sky130_fd_sc_hd__dfrtp_1
XFILLER_0_48_641 VGND VGND VPWR VPWR sky130_fd_sc_hd__decap_3
XFILLER_0_75_471 VGND VGND VPWR VPWR sky130_fd_sc_hd__fill_1
XFILLER_0_90_441 VGND VGND VPWR VPWR sky130_fd_sc_hd__fill_2
XFILLER_0_62_121 VGND VGND VPWR VPWR sky130_fd_sc_hd__fill_1
XFILLER_0_35_335 VGND VGND VPWR VPWR sky130_fd_sc_hd__fill_1
XANTENNA__5706__A0 net34 VGND VGND VPWR VPWR sky130_fd_sc_hd__diode_2
XFILLER_0_101_440 VGND VGND VPWR VPWR sky130_fd_sc_hd__fill_2
XFILLER_0_31_585 VGND VGND VPWR VPWR sky130_fd_sc_hd__decap_8
XFILLER_0_101_473 VGND VGND VPWR VPWR sky130_fd_sc_hd__decap_3
XANTENNA_input31_A w_in_flat[4] VGND VGND VPWR VPWR sky130_fd_sc_hd__diode_2
XANTENNA__6929__RESET_B net819 VGND VGND VPWR VPWR sky130_fd_sc_hd__diode_2
XANTENNA__5237__A2 _1714_ VGND VGND VPWR VPWR sky130_fd_sc_hd__diode_2
XFILLER_0_98_530 VGND VGND VPWR VPWR sky130_fd_sc_hd__fill_2
XFILLER_0_105_15 VPWR VGND VPWR VGND sky130_ef_sc_hd__decap_12
XANTENNA__3799__A2 _0996_ VGND VGND VPWR VPWR sky130_fd_sc_hd__diode_2
XFILLER_0_109_540 VPWR VGND VPWR VGND sky130_ef_sc_hd__decap_12
XFILLER_0_109_573 VPWR VGND VPWR VGND sky130_ef_sc_hd__decap_12
XANTENNA__7370__RESET_B net812 VGND VGND VPWR VPWR sky130_fd_sc_hd__diode_2
XFILLER_0_30_67 VGND VGND VPWR VPWR sky130_fd_sc_hd__decap_6
XFILLER_0_41_349 VGND VGND VPWR VPWR sky130_fd_sc_hd__decap_3
X_4350_ _1438_ _1439_ _1452_ VGND VGND VPWR VPWR _1453_ sky130_fd_sc_hd__o21a_1
XFILLER_0_22_552 VGND VGND VPWR VPWR sky130_fd_sc_hd__fill_2
XFILLER_0_22_585 VGND VGND VPWR VPWR sky130_fd_sc_hd__decap_3
XANTENNA__6785__S _3366_ VGND VGND VPWR VPWR sky130_fd_sc_hd__diode_2
X_4281_ net771 _1392_ _1258_ _1396_ VGND VGND VPWR VPWR _0128_ sky130_fd_sc_hd__a22o_1
XANTENNA__5476__A2 _2387_ VGND VGND VPWR VPWR sky130_fd_sc_hd__diode_2
X_6020_ _2837_ _2841_ _2848_ _2850_ _2847_ VGND VGND VPWR VPWR _2851_ sky130_fd_sc_hd__a32o_1
XTAP_257 VGND VPWR sky130_fd_sc_hd__tapvpwrvgnd_1
XTAP_235 VGND VPWR sky130_fd_sc_hd__tapvpwrvgnd_1
XTAP_246 VGND VPWR sky130_fd_sc_hd__tapvpwrvgnd_1
Xclkbuf_leaf_3_clk clknet_3_0__leaf_clk VGND VGND VPWR VPWR clknet_leaf_3_clk sky130_fd_sc_hd__clkbuf_16
XTAP_268 VGND VPWR sky130_fd_sc_hd__tapvpwrvgnd_1
XTAP_279 VGND VPWR sky130_fd_sc_hd__tapvpwrvgnd_1
XANTENNA__3503__A _0762_ VGND VGND VPWR VPWR sky130_fd_sc_hd__diode_2
XANTENNA__6425__A1 _1814_ VGND VGND VPWR VPWR sky130_fd_sc_hd__diode_2
X_6922_ clknet_leaf_61_clk _0008_ net73 VGND VGND VPWR VPWR u_fsm.v_cnt\[2\] sky130_fd_sc_hd__dfrtp_1
X_6853_ _3408_ VGND VGND VPWR VPWR _0688_ sky130_fd_sc_hd__clkbuf_1
XFILLER_0_49_449 VGND VGND VPWR VPWR sky130_fd_sc_hd__fill_2
XFILLER_0_49_438 VGND VGND VPWR VPWR sky130_fd_sc_hd__fill_2
X_5804_ _2664_ _2668_ VGND VGND VPWR VPWR _2669_ sky130_fd_sc_hd__and2b_1
X_6784_ _3371_ VGND VGND VPWR VPWR _0656_ sky130_fd_sc_hd__clkbuf_1
X_3996_ _1157_ u_pe_array.g_pe_row\[3\].g_pe_col\[1\].u_pe.psum_out\[1\] _1145_ VGND
+ VGND VPWR VPWR _1158_ sky130_fd_sc_hd__o21a_1
XANTENNA__5400__A2 _2144_ VGND VGND VPWR VPWR sky130_fd_sc_hd__diode_2
XFILLER_0_57_460 VGND VGND VPWR VPWR sky130_fd_sc_hd__decap_8
XANTENNA__4334__A _1407_ VGND VGND VPWR VPWR sky130_fd_sc_hd__diode_2
XFILLER_0_91_249 VGND VGND VPWR VPWR sky130_fd_sc_hd__decap_4
X_5735_ net152 _2600_ _2606_ _0722_ VGND VGND VPWR VPWR _0372_ sky130_fd_sc_hd__a22o_1
XFILLER_0_95_3 VPWR VGND VPWR VGND sky130_ef_sc_hd__decap_12
XANTENNA__3962__A2 _0996_ VGND VGND VPWR VPWR sky130_fd_sc_hd__diode_2
X_5666_ u_pe_array.g_pe_row\[1\].g_pe_col\[0\].u_pe.psum_out\[8\] _2478_ VGND VGND
+ VPWR VPWR _2557_ sky130_fd_sc_hd__nand2_1
XFILLER_0_45_666 VGND VGND VPWR VPWR sky130_fd_sc_hd__fill_2
X_7405_ clknet_leaf_44_clk _0455_ net817 VGND VGND VPWR VPWR u_pe_array.g_pe_row\[0\].g_pe_col\[0\].u_pe.psum_out\[9\]
+ sky130_fd_sc_hd__dfrtp_1
X_4617_ u_pe_array.g_pe_row\[2\].g_pe_col\[1\].u_pe.w_reg\[0\] u_pe_array.g_pe_row\[2\].g_pe_col\[1\].u_pe.act_val\[0\]
+ u_pe_array.g_pe_row\[2\].g_pe_col\[1\].u_pe.psum_out\[0\] VGND VGND VPWR VPWR _1669_
+ sky130_fd_sc_hd__and3_1
XANTENNA__3892__B _1009_ VGND VGND VPWR VPWR sky130_fd_sc_hd__diode_2
XANTENNA__6361__B1 net52 VGND VGND VPWR VPWR sky130_fd_sc_hd__diode_2
X_5597_ net617 _2387_ _2174_ _2493_ VGND VGND VPWR VPWR _0347_ sky130_fd_sc_hd__a22o_1
Xhold420 u_pe_array.u_fifo2.buffer\[3\]\[5\] VGND VGND VPWR VPWR net496 sky130_fd_sc_hd__dlygate4sd3_1
XANTENNA__7040__RESET_B net817 VGND VGND VPWR VPWR sky130_fd_sc_hd__diode_2
X_7336_ clknet_leaf_48_clk _0393_ net812 VGND VGND VPWR VPWR u_pe_array.g_pe_row\[0\].g_pe_col\[1\].u_pe.act_val\[5\]
+ sky130_fd_sc_hd__dfrtp_1
Xhold453 u_pe_array.u_fifo1.buffer\[4\]\[5\] VGND VGND VPWR VPWR net529 sky130_fd_sc_hd__dlygate4sd3_1
Xhold442 u_pe_array.u_fifo1.buffer\[3\]\[5\] VGND VGND VPWR VPWR net518 sky130_fd_sc_hd__dlygate4sd3_1
Xhold431 u_pe_array.g_pe_row\[0\].g_pe_col\[2\].u_pe.psum_out\[11\] VGND VGND VPWR
+ VPWR net507 sky130_fd_sc_hd__dlygate4sd3_1
X_4548_ _1617_ _1619_ net829 _0916_ VGND VGND VPWR VPWR _0172_ sky130_fd_sc_hd__a2bb2o_1
Xhold486 u_pe_array.u_fifo1.buffer\[7\]\[4\] VGND VGND VPWR VPWR net562 sky130_fd_sc_hd__dlygate4sd3_1
Xhold475 u_pe_array.u_fifo1.buffer\[8\]\[5\] VGND VGND VPWR VPWR net551 sky130_fd_sc_hd__dlygate4sd3_1
X_7267_ clknet_leaf_51_clk _0328_ net812 VGND VGND VPWR VPWR u_pe_array.g_pe_row\[1\].g_pe_col\[1\].u_pe.psum_out\[11\]
+ sky130_fd_sc_hd__dfrtp_1
X_4479_ u_pe_array.g_pe_row\[2\].g_pe_col\[2\].u_pe.act_val\[2\] u_pe_array.g_pe_row\[2\].g_pe_col\[2\].u_pe.act_val\[3\]
+ u_pe_array.g_pe_row\[2\].g_pe_col\[2\].u_pe.w_reg\[0\] _1536_ VGND VGND VPWR VPWR
+ _1556_ sky130_fd_sc_hd__and4b_1
Xhold464 u_pe_array.u_fifo2.buffer\[5\]\[4\] VGND VGND VPWR VPWR net540 sky130_fd_sc_hd__dlygate4sd3_1
XFILLER_0_110_292 VPWR VGND VPWR VGND sky130_ef_sc_hd__decap_12
X_6218_ u_pe_array.g_pe_row\[0\].g_pe_col\[0\].u_pe.act_val\[2\] VGND VGND VPWR VPWR
+ _3013_ sky130_fd_sc_hd__inv_2
XFILLER_0_96_82 VGND VGND VPWR VPWR sky130_fd_sc_hd__fill_2
Xhold497 u_pe_array.u_fifo2.buffer\[8\]\[4\] VGND VGND VPWR VPWR net573 sky130_fd_sc_hd__dlygate4sd3_1
X_7198_ clknet_leaf_74_clk _0263_ net814 VGND VGND VPWR VPWR u_pe_array.g_pe_row\[1\].g_pe_col\[3\].u_pe.psum_out\[2\]
+ sky130_fd_sc_hd__dfrtp_2
X_6149_ net71 _2955_ VGND VGND VPWR VPWR _2956_ sky130_fd_sc_hd__or2_1
XTAP_791 VGND VPWR sky130_fd_sc_hd__tapvpwrvgnd_1
XTAP_780 VGND VPWR sky130_fd_sc_hd__tapvpwrvgnd_1
XANTENNA__4427__B1 _1258_ VGND VGND VPWR VPWR sky130_fd_sc_hd__diode_2
XFILLER_0_55_408 VGND VGND VPWR VPWR sky130_fd_sc_hd__fill_1
XANTENNA__4244__A _1275_ VGND VGND VPWR VPWR sky130_fd_sc_hd__diode_2
XANTENNA__7199__RESET_B net815 VGND VGND VPWR VPWR sky130_fd_sc_hd__diode_2
XANTENNA__3953__A2 _0996_ VGND VGND VPWR VPWR sky130_fd_sc_hd__diode_2
XANTENNA__7128__RESET_B net76 VGND VGND VPWR VPWR sky130_fd_sc_hd__diode_2
XFILLER_0_51_625 VGND VGND VPWR VPWR sky130_fd_sc_hd__fill_2
XANTENNA__6352__B1 net61 VGND VGND VPWR VPWR sky130_fd_sc_hd__diode_2
XANTENNA__5506__C _2345_ VGND VGND VPWR VPWR sky130_fd_sc_hd__diode_2
XFILLER_0_101_292 VPWR VGND VPWR VGND sky130_ef_sc_hd__decap_12
XFILLER_0_25_45 VGND VGND VPWR VPWR sky130_fd_sc_hd__fill_1
X_3850_ _1035_ _1037_ _1026_ VGND VGND VPWR VPWR _1039_ sky130_fd_sc_hd__o21ai_1
XANTENNA__5918__B1 _2174_ VGND VGND VPWR VPWR sky130_fd_sc_hd__diode_2
X_3781_ u_pe_array.g_pe_row\[3\].g_pe_col\[2\].u_pe.psum_out\[0\] u_pe_array.g_pe_row\[3\].g_pe_col\[2\].u_pe.act_val\[0\]
+ _0745_ VGND VGND VPWR VPWR _0986_ sky130_fd_sc_hd__mux2_2
XFILLER_0_27_644 VGND VGND VPWR VPWR sky130_fd_sc_hd__fill_1
XANTENNA__7551__RESET_B net74 VGND VGND VPWR VPWR sky130_fd_sc_hd__diode_2
XFILLER_0_41_33 VGND VGND VPWR VPWR sky130_fd_sc_hd__decap_4
X_5520_ _2436_ VGND VGND VPWR VPWR _2437_ sky130_fd_sc_hd__inv_2
XFILLER_0_42_614 VGND VGND VPWR VPWR sky130_fd_sc_hd__fill_2
XFILLER_0_41_113 VGND VGND VPWR VPWR sky130_fd_sc_hd__fill_1
XFILLER_0_112_513 VPWR VGND VPWR VGND sky130_ef_sc_hd__decap_12
XANTENNA__6343__B1 net58 VGND VGND VPWR VPWR sky130_fd_sc_hd__diode_2
X_5451_ net633 _1714_ _2174_ _2374_ VGND VGND VPWR VPWR _0320_ sky130_fd_sc_hd__a22o_1
XFILLER_0_42_669 VGND VGND VPWR VPWR sky130_fd_sc_hd__fill_2
XFILLER_0_112_557 VPWR VGND VPWR VGND sky130_ef_sc_hd__decap_12
X_5382_ u_pe_array.u_fifo1.buffer\[4\]\[4\] _2279_ _2280_ u_pe_array.u_fifo1.buffer\[7\]\[4\]
+ VGND VGND VPWR VPWR _2318_ sky130_fd_sc_hd__a22o_1
X_4402_ _1489_ _1497_ _1498_ VGND VGND VPWR VPWR _1500_ sky130_fd_sc_hd__and3_1
X_7121_ clknet_leaf_35_clk net85 net816 VGND VGND VPWR VPWR u_pe_array.g_pe_row\[2\].g_pe_col\[1\].u_pe.w_reg\[0\]
+ sky130_fd_sc_hd__dfrtp_4
XFILLER_0_10_533 VPWR VGND VPWR VGND sky130_ef_sc_hd__decap_12
X_4333_ _1407_ _1436_ u_pe_array.g_pe_row\[2\].g_pe_col\[3\].u_pe.psum_out\[4\] VGND
+ VGND VPWR VPWR _1437_ sky130_fd_sc_hd__a21oi_1
X_4264_ net570 _1152_ _0887_ _1387_ VGND VGND VPWR VPWR _0120_ sky130_fd_sc_hd__a22o_1
X_7052_ clknet_leaf_91_clk _0127_ net819 VGND VGND VPWR VPWR u_pe_array.g_pe_row\[2\].g_pe_col\[2\].u_pe.act_val\[4\]
+ sky130_fd_sc_hd__dfrtp_1
XFILLER_0_66_41 VPWR VGND VPWR VGND sky130_ef_sc_hd__decap_12
X_6003_ u_pe_array.g_pe_row\[0\].g_pe_col\[2\].u_pe.psum_out\[7\] u_pe_array.g_pe_row\[0\].g_pe_col\[2\].u_pe.psum_out\[8\]
+ _2743_ VGND VGND VPWR VPWR _2836_ sky130_fd_sc_hd__o21a_1
XFILLER_0_5_55 VGND VGND VPWR VPWR sky130_fd_sc_hd__fill_1
X_4195_ _1312_ _1315_ _1324_ _0885_ VGND VGND VPWR VPWR _1326_ sky130_fd_sc_hd__o31a_1
XFILLER_0_66_85 VGND VGND VPWR VPWR sky130_fd_sc_hd__decap_8
XANTENNA__4121__A2 _1138_ VGND VGND VPWR VPWR sky130_fd_sc_hd__diode_2
X_6905_ _3436_ VGND VGND VPWR VPWR _0712_ sky130_fd_sc_hd__clkbuf_1
XTAP_1209 VGND VPWR sky130_fd_sc_hd__tapvpwrvgnd_1
XFILLER_0_49_235 VGND VGND VPWR VPWR sky130_fd_sc_hd__fill_2
XANTENNA__3632__B2 u_fsm.psum_shift_en VGND VGND VPWR VPWR sky130_fd_sc_hd__diode_2
X_6836_ net516 _3114_ _3397_ VGND VGND VPWR VPWR _3400_ sky130_fd_sc_hd__mux2_1
X_6767_ _3362_ VGND VGND VPWR VPWR _0648_ sky130_fd_sc_hd__clkbuf_1
XFILLER_0_92_569 VGND VGND VPWR VPWR sky130_fd_sc_hd__fill_2
XANTENNA__7292__RESET_B net75 VGND VGND VPWR VPWR sky130_fd_sc_hd__diode_2
X_3979_ u_pe_array.g_pe_row\[3\].g_pe_col\[1\].u_pe.w_reg\[0\] u_pe_array.g_pe_row\[3\].g_pe_col\[1\].u_pe.act_val\[0\]
+ u_pe_array.g_pe_row\[3\].g_pe_col\[1\].u_pe.psum_out\[0\] VGND VGND VPWR VPWR _1143_
+ sky130_fd_sc_hd__nand3_1
XANTENNA__7221__RESET_B net812 VGND VGND VPWR VPWR sky130_fd_sc_hd__diode_2
X_5718_ net753 _2463_ _2592_ _2597_ VGND VGND VPWR VPWR _0364_ sky130_fd_sc_hd__a22o_1
XANTENNA__3935__A2 _0875_ VGND VGND VPWR VPWR sky130_fd_sc_hd__diode_2
X_6698_ net414 _3114_ _3324_ VGND VGND VPWR VPWR _3327_ sky130_fd_sc_hd__mux2_1
XFILLER_0_17_176 VGND VGND VPWR VPWR sky130_fd_sc_hd__fill_2
XFILLER_0_17_187 VGND VGND VPWR VPWR sky130_fd_sc_hd__fill_2
XANTENNA__6334__B1 net55 VGND VGND VPWR VPWR sky130_fd_sc_hd__diode_2
X_5649_ net569 _2387_ _2174_ _2541_ VGND VGND VPWR VPWR _0351_ sky130_fd_sc_hd__a22o_1
XANTENNA__5137__B2 _0916_ VGND VGND VPWR VPWR sky130_fd_sc_hd__diode_2
XFILLER_0_33_669 VGND VGND VPWR VPWR sky130_fd_sc_hd__decap_3
XFILLER_0_103_557 VGND VGND VPWR VPWR sky130_fd_sc_hd__decap_3
XFILLER_0_60_477 VGND VGND VPWR VPWR sky130_fd_sc_hd__fill_2
Xhold250 u_pe_array.u_fifo1.buffer\[8\]\[12\] VGND VGND VPWR VPWR net326 sky130_fd_sc_hd__dlygate4sd3_1
Xhold261 u_pe_array.g_pe_row\[2\].g_pe_col\[3\].u_pe.psum_out\[4\] VGND VGND VPWR
+ VPWR net337 sky130_fd_sc_hd__dlygate4sd3_1
XFILLER_0_13_393 VGND VGND VPWR VPWR sky130_fd_sc_hd__fill_2
X_7319_ clknet_leaf_63_clk _0376_ net814 VGND VGND VPWR VPWR u_pe_array.g_pe_row\[0\].g_pe_col\[3\].u_pe.psum_out\[3\]
+ sky130_fd_sc_hd__dfrtp_1
Xhold294 u_pe_array.g_pe_row\[1\].g_pe_col\[2\].u_pe.psum_out\[0\] VGND VGND VPWR
+ VPWR net370 sky130_fd_sc_hd__dlygate4sd3_1
XANTENNA__6637__A1 net12 VGND VGND VPWR VPWR sky130_fd_sc_hd__diode_2
Xhold272 u_pe_array.u_fifo2.buffer\[3\]\[9\] VGND VGND VPWR VPWR net348 sky130_fd_sc_hd__dlygate4sd3_1
Xhold283 u_pe_array.u_fifo2.buffer\[1\]\[11\] VGND VGND VPWR VPWR net359 sky130_fd_sc_hd__dlygate4sd3_1
XFILLER_0_99_113 VGND VGND VPWR VPWR sky130_fd_sc_hd__fill_2
XFILLER_0_68_511 VGND VGND VPWR VPWR sky130_fd_sc_hd__fill_1
XFILLER_0_68_555 VGND VGND VPWR VPWR sky130_fd_sc_hd__fill_1
XANTENNA__7309__RESET_B net814 VGND VGND VPWR VPWR sky130_fd_sc_hd__diode_2
XFILLER_0_95_396 VGND VGND VPWR VPWR sky130_fd_sc_hd__fill_2
XFILLER_0_83_547 VGND VGND VPWR VPWR sky130_fd_sc_hd__fill_1
XFILLER_0_48_290 VGND VGND VPWR VPWR sky130_fd_sc_hd__fill_2
XFILLER_0_102_27 VGND VGND VPWR VPWR sky130_fd_sc_hd__fill_1
XFILLER_0_11_36 VGND VGND VPWR VPWR sky130_fd_sc_hd__fill_2
XFILLER_0_23_113 VGND VGND VPWR VPWR sky130_fd_sc_hd__fill_1
XANTENNA__5009__S _0756_ VGND VGND VPWR VPWR sky130_fd_sc_hd__diode_2
XANTENNA__6876__A1 _3126_ VGND VGND VPWR VPWR sky130_fd_sc_hd__diode_2
XANTENNA__6944__RESET_B net815 VGND VGND VPWR VPWR sky130_fd_sc_hd__diode_2
XANTENNA__6628__B2 _3283_ VGND VGND VPWR VPWR sky130_fd_sc_hd__diode_2
XFILLER_0_36_11 VGND VGND VPWR VPWR sky130_fd_sc_hd__decap_6
Xinput7 h_in1[0] VGND VGND VPWR VPWR net7 sky130_fd_sc_hd__buf_1
XANTENNA__6364__A _0788_ VGND VGND VPWR VPWR sky130_fd_sc_hd__diode_2
XANTENNA__5064__B1 _0887_ VGND VGND VPWR VPWR sky130_fd_sc_hd__diode_2
X_4951_ _1942_ _1944_ _1949_ VGND VGND VPWR VPWR _1951_ sky130_fd_sc_hd__or3_1
XFILLER_0_86_330 VGND VGND VPWR VPWR sky130_fd_sc_hd__fill_2
XFILLER_0_59_533 VGND VGND VPWR VPWR sky130_fd_sc_hd__fill_2
XANTENNA__4811__B1 _1655_ VGND VGND VPWR VPWR sky130_fd_sc_hd__diode_2
X_4882_ _1887_ _1888_ net713 _0916_ VGND VGND VPWR VPWR _0237_ sky130_fd_sc_hd__a2bb2o_1
XFILLER_0_86_374 VGND VGND VPWR VPWR sky130_fd_sc_hd__fill_1
X_3902_ _1058_ _1070_ _1080_ _1085_ VGND VGND VPWR VPWR _1086_ sky130_fd_sc_hd__or4_1
XFILLER_0_19_408 VGND VGND VPWR VPWR sky130_fd_sc_hd__fill_2
XFILLER_0_52_76 VGND VGND VPWR VPWR sky130_fd_sc_hd__decap_3
X_6621_ net350 _1816_ _3269_ VGND VGND VPWR VPWR _3280_ sky130_fd_sc_hd__mux2_1
X_3833_ _1012_ _1015_ VGND VGND VPWR VPWR _1023_ sky130_fd_sc_hd__and2_1
XFILLER_0_6_313 VGND VGND VPWR VPWR sky130_fd_sc_hd__fill_1
XFILLER_0_54_282 VGND VGND VPWR VPWR sky130_fd_sc_hd__decap_3
X_3764_ _0972_ _0973_ net783 _0916_ VGND VGND VPWR VPWR _0034_ sky130_fd_sc_hd__a2bb2o_1
X_6552_ _3243_ VGND VGND VPWR VPWR _0552_ sky130_fd_sc_hd__clkbuf_1
X_5503_ _2345_ u_pe_array.g_pe_row\[1\].g_pe_col\[1\].u_pe.psum_out\[8\] VGND VGND
+ VPWR VPWR _2422_ sky130_fd_sc_hd__nand2_1
XFILLER_0_54_293 VGND VGND VPWR VPWR sky130_fd_sc_hd__fill_2
X_3695_ _0909_ _0910_ VGND VGND VPWR VPWR _0911_ sky130_fd_sc_hd__or2_1
XFILLER_0_15_669 VGND VGND VPWR VPWR sky130_fd_sc_hd__fill_1
X_6483_ net341 _1818_ net67 VGND VGND VPWR VPWR _3206_ sky130_fd_sc_hd__mux2_1
XFILLER_0_112_321 VPWR VGND VPWR VGND sky130_ef_sc_hd__decap_12
X_5434_ _2352_ _2358_ VGND VGND VPWR VPWR _2359_ sky130_fd_sc_hd__nand2_1
XFILLER_0_42_477 VGND VGND VPWR VPWR sky130_fd_sc_hd__fill_2
XFILLER_0_112_365 VPWR VGND VPWR VGND sky130_ef_sc_hd__decap_12
XANTENNA__4758__S _1796_ VGND VGND VPWR VPWR sky130_fd_sc_hd__diode_2
X_5365_ u_pe_array.u_fifo1.buffer\[5\]\[2\] _2284_ _2285_ u_pe_array.u_fifo1.buffer\[6\]\[2\]
+ _2286_ VGND VGND VPWR VPWR _2303_ sky130_fd_sc_hd__a221o_1
XFILLER_0_58_3 VPWR VGND VPWR VGND sky130_ef_sc_hd__decap_12
XANTENNA__6619__A1 _1814_ VGND VGND VPWR VPWR sky130_fd_sc_hd__diode_2
X_7104_ clknet_leaf_85_clk _0175_ net74 VGND VGND VPWR VPWR u_pe_array.g_pe_row\[2\].g_pe_col\[2\].u_pe.psum_out\[11\]
+ sky130_fd_sc_hd__dfrtp_1
X_5296_ _0914_ _2240_ _2241_ _0861_ _2242_ VGND VGND VPWR VPWR _0297_ sky130_fd_sc_hd__o32ai_1
X_4316_ _1420_ _1421_ VGND VGND VPWR VPWR _1422_ sky130_fd_sc_hd__xor2_1
X_4247_ _1275_ u_pe_array.g_pe_row\[3\].g_pe_col\[0\].u_pe.psum_out\[9\] _1372_ VGND
+ VGND VPWR VPWR _1373_ sky130_fd_sc_hd__and3_1
X_7035_ clknet_leaf_16_clk _0110_ net816 VGND VGND VPWR VPWR u_pe_array.g_pe_row\[3\].g_pe_col\[0\].u_pe.psum_out\[2\]
+ sky130_fd_sc_hd__dfrtp_1
X_4178_ _1307_ _1308_ u_pe_array.g_pe_row\[3\].g_pe_col\[0\].u_pe.psum_out\[4\] VGND
+ VGND VPWR VPWR _1310_ sky130_fd_sc_hd__a21o_1
XFILLER_0_97_617 VGND VGND VPWR VPWR sky130_fd_sc_hd__decap_3
XFILLER_0_96_149 VGND VGND VPWR VPWR sky130_fd_sc_hd__fill_1
XTAP_1028 VGND VPWR sky130_fd_sc_hd__tapvpwrvgnd_1
XTAP_1017 VGND VPWR sky130_fd_sc_hd__tapvpwrvgnd_1
XTAP_1006 VGND VPWR sky130_fd_sc_hd__tapvpwrvgnd_1
XANTENNA__4802__B1 _1655_ VGND VGND VPWR VPWR sky130_fd_sc_hd__diode_2
XANTENNA__7402__RESET_B net817 VGND VGND VPWR VPWR sky130_fd_sc_hd__diode_2
XTAP_1039 VGND VPWR sky130_fd_sc_hd__tapvpwrvgnd_1
XFILLER_0_65_525 VGND VGND VPWR VPWR sky130_fd_sc_hd__decap_6
X_6819_ _3390_ VGND VGND VPWR VPWR _0672_ sky130_fd_sc_hd__clkbuf_1
XFILLER_0_52_208 VGND VGND VPWR VPWR sky130_fd_sc_hd__fill_1
XFILLER_0_9_173 VPWR VGND VPWR VGND sky130_ef_sc_hd__decap_12
XFILLER_0_18_441 VGND VGND VPWR VPWR sky130_fd_sc_hd__decap_3
XFILLER_0_80_539 VGND VGND VPWR VPWR sky130_fd_sc_hd__decap_3
XFILLER_0_80_528 VGND VGND VPWR VPWR sky130_fd_sc_hd__fill_2
XFILLER_0_9_195 VPWR VGND VPWR VGND sky130_ef_sc_hd__decap_12
XFILLER_0_33_433 VGND VGND VPWR VPWR sky130_fd_sc_hd__fill_2
XANTENNA__4581__A2 _1152_ VGND VGND VPWR VPWR sky130_fd_sc_hd__diode_2
XFILLER_0_21_606 VGND VGND VPWR VPWR sky130_fd_sc_hd__fill_2
XFILLER_0_103_365 VGND VGND VPWR VPWR sky130_fd_sc_hd__fill_1
XANTENNA__4869__B1 _0887_ VGND VGND VPWR VPWR sky130_fd_sc_hd__diode_2
XANTENNA__4895__C _1847_ VGND VGND VPWR VPWR sky130_fd_sc_hd__diode_2
XFILLER_0_13_190 VGND VGND VPWR VPWR sky130_fd_sc_hd__fill_1
XANTENNA__4097__A1 _0864_ VGND VGND VPWR VPWR sky130_fd_sc_hd__diode_2
XFILLER_0_88_639 VGND VGND VPWR VPWR sky130_fd_sc_hd__fill_2
XANTENNA__5046__B1 _1534_ VGND VGND VPWR VPWR sky130_fd_sc_hd__diode_2
XANTENNA__3601__A _0833_ VGND VGND VPWR VPWR sky130_fd_sc_hd__diode_2
XFILLER_0_96_650 VGND VGND VPWR VPWR sky130_fd_sc_hd__fill_2
XTAP_1551 VGND VPWR sky130_fd_sc_hd__tapvpwrvgnd_1
XTAP_1540 VGND VPWR sky130_fd_sc_hd__tapvpwrvgnd_1
XFILLER_0_68_363 VGND VGND VPWR VPWR sky130_fd_sc_hd__fill_1
XFILLER_0_113_15 VPWR VGND VPWR VGND sky130_ef_sc_hd__decap_12
XTAP_1584 VGND VPWR sky130_fd_sc_hd__tapvpwrvgnd_1
XTAP_1573 VGND VPWR sky130_fd_sc_hd__tapvpwrvgnd_1
XTAP_1562 VGND VPWR sky130_fd_sc_hd__tapvpwrvgnd_1
XFILLER_0_83_322 VGND VGND VPWR VPWR sky130_fd_sc_hd__decap_4
XPHY_91 VGND VGND VPWR VPWR sky130_fd_sc_hd__decap_3
XPHY_80 VGND VGND VPWR VPWR sky130_fd_sc_hd__decap_3
XTAP_1595 VGND VPWR sky130_fd_sc_hd__tapvpwrvgnd_1
XFILLER_0_114_608 VGND VGND VPWR VPWR sky130_fd_sc_hd__decap_8
XFILLER_0_71_539 VGND VGND VPWR VPWR sky130_fd_sc_hd__decap_3
XFILLER_0_107_671 VGND VGND VPWR VPWR sky130_fd_sc_hd__fill_1
XANTENNA__4151__B _1275_ VGND VGND VPWR VPWR sky130_fd_sc_hd__diode_2
XFILLER_0_3_305 VGND VGND VPWR VPWR sky130_fd_sc_hd__decap_6
XFILLER_0_24_433 VGND VGND VPWR VPWR sky130_fd_sc_hd__fill_1
XFILLER_0_36_282 VGND VGND VPWR VPWR sky130_fd_sc_hd__fill_2
X_3480_ u_pe_array.g_pe_row\[3\].g_pe_col\[0\].u_pe.move_reg\[7\] _0730_ VGND VGND
+ VPWR VPWR _0748_ sky130_fd_sc_hd__or2_1
X_5150_ _2112_ _2120_ _2121_ VGND VGND VPWR VPWR _2123_ sky130_fd_sc_hd__and3_1
XANTENNA__6793__S _3366_ VGND VGND VPWR VPWR sky130_fd_sc_hd__diode_2
X_4101_ _1251_ _1252_ VGND VGND VPWR VPWR _1253_ sky130_fd_sc_hd__xnor2_1
X_5081_ _2029_ _2058_ u_pe_array.g_pe_row\[1\].g_pe_col\[3\].u_pe.psum_out\[4\] VGND
+ VGND VPWR VPWR _2060_ sky130_fd_sc_hd__and3_1
X_4032_ _1188_ _1190_ VGND VGND VPWR VPWR _1191_ sky130_fd_sc_hd__xor2_1
XANTENNA__3511__A _0754_ VGND VGND VPWR VPWR sky130_fd_sc_hd__diode_2
X_5983_ _2783_ _2784_ _2817_ VGND VGND VPWR VPWR _2818_ sky130_fd_sc_hd__or3_1
XFILLER_0_93_108 VGND VGND VPWR VPWR sky130_fd_sc_hd__fill_2
X_4934_ _1926_ _1928_ _1934_ _0885_ VGND VGND VPWR VPWR _1936_ sky130_fd_sc_hd__o31a_1
XFILLER_0_59_385 VGND VGND VPWR VPWR sky130_fd_sc_hd__decap_6
XFILLER_0_19_238 VGND VGND VPWR VPWR sky130_fd_sc_hd__fill_2
X_7653_ clknet_leaf_23_clk _0702_ VGND VGND VPWR VPWR u_pe_array.u_fifo1.buffer\[6\]\[11\]
+ sky130_fd_sc_hd__dfxtp_1
X_4865_ _1870_ _1872_ VGND VGND VPWR VPWR _1873_ sky130_fd_sc_hd__nor2_1
X_7584_ clknet_leaf_25_clk _0633_ VGND VGND VPWR VPWR u_pe_array.u_fifo1.buffer\[1\]\[7\]
+ sky130_fd_sc_hd__dfxtp_1
X_4796_ u_pe_array.g_pe_row\[1\].g_pe_col\[0\].u_pe.w_buffer\[0\] net804 _0828_ VGND
+ VGND VPWR VPWR _1822_ sky130_fd_sc_hd__mux2_1
XFILLER_0_6_121 VPWR VGND VPWR VGND sky130_ef_sc_hd__decap_12
X_6604_ _3271_ VGND VGND VPWR VPWR _0576_ sky130_fd_sc_hd__clkbuf_1
X_3816_ u_pe_array.g_pe_row\[3\].g_pe_col\[2\].u_pe.psum_out\[0\] u_pe_array.g_pe_row\[3\].g_pe_col\[2\].u_pe.act_val\[0\]
+ u_pe_array.g_pe_row\[3\].g_pe_col\[2\].u_pe.w_reg\[0\] VGND VGND VPWR VPWR _1008_
+ sky130_fd_sc_hd__nand3_1
X_6535_ net282 _1814_ _3224_ VGND VGND VPWR VPWR _3234_ sky130_fd_sc_hd__mux2_1
XFILLER_0_6_165 VPWR VGND VPWR VGND sky130_ef_sc_hd__decap_12
XFILLER_0_15_422 VGND VGND VPWR VPWR sky130_fd_sc_hd__decap_4
XFILLER_0_15_444 VGND VGND VPWR VPWR sky130_fd_sc_hd__fill_2
X_3747_ _0914_ _0956_ _0957_ _0861_ _0958_ VGND VGND VPWR VPWR _0032_ sky130_fd_sc_hd__o32ai_1
XFILLER_0_113_641 VPWR VGND VPWR VGND sky130_ef_sc_hd__decap_12
XFILLER_0_70_572 VGND VGND VPWR VPWR sky130_fd_sc_hd__fill_2
XFILLER_0_70_561 VGND VGND VPWR VPWR sky130_fd_sc_hd__decap_4
XANTENNA__5872__S _0745_ VGND VGND VPWR VPWR sky130_fd_sc_hd__diode_2
XFILLER_0_30_414 VGND VGND VPWR VPWR sky130_fd_sc_hd__fill_2
XANTENNA__3771__B1 _0867_ VGND VGND VPWR VPWR sky130_fd_sc_hd__diode_2
XFILLER_0_88_72 VGND VGND VPWR VPWR sky130_fd_sc_hd__fill_2
XFILLER_0_88_61 VGND VGND VPWR VPWR sky130_fd_sc_hd__decap_3
X_3678_ u_pe_array.g_pe_row\[3\].g_pe_col\[3\].u_pe.psum_out\[3\] _0894_ VGND VGND
+ VPWR VPWR _0895_ sky130_fd_sc_hd__xor2_1
X_6466_ _3197_ VGND VGND VPWR VPWR _0512_ sky130_fd_sc_hd__clkbuf_1
XFILLER_0_42_285 VGND VGND VPWR VPWR sky130_fd_sc_hd__fill_2
X_5417_ _2258_ _2341_ _2343_ _2071_ net371 VGND VGND VPWR VPWR _0317_ sky130_fd_sc_hd__a32o_1
X_6397_ u_pe_array.u_fifo2.count\[0\] _3157_ u_pe_array.u_fifo2.count\[2\] VGND VGND
+ VPWR VPWR _3159_ sky130_fd_sc_hd__a21o_1
XFILLER_0_2_371 VGND VGND VPWR VPWR sky130_fd_sc_hd__fill_1
X_5348_ u_pe_array.u_fifo1.buffer\[3\]\[0\] _2282_ _2283_ u_pe_array.u_fifo1.buffer\[2\]\[0\]
+ _2287_ VGND VGND VPWR VPWR _2288_ sky130_fd_sc_hd__a221o_1
XFILLER_0_10_193 VGND VGND VPWR VPWR sky130_fd_sc_hd__decap_3
X_5279_ _2226_ u_pe_array.g_pe_row\[1\].g_pe_col\[2\].u_pe.psum_out\[7\] _2212_ VGND
+ VGND VPWR VPWR _2227_ sky130_fd_sc_hd__mux2_1
XANTENNA__4079__A1 _0864_ VGND VGND VPWR VPWR sky130_fd_sc_hd__diode_2
X_7018_ clknet_leaf_89_clk _0095_ net819 VGND VGND VPWR VPWR u_pe_array.g_pe_row\[2\].g_pe_col\[3\].u_pe.act_val\[0\]
+ sky130_fd_sc_hd__dfrtp_4
XANTENNA__4517__A _1536_ VGND VGND VPWR VPWR sky130_fd_sc_hd__diode_2
XANTENNA__5579__A1 _2258_ VGND VGND VPWR VPWR sky130_fd_sc_hd__diode_2
XFILLER_0_38_514 VGND VGND VPWR VPWR sky130_fd_sc_hd__fill_2
XANTENNA__4251__A1 _0914_ VGND VGND VPWR VPWR sky130_fd_sc_hd__diode_2
XFILLER_0_77_193 VGND VGND VPWR VPWR sky130_fd_sc_hd__fill_2
XFILLER_0_77_182 VGND VGND VPWR VPWR sky130_fd_sc_hd__decap_4
XFILLER_0_65_333 VGND VGND VPWR VPWR sky130_fd_sc_hd__decap_3
XFILLER_0_108_413 VGND VGND VPWR VPWR sky130_fd_sc_hd__fill_2
XFILLER_0_92_141 VGND VGND VPWR VPWR sky130_fd_sc_hd__fill_2
XFILLER_0_53_539 VGND VGND VPWR VPWR sky130_fd_sc_hd__fill_2
XFILLER_0_25_219 VGND VGND VPWR VPWR sky130_fd_sc_hd__decap_3
XANTENNA__6878__S _3412_ VGND VGND VPWR VPWR sky130_fd_sc_hd__diode_2
XANTENNA__5067__B _2029_ VGND VGND VPWR VPWR sky130_fd_sc_hd__diode_2
XFILLER_0_61_561 VGND VGND VPWR VPWR sky130_fd_sc_hd__fill_2
XFILLER_0_103_140 VGND VGND VPWR VPWR sky130_fd_sc_hd__decap_8
XFILLER_0_33_285 VGND VGND VPWR VPWR sky130_fd_sc_hd__fill_2
XFILLER_0_21_458 VGND VGND VPWR VPWR sky130_fd_sc_hd__decap_3
XFILLER_0_21_469 VGND VGND VPWR VPWR sky130_fd_sc_hd__decap_4
XTAP_609 VGND VPWR sky130_fd_sc_hd__tapvpwrvgnd_1
XANTENNA__7395__RESET_B net817 VGND VGND VPWR VPWR sky130_fd_sc_hd__diode_2
XANTENNA__3817__A1 _0864_ VGND VGND VPWR VPWR sky130_fd_sc_hd__diode_2
XFILLER_0_88_403 VGND VGND VPWR VPWR sky130_fd_sc_hd__fill_2
XFILLER_0_17_57 VGND VGND VPWR VPWR sky130_fd_sc_hd__fill_2
XANTENNA__7324__RESET_B net13 VGND VGND VPWR VPWR sky130_fd_sc_hd__diode_2
XTAP_1392 VGND VPWR sky130_fd_sc_hd__tapvpwrvgnd_1
XTAP_1381 VGND VPWR sky130_fd_sc_hd__tapvpwrvgnd_1
XTAP_1370 VGND VPWR sky130_fd_sc_hd__tapvpwrvgnd_1
X_4650_ _1695_ _1697_ VGND VGND VPWR VPWR _1699_ sky130_fd_sc_hd__nand2_1
XFILLER_0_114_427 VPWR VGND VPWR VGND sky130_ef_sc_hd__decap_12
XFILLER_0_114_405 VPWR VGND VPWR VGND sky130_ef_sc_hd__decap_12
Xinput10 h_in1[3] VGND VGND VPWR VPWR net10 sky130_fd_sc_hd__clkbuf_2
Xinput21 v_in1[0] VGND VGND VPWR VPWR net21 sky130_fd_sc_hd__clkbuf_2
XFILLER_0_4_625 VPWR VGND VPWR VGND sky130_ef_sc_hd__decap_12
X_3601_ _0833_ VGND VGND VPWR VPWR _0834_ sky130_fd_sc_hd__buf_6
XFILLER_0_114_449 VPWR VGND VPWR VGND sky130_ef_sc_hd__decap_12
X_6320_ _0788_ _3104_ VGND VGND VPWR VPWR _3105_ sky130_fd_sc_hd__nand2_1
XFILLER_0_3_113 VPWR VGND VPWR VGND sky130_ef_sc_hd__decap_12
XANTENNA__3753__B1 _0885_ VGND VGND VPWR VPWR sky130_fd_sc_hd__diode_2
X_4581_ net567 _1152_ _0887_ _1648_ VGND VGND VPWR VPWR _0176_ sky130_fd_sc_hd__a22o_1
Xinput32 w_in_flat[5] VGND VGND VPWR VPWR net32 sky130_fd_sc_hd__clkbuf_2
X_3532_ u_fsm.cnt\[3\] _0779_ VGND VGND VPWR VPWR _0780_ sky130_fd_sc_hd__or2_2
XFILLER_0_52_583 VGND VGND VPWR VPWR sky130_fd_sc_hd__decap_3
XFILLER_0_4_669 VGND VGND VPWR VPWR sky130_fd_sc_hd__decap_8
XFILLER_0_12_425 VGND VGND VPWR VPWR sky130_fd_sc_hd__fill_1
X_6251_ _3042_ _3043_ VGND VGND VPWR VPWR _3044_ sky130_fd_sc_hd__nand2_1
X_3463_ _0736_ VGND VGND VPWR VPWR net53 sky130_fd_sc_hd__buf_1
X_6182_ _2983_ _2984_ VGND VGND VPWR VPWR _2985_ sky130_fd_sc_hd__xnor2_1
XANTENNA__3506__A _0764_ VGND VGND VPWR VPWR sky130_fd_sc_hd__diode_2
XFILLER_0_58_53 VPWR VGND VPWR VGND sky130_ef_sc_hd__decap_12
X_5202_ _1725_ _2154_ _2156_ _2071_ net370 VGND VGND VPWR VPWR _0289_ sky130_fd_sc_hd__a32o_1
XFILLER_0_58_97 VGND VGND VPWR VPWR sky130_fd_sc_hd__decap_3
X_5133_ u_pe_array.g_pe_row\[1\].g_pe_col\[3\].u_pe.psum_out\[8\] u_pe_array.g_pe_row\[1\].g_pe_col\[3\].u_pe.psum_out\[7\]
+ _2029_ VGND VGND VPWR VPWR _2108_ sky130_fd_sc_hd__and3b_1
X_5064_ net579 _1714_ _0887_ _2044_ VGND VGND VPWR VPWR _0263_ sky130_fd_sc_hd__a22o_1
XANTENNA__6028__S _0770_ VGND VGND VPWR VPWR sky130_fd_sc_hd__diode_2
XFILLER_0_74_85 VGND VGND VPWR VPWR sky130_fd_sc_hd__fill_1
X_4015_ u_pe_array.g_pe_row\[3\].g_pe_col\[1\].u_pe.act_val\[3\] VGND VGND VPWR VPWR
+ _1175_ sky130_fd_sc_hd__inv_2
XANTENNA__7065__RESET_B net819 VGND VGND VPWR VPWR sky130_fd_sc_hd__diode_2
XANTENNA__6255__C _2992_ VGND VGND VPWR VPWR sky130_fd_sc_hd__diode_2
XFILLER_0_94_428 VGND VGND VPWR VPWR sky130_fd_sc_hd__decap_3
XFILLER_0_90_73 VGND VGND VPWR VPWR sky130_fd_sc_hd__fill_2
X_5966_ _2798_ _2799_ _2801_ VGND VGND VPWR VPWR _2803_ sky130_fd_sc_hd__a21oi_1
X_4917_ u_pe_array.g_pe_row\[2\].g_pe_col\[0\].u_pe.psum_out\[7\] VGND VGND VPWR VPWR
+ _1920_ sky130_fd_sc_hd__inv_2
XFILLER_0_74_141 VGND VGND VPWR VPWR sky130_fd_sc_hd__fill_2
X_5897_ _0863_ VGND VGND VPWR VPWR _2740_ sky130_fd_sc_hd__buf_8
XANTENNA__5981__A1 _2740_ VGND VGND VPWR VPWR sky130_fd_sc_hd__diode_2
X_7636_ clknet_leaf_24_clk _0685_ VGND VGND VPWR VPWR u_pe_array.u_fifo1.buffer\[5\]\[7\]
+ sky130_fd_sc_hd__dfxtp_1
X_4848_ u_pe_array.g_pe_row\[2\].g_pe_col\[0\].u_pe.act_val\[2\] u_pe_array.g_pe_row\[2\].g_pe_col\[0\].u_pe.w_reg\[0\]
+ VGND VGND VPWR VPWR _1857_ sky130_fd_sc_hd__nand2_1
XFILLER_0_90_634 VGND VGND VPWR VPWR sky130_fd_sc_hd__fill_2
XFILLER_0_74_152 VGND VGND VPWR VPWR sky130_fd_sc_hd__decap_3
XFILLER_0_90_645 VGND VGND VPWR VPWR sky130_fd_sc_hd__fill_2
XFILLER_0_62_358 VGND VGND VPWR VPWR sky130_fd_sc_hd__fill_1
XFILLER_0_105_449 VGND VGND VPWR VPWR sky130_fd_sc_hd__decap_3
X_7567_ clknet_leaf_21_clk _0616_ VGND VGND VPWR VPWR u_pe_array.u_fifo1.buffer\[0\]\[3\]
+ sky130_fd_sc_hd__dfxtp_1
X_4779_ _1810_ net315 _1796_ VGND VGND VPWR VPWR _1811_ sky130_fd_sc_hd__mux2_1
XANTENNA__5733__B2 _2336_ VGND VGND VPWR VPWR sky130_fd_sc_hd__diode_2
XFILLER_0_70_380 VGND VGND VPWR VPWR sky130_fd_sc_hd__decap_3
X_7498_ clknet_leaf_0_clk _0547_ VGND VGND VPWR VPWR u_pe_array.u_fifo2.buffer\[4\]\[11\]
+ sky130_fd_sc_hd__dfxtp_1
XFILLER_0_15_285 VGND VGND VPWR VPWR sky130_fd_sc_hd__fill_1
XFILLER_0_15_296 VGND VGND VPWR VPWR sky130_fd_sc_hd__decap_3
X_6518_ _3225_ VGND VGND VPWR VPWR _0536_ sky130_fd_sc_hd__clkbuf_1
XFILLER_0_101_600 VGND VGND VPWR VPWR sky130_fd_sc_hd__fill_1
X_6449_ _3188_ VGND VGND VPWR VPWR _0504_ sky130_fd_sc_hd__clkbuf_1
XANTENNA__5249__B1 _0913_ VGND VGND VPWR VPWR sky130_fd_sc_hd__diode_2
XANTENNA__4247__A _1275_ VGND VGND VPWR VPWR sky130_fd_sc_hd__diode_2
XFILLER_0_97_233 VGND VGND VPWR VPWR sky130_fd_sc_hd__decap_8
XFILLER_0_97_211 VGND VGND VPWR VPWR sky130_fd_sc_hd__fill_2
XFILLER_0_97_255 VGND VGND VPWR VPWR sky130_fd_sc_hd__fill_2
XFILLER_0_97_288 VGND VGND VPWR VPWR sky130_fd_sc_hd__decap_4
XFILLER_0_78_491 VGND VGND VPWR VPWR sky130_fd_sc_hd__fill_2
XFILLER_0_38_333 VGND VGND VPWR VPWR sky130_fd_sc_hd__decap_4
XFILLER_0_93_483 VGND VGND VPWR VPWR sky130_fd_sc_hd__fill_2
XFILLER_0_38_388 VGND VGND VPWR VPWR sky130_fd_sc_hd__fill_2
XFILLER_0_80_166 VGND VGND VPWR VPWR sky130_fd_sc_hd__fill_2
XFILLER_0_110_27 VGND VGND VPWR VPWR sky130_fd_sc_hd__fill_1
XFILLER_0_1_617 VPWR VGND VPWR VGND sky130_ef_sc_hd__decap_12
XFILLER_0_34_572 VGND VGND VPWR VPWR sky130_fd_sc_hd__fill_1
XFILLER_0_104_471 VGND VGND VPWR VPWR sky130_fd_sc_hd__fill_1
XFILLER_0_0_138 VGND VGND VPWR VPWR sky130_fd_sc_hd__fill_2
XTAP_406 VGND VPWR sky130_fd_sc_hd__tapvpwrvgnd_1
XTAP_417 VGND VPWR sky130_fd_sc_hd__tapvpwrvgnd_1
XTAP_428 VGND VPWR sky130_fd_sc_hd__tapvpwrvgnd_1
XTAP_439 VGND VPWR sky130_fd_sc_hd__tapvpwrvgnd_1
XFILLER_0_28_45 VGND VGND VPWR VPWR sky130_fd_sc_hd__fill_1
XANTENNA__4999__C1 _0819_ VGND VGND VPWR VPWR sky130_fd_sc_hd__diode_2
XANTENNA__5660__B1 _2071_ VGND VGND VPWR VPWR sky130_fd_sc_hd__diode_2
XANTENNA__4463__A1 _1273_ VGND VGND VPWR VPWR sky130_fd_sc_hd__diode_2
XFILLER_0_76_406 VPWR VGND VPWR VGND sky130_ef_sc_hd__decap_12
XFILLER_0_57_631 VGND VGND VPWR VPWR sky130_fd_sc_hd__fill_2
X_5820_ _2641_ _2650_ _2681_ _2682_ VGND VGND VPWR VPWR _2683_ sky130_fd_sc_hd__or4_1
XFILLER_0_8_216 VGND VGND VPWR VPWR sky130_fd_sc_hd__fill_2
XFILLER_0_8_205 VGND VGND VPWR VPWR sky130_fd_sc_hd__fill_2
X_5751_ u_pe_array.g_pe_row\[0\].g_pe_col\[3\].u_pe.act_val\[1\] _2611_ VGND VGND
+ VPWR VPWR _2620_ sky130_fd_sc_hd__and2b_1
XANTENNA__4766__A2 _0844_ VGND VGND VPWR VPWR sky130_fd_sc_hd__diode_2
X_4702_ _1702_ _1711_ _1744_ _1745_ VGND VGND VPWR VPWR _1746_ sky130_fd_sc_hd__or4_1
XFILLER_0_56_152 VGND VGND VPWR VPWR sky130_fd_sc_hd__fill_2
XFILLER_0_17_528 VGND VGND VPWR VPWR sky130_fd_sc_hd__decap_3
X_5682_ _2258_ _2569_ _2570_ _2571_ net738 VGND VGND VPWR VPWR _0354_ sky130_fd_sc_hd__a32o_1
X_7421_ clknet_leaf_17_clk _0470_ VGND VGND VPWR VPWR u_pe_array.u_fifo1.buffer\[8\]\[11\]
+ sky130_fd_sc_hd__dfxtp_1
XFILLER_0_71_122 VPWR VGND VPWR VGND sky130_ef_sc_hd__decap_12
XFILLER_0_71_111 VGND VGND VPWR VPWR sky130_fd_sc_hd__fill_1
XFILLER_0_60_65 VPWR VGND VPWR VGND sky130_ef_sc_hd__decap_12
X_4633_ _1681_ _1682_ VGND VGND VPWR VPWR _1683_ sky130_fd_sc_hd__xnor2_1
XFILLER_0_8_22 VGND VGND VPWR VPWR sky130_fd_sc_hd__decap_6
XFILLER_0_4_411 VGND VGND VPWR VPWR sky130_fd_sc_hd__fill_1
XFILLER_0_25_561 VGND VGND VPWR VPWR sky130_fd_sc_hd__fill_1
XFILLER_0_71_188 VGND VGND VPWR VPWR sky130_fd_sc_hd__fill_2
X_7352_ clknet_leaf_64_clk _0407_ net818 VGND VGND VPWR VPWR u_pe_array.g_pe_row\[0\].g_pe_col\[2\].u_pe.psum_out\[6\]
+ sky130_fd_sc_hd__dfrtp_1
XFILLER_0_12_211 VPWR VGND VPWR VGND sky130_ef_sc_hd__decap_12
XFILLER_0_8_44 VGND VGND VPWR VPWR sky130_fd_sc_hd__fill_1
XFILLER_0_8_33 VGND VGND VPWR VPWR sky130_fd_sc_hd__fill_1
X_4564_ _1536_ u_pe_array.g_pe_row\[2\].g_pe_col\[2\].u_pe.psum_out\[9\] _1633_ VGND
+ VGND VPWR VPWR _1634_ sky130_fd_sc_hd__and3_1
Xhold602 u_pe_array.g_pe_row\[0\].g_pe_col\[3\].u_pe.act_val\[2\] VGND VGND VPWR VPWR
+ net678 sky130_fd_sc_hd__dlygate4sd3_1
XFILLER_0_102_419 VGND VGND VPWR VPWR sky130_fd_sc_hd__fill_1
X_6303_ _3086_ _3090_ VGND VGND VPWR VPWR _3091_ sky130_fd_sc_hd__or2_1
Xhold624 u_pe_array.g_pe_row\[2\].g_pe_col\[1\].u_pe.psum_out\[3\] VGND VGND VPWR
+ VPWR net700 sky130_fd_sc_hd__dlygate4sd3_1
X_3515_ u_pe_array.g_pe_row\[1\].g_pe_col\[0\].u_pe.move_reg\[6\] _0770_ VGND VGND
+ VPWR VPWR _0771_ sky130_fd_sc_hd__or2_1
Xhold635 u_pe_array.g_pe_row\[1\].g_pe_col\[2\].u_pe.act_val\[0\] VGND VGND VPWR VPWR
+ net711 sky130_fd_sc_hd__dlygate4sd3_1
Xhold613 u_pe_array.g_pe_row\[0\].g_pe_col\[2\].u_pe.psum_out\[2\] VGND VGND VPWR
+ VPWR net689 sky130_fd_sc_hd__dlygate4sd3_1
XFILLER_0_8_88 VGND VGND VPWR VPWR sky130_fd_sc_hd__fill_2
XFILLER_0_4_477 VPWR VGND VPWR VGND sky130_ef_sc_hd__decap_12
X_7283_ clknet_leaf_71_clk _0344_ net814 VGND VGND VPWR VPWR u_pe_array.g_pe_row\[0\].g_pe_col\[3\].u_pe.move_reg\[12\]
+ sky130_fd_sc_hd__dfrtp_1
X_6234_ _3026_ _3027_ VGND VGND VPWR VPWR _3028_ sky130_fd_sc_hd__nor2_1
Xhold646 u_pe_array.g_pe_row\[0\].g_pe_col\[1\].u_pe.psum_out\[10\] VGND VGND VPWR
+ VPWR net722 sky130_fd_sc_hd__dlygate4sd3_1
XFILLER_0_69_96 VGND VGND VPWR VPWR sky130_fd_sc_hd__fill_1
Xhold668 u_pe_array.u_fifo2.count\[3\] VGND VGND VPWR VPWR net744 sky130_fd_sc_hd__dlygate4sd3_1
Xhold657 u_pe_array.g_pe_row\[3\].g_pe_col\[3\].u_pe.psum_out\[2\] VGND VGND VPWR
+ VPWR net733 sky130_fd_sc_hd__dlygate4sd3_1
X_4495_ _1568_ _1569_ u_pe_array.g_pe_row\[2\].g_pe_col\[2\].u_pe.psum_out\[4\] VGND
+ VGND VPWR VPWR _1571_ sky130_fd_sc_hd__a21o_1
Xhold679 u_pe_array.g_pe_row\[2\].g_pe_col\[3\].u_pe.act_val\[0\] VGND VGND VPWR VPWR
+ net755 sky130_fd_sc_hd__dlygate4sd3_1
XFILLER_0_40_597 VGND VGND VPWR VPWR sky130_fd_sc_hd__fill_2
XFILLER_0_110_463 VPWR VGND VPWR VGND sky130_ef_sc_hd__decap_12
X_3446_ _0721_ VGND VGND VPWR VPWR _0722_ sky130_fd_sc_hd__clkbuf_8
XFILLER_0_12_299 VGND VGND VPWR VPWR sky130_fd_sc_hd__decap_3
X_6165_ net722 VGND VGND VPWR VPWR _2970_ sky130_fd_sc_hd__inv_2
XANTENNA__7246__RESET_B net75 VGND VGND VPWR VPWR sky130_fd_sc_hd__diode_2
XTAP_951 VGND VPWR sky130_fd_sc_hd__tapvpwrvgnd_1
XTAP_962 VGND VPWR sky130_fd_sc_hd__tapvpwrvgnd_1
XTAP_940 VGND VPWR sky130_fd_sc_hd__tapvpwrvgnd_1
X_6096_ u_pe_array.g_pe_row\[0\].g_pe_col\[1\].u_pe.psum_out\[4\] _2905_ _2906_ VGND
+ VGND VPWR VPWR _2907_ sky130_fd_sc_hd__nand3_1
XTAP_995 VGND VPWR sky130_fd_sc_hd__tapvpwrvgnd_1
XTAP_984 VGND VPWR sky130_fd_sc_hd__tapvpwrvgnd_1
XTAP_973 VGND VPWR sky130_fd_sc_hd__tapvpwrvgnd_1
X_5116_ _0914_ _2092_ VGND VGND VPWR VPWR _2093_ sky130_fd_sc_hd__nor2_1
X_5047_ u_pe_array.g_pe_row\[1\].g_pe_col\[3\].u_pe.w_reg\[1\] VGND VGND VPWR VPWR
+ _2029_ sky130_fd_sc_hd__clkbuf_8
XFILLER_0_79_244 VGND VGND VPWR VPWR sky130_fd_sc_hd__fill_1
X_6998_ clknet_leaf_39_clk _0077_ net817 VGND VGND VPWR VPWR u_pe_array.g_pe_row\[3\].g_pe_col\[0\].u_pe.move_reg\[10\]
+ sky130_fd_sc_hd__dfrtp_1
XFILLER_0_79_288 VGND VGND VPWR VPWR sky130_fd_sc_hd__fill_2
X_5949_ u_pe_array.g_pe_row\[0\].g_pe_col\[2\].u_pe.act_val\[5\] u_pe_array.g_pe_row\[0\].g_pe_col\[2\].u_pe.w_reg\[0\]
+ VGND VGND VPWR VPWR _2787_ sky130_fd_sc_hd__nand2_1
XANTENNA__3965__A0 u_pe_array.g_pe_row\[2\].g_pe_col\[0\].u_pe.move_reg\[7\] VGND
+ VGND VPWR VPWR sky130_fd_sc_hd__diode_2
XFILLER_0_105_235 VGND VGND VPWR VPWR sky130_fd_sc_hd__fill_2
XFILLER_0_90_464 VGND VGND VPWR VPWR sky130_fd_sc_hd__fill_2
X_7619_ clknet_leaf_21_clk _0668_ VGND VGND VPWR VPWR u_pe_array.u_fifo1.buffer\[4\]\[3\]
+ sky130_fd_sc_hd__dfxtp_1
XFILLER_0_62_166 VGND VGND VPWR VPWR sky130_fd_sc_hd__fill_1
XFILLER_0_16_550 VGND VGND VPWR VPWR sky130_fd_sc_hd__fill_2
XFILLER_0_105_257 VGND VGND VPWR VPWR sky130_fd_sc_hd__decap_4
XFILLER_0_105_246 VGND VGND VPWR VPWR sky130_fd_sc_hd__decap_4
XANTENNA__5182__A2 _2144_ VGND VGND VPWR VPWR sky130_fd_sc_hd__diode_2
XFILLER_0_31_597 VGND VGND VPWR VPWR sky130_fd_sc_hd__fill_2
XANTENNA__5361__A _1787_ VGND VGND VPWR VPWR sky130_fd_sc_hd__diode_2
XANTENNA_input24_A v_in1[3] VGND VGND VPWR VPWR sky130_fd_sc_hd__diode_2
XANTENNA__6969__RESET_B net818 VGND VGND VPWR VPWR sky130_fd_sc_hd__diode_2
XFILLER_0_98_564 VGND VGND VPWR VPWR sky130_fd_sc_hd__decap_4
XFILLER_0_105_27 VPWR VGND VPWR VGND sky130_ef_sc_hd__decap_12
XFILLER_0_85_225 VGND VGND VPWR VPWR sky130_fd_sc_hd__fill_2
XANTENNA__3956__B1 _0837_ VGND VGND VPWR VPWR sky130_fd_sc_hd__diode_2
XFILLER_0_38_141 VGND VGND VPWR VPWR sky130_fd_sc_hd__decap_4
XFILLER_0_109_552 VGND VGND VPWR VPWR sky130_fd_sc_hd__decap_8
XFILLER_0_54_645 VGND VGND VPWR VPWR sky130_fd_sc_hd__decap_3
XFILLER_0_38_185 VGND VGND VPWR VPWR sky130_fd_sc_hd__fill_1
XFILLER_0_109_585 VPWR VGND VPWR VGND sky130_ef_sc_hd__decap_12
XANTENNA__5173__A2 _1666_ VGND VGND VPWR VPWR sky130_fd_sc_hd__diode_2
XFILLER_0_104_290 VGND VGND VPWR VPWR sky130_fd_sc_hd__decap_8
XFILLER_0_1_447 VGND VGND VPWR VPWR sky130_fd_sc_hd__fill_1
X_4280_ u_pe_array.g_pe_row\[2\].g_pe_col\[3\].u_pe.psum_out\[5\] u_pe_array.g_pe_row\[2\].g_pe_col\[3\].u_pe.act_val\[5\]
+ _0769_ VGND VGND VPWR VPWR _1396_ sky130_fd_sc_hd__mux2_1
XANTENNA__4586__S _0770_ VGND VGND VPWR VPWR sky130_fd_sc_hd__diode_2
XTAP_236 VGND VPWR sky130_fd_sc_hd__tapvpwrvgnd_1
XTAP_247 VGND VPWR sky130_fd_sc_hd__tapvpwrvgnd_1
XFILLER_0_39_77 VGND VGND VPWR VPWR sky130_fd_sc_hd__fill_2
XANTENNA__5881__B1 _2592_ VGND VGND VPWR VPWR sky130_fd_sc_hd__diode_2
XANTENNA__3487__A2 _0745_ VGND VGND VPWR VPWR sky130_fd_sc_hd__diode_2
XANTENNA__4684__A1 _1672_ VGND VGND VPWR VPWR sky130_fd_sc_hd__diode_2
XTAP_258 VGND VPWR sky130_fd_sc_hd__tapvpwrvgnd_1
XTAP_269 VGND VPWR sky130_fd_sc_hd__tapvpwrvgnd_1
X_6921_ clknet_leaf_82_clk _0007_ net815 VGND VGND VPWR VPWR u_fsm.v_cnt\[1\] sky130_fd_sc_hd__dfrtp_1
X_6852_ net268 _3130_ _3397_ VGND VGND VPWR VPWR _3408_ sky130_fd_sc_hd__mux2_1
XFILLER_0_89_597 VGND VGND VPWR VPWR sky130_fd_sc_hd__fill_2
XFILLER_0_76_247 VGND VGND VPWR VPWR sky130_fd_sc_hd__decap_4
X_5803_ _2666_ _2667_ VGND VGND VPWR VPWR _2668_ sky130_fd_sc_hd__or2_1
XANTENNA__3947__B1 _0837_ VGND VGND VPWR VPWR sky130_fd_sc_hd__diode_2
X_6783_ net524 _3118_ _3366_ VGND VGND VPWR VPWR _3371_ sky130_fd_sc_hd__mux2_1
X_3995_ u_pe_array.g_pe_row\[3\].g_pe_col\[1\].u_pe.act_val\[0\] VGND VGND VPWR VPWR
+ _1157_ sky130_fd_sc_hd__inv_2
XFILLER_0_57_494 VGND VGND VPWR VPWR sky130_fd_sc_hd__decap_8
XFILLER_0_44_100 VGND VGND VPWR VPWR sky130_fd_sc_hd__fill_1
X_5734_ u_pe_array.g_pe_row\[0\].g_pe_col\[3\].u_pe.psum_out\[12\] u_pe_array.g_pe_row\[0\].g_pe_col\[3\].u_pe.move_reg\[12\]
+ _2469_ VGND VGND VPWR VPWR _2606_ sky130_fd_sc_hd__mux2_1
XFILLER_0_72_464 VGND VGND VPWR VPWR sky130_fd_sc_hd__fill_1
X_5665_ _2537_ _2547_ u_pe_array.g_pe_row\[1\].g_pe_col\[0\].u_pe.psum_out\[7\] _2533_
+ VGND VGND VPWR VPWR _2556_ sky130_fd_sc_hd__o2bb2a_1
XFILLER_0_60_615 VGND VGND VPWR VPWR sky130_fd_sc_hd__fill_2
XFILLER_0_17_358 VGND VGND VPWR VPWR sky130_fd_sc_hd__decap_6
X_7404_ clknet_leaf_44_clk _0454_ net817 VGND VGND VPWR VPWR u_pe_array.g_pe_row\[0\].g_pe_col\[0\].u_pe.psum_out\[8\]
+ sky130_fd_sc_hd__dfrtp_2
XFILLER_0_88_3 VGND VGND VPWR VPWR sky130_fd_sc_hd__decap_8
XANTENNA__6361__A1 _1787_ VGND VGND VPWR VPWR sky130_fd_sc_hd__diode_2
X_4616_ u_pe_array.g_pe_row\[2\].g_pe_col\[1\].u_pe.w_reg\[0\] u_pe_array.g_pe_row\[2\].g_pe_col\[1\].u_pe.act_val\[0\]
+ u_pe_array.g_pe_row\[2\].g_pe_col\[1\].u_pe.psum_out\[0\] VGND VGND VPWR VPWR _1668_
+ sky130_fd_sc_hd__a21o_1
XFILLER_0_44_177 VGND VGND VPWR VPWR sky130_fd_sc_hd__decap_3
XFILLER_0_111_81 VGND VGND VPWR VPWR sky130_fd_sc_hd__decap_8
X_7335_ clknet_leaf_48_clk _0392_ net812 VGND VGND VPWR VPWR u_pe_array.g_pe_row\[0\].g_pe_col\[1\].u_pe.act_val\[4\]
+ sky130_fd_sc_hd__dfrtp_1
X_5596_ _2491_ _2492_ VGND VGND VPWR VPWR _2493_ sky130_fd_sc_hd__xor2_1
Xhold410 u_pe_array.u_fifo2.buffer\[1\]\[0\] VGND VGND VPWR VPWR net486 sky130_fd_sc_hd__dlygate4sd3_1
XFILLER_0_102_249 VGND VGND VPWR VPWR sky130_fd_sc_hd__fill_1
Xhold454 u_pe_array.u_fifo1.buffer\[3\]\[1\] VGND VGND VPWR VPWR net530 sky130_fd_sc_hd__dlygate4sd3_1
Xhold443 u_pe_array.g_pe_row\[2\].g_pe_col\[0\].u_pe.psum_out\[12\] VGND VGND VPWR
+ VPWR net519 sky130_fd_sc_hd__dlygate4sd3_1
XANTENNA__5880__S _0770_ VGND VGND VPWR VPWR sky130_fd_sc_hd__diode_2
Xhold432 u_pe_array.g_pe_row\[1\].g_pe_col\[2\].u_pe.psum_out\[1\] VGND VGND VPWR
+ VPWR net508 sky130_fd_sc_hd__dlygate4sd3_1
XANTENNA__7427__RESET_B net74 VGND VGND VPWR VPWR sky130_fd_sc_hd__diode_2
Xhold421 u_pe_array.g_pe_row\[2\].g_pe_col\[3\].u_pe.psum_out\[3\] VGND VGND VPWR
+ VPWR net497 sky130_fd_sc_hd__dlygate4sd3_1
X_4547_ net72 _1618_ VGND VGND VPWR VPWR _1619_ sky130_fd_sc_hd__or2_1
XFILLER_0_40_361 VGND VGND VPWR VPWR sky130_fd_sc_hd__decap_3
Xhold476 u_pe_array.u_fifo1.buffer\[8\]\[0\] VGND VGND VPWR VPWR net552 sky130_fd_sc_hd__dlygate4sd3_1
XANTENNA__5533__A_N _2345_ VGND VGND VPWR VPWR sky130_fd_sc_hd__diode_2
X_7266_ clknet_leaf_50_clk _0327_ net812 VGND VGND VPWR VPWR u_pe_array.g_pe_row\[1\].g_pe_col\[1\].u_pe.psum_out\[10\]
+ sky130_fd_sc_hd__dfrtp_1
Xhold487 u_pe_array.g_pe_row\[3\].g_pe_col\[1\].u_pe.psum_out\[6\] VGND VGND VPWR
+ VPWR net563 sky130_fd_sc_hd__dlygate4sd3_1
X_4478_ _1536_ _1554_ u_pe_array.g_pe_row\[2\].g_pe_col\[2\].u_pe.act_val\[3\] u_pe_array.g_pe_row\[2\].g_pe_col\[2\].u_pe.w_reg\[0\]
+ VGND VGND VPWR VPWR _1555_ sky130_fd_sc_hd__a22o_1
Xhold465 u_pe_array.u_fifo2.buffer\[8\]\[2\] VGND VGND VPWR VPWR net541 sky130_fd_sc_hd__dlygate4sd3_1
X_6217_ u_pe_array.g_pe_row\[0\].g_pe_col\[0\].u_pe.act_val\[3\] u_pe_array.g_pe_row\[0\].g_pe_col\[0\].u_pe.w_reg\[0\]
+ VGND VGND VPWR VPWR _3012_ sky130_fd_sc_hd__nand2_1
Xhold498 u_pe_array.g_pe_row\[1\].g_pe_col\[0\].u_pe.act_val\[4\] VGND VGND VPWR VPWR
+ net574 sky130_fd_sc_hd__dlygate4sd3_1
XANTENNA__7080__RESET_B net816 VGND VGND VPWR VPWR sky130_fd_sc_hd__diode_2
X_7197_ clknet_leaf_75_clk _0262_ net815 VGND VGND VPWR VPWR u_pe_array.g_pe_row\[1\].g_pe_col\[3\].u_pe.psum_out\[1\]
+ sky130_fd_sc_hd__dfrtp_1
X_6148_ _2945_ _2948_ _2953_ VGND VGND VPWR VPWR _2955_ sky130_fd_sc_hd__a21oi_1
XTAP_770 VGND VPWR sky130_fd_sc_hd__tapvpwrvgnd_1
XTAP_792 VGND VPWR sky130_fd_sc_hd__tapvpwrvgnd_1
XTAP_781 VGND VPWR sky130_fd_sc_hd__tapvpwrvgnd_1
X_6079_ u_pe_array.g_pe_row\[0\].g_pe_col\[1\].u_pe.act_val\[2\] VGND VGND VPWR VPWR
+ _2891_ sky130_fd_sc_hd__inv_2
XFILLER_0_95_501 VGND VGND VPWR VPWR sky130_fd_sc_hd__decap_3
XFILLER_0_67_225 VGND VGND VPWR VPWR sky130_fd_sc_hd__fill_2
XFILLER_0_67_258 VGND VGND VPWR VPWR sky130_fd_sc_hd__fill_2
XANTENNA__4006__B_N _1145_ VGND VGND VPWR VPWR sky130_fd_sc_hd__diode_2
XFILLER_0_82_217 VGND VGND VPWR VPWR sky130_fd_sc_hd__fill_2
XFILLER_0_36_601 VGND VGND VPWR VPWR sky130_fd_sc_hd__fill_1
XFILLER_0_36_612 VGND VGND VPWR VPWR sky130_fd_sc_hd__fill_2
XFILLER_0_106_533 VGND VGND VPWR VPWR sky130_fd_sc_hd__decap_3
XANTENNA__6352__A1 _1787_ VGND VGND VPWR VPWR sky130_fd_sc_hd__diode_2
XFILLER_0_51_637 VGND VGND VPWR VPWR sky130_fd_sc_hd__fill_2
XFILLER_0_35_177 VGND VGND VPWR VPWR sky130_fd_sc_hd__fill_2
XFILLER_0_35_188 VPWR VGND VPWR VGND sky130_ef_sc_hd__decap_12
XANTENNA__7168__RESET_B net817 VGND VGND VPWR VPWR sky130_fd_sc_hd__diode_2
XFILLER_0_50_169 VGND VGND VPWR VPWR sky130_fd_sc_hd__decap_3
XANTENNA__6104__B2 _0875_ VGND VGND VPWR VPWR sky130_fd_sc_hd__diode_2
XANTENNA_clkbuf_leaf_61_clk_A clknet_3_4__leaf_clk VGND VGND VPWR VPWR sky130_fd_sc_hd__diode_2
XFILLER_0_31_383 VGND VGND VPWR VPWR sky130_fd_sc_hd__fill_2
XANTENNA__4115__B1 _1258_ VGND VGND VPWR VPWR sky130_fd_sc_hd__diode_2
XANTENNA__4666__B2 _0916_ VGND VGND VPWR VPWR sky130_fd_sc_hd__diode_2
XANTENNA__3604__A _0836_ VGND VGND VPWR VPWR sky130_fd_sc_hd__diode_2
XANTENNA_clkbuf_leaf_76_clk_A clknet_3_4__leaf_clk VGND VGND VPWR VPWR sky130_fd_sc_hd__diode_2
XANTENNA__5241__D _2158_ VGND VGND VPWR VPWR sky130_fd_sc_hd__diode_2
XFILLER_0_86_501 VGND VGND VPWR VPWR sky130_fd_sc_hd__fill_1
XFILLER_0_58_236 VGND VGND VPWR VPWR sky130_fd_sc_hd__decap_4
XANTENNA__5030__S _1661_ VGND VGND VPWR VPWR sky130_fd_sc_hd__diode_2
XFILLER_0_86_589 VGND VGND VPWR VPWR sky130_fd_sc_hd__fill_2
XFILLER_0_39_461 VGND VGND VPWR VPWR sky130_fd_sc_hd__fill_2
XANTENNA__6591__A1 _1814_ VGND VGND VPWR VPWR sky130_fd_sc_hd__diode_2
X_3780_ _0985_ VGND VGND VPWR VPWR _0038_ sky130_fd_sc_hd__clkbuf_1
XFILLER_0_109_371 VGND VGND VPWR VPWR sky130_fd_sc_hd__fill_2
XANTENNA_clkbuf_leaf_14_clk_A clknet_3_3__leaf_clk VGND VGND VPWR VPWR sky130_fd_sc_hd__diode_2
XFILLER_0_26_144 VGND VGND VPWR VPWR sky130_fd_sc_hd__decap_4
XFILLER_0_26_155 VGND VGND VPWR VPWR sky130_fd_sc_hd__decap_3
XFILLER_0_109_393 VGND VGND VPWR VPWR sky130_fd_sc_hd__fill_2
X_5450_ _2362_ _2373_ VGND VGND VPWR VPWR _2374_ sky130_fd_sc_hd__xor2_1
XFILLER_0_42_626 VGND VGND VPWR VPWR sky130_fd_sc_hd__fill_2
XFILLER_0_26_166 VGND VGND VPWR VPWR sky130_fd_sc_hd__fill_2
XFILLER_0_112_525 VGND VGND VPWR VPWR sky130_fd_sc_hd__decap_6
XANTENNA__6343__A1 _1787_ VGND VGND VPWR VPWR sky130_fd_sc_hd__diode_2
X_4401_ _1497_ _1498_ _1489_ VGND VGND VPWR VPWR _1499_ sky130_fd_sc_hd__a21oi_1
XANTENNA_clkbuf_leaf_29_clk_A clknet_3_3__leaf_clk VGND VGND VPWR VPWR sky130_fd_sc_hd__diode_2
X_5381_ u_pe_array.u_fifo1.buffer\[0\]\[4\] _2275_ VGND VGND VPWR VPWR _2317_ sky130_fd_sc_hd__or2_1
XFILLER_0_10_501 VPWR VGND VPWR VGND sky130_ef_sc_hd__decap_12
XFILLER_0_41_169 VGND VGND VPWR VPWR sky130_fd_sc_hd__decap_3
XFILLER_0_112_569 VPWR VGND VPWR VGND sky130_ef_sc_hd__decap_12
X_7120_ clknet_leaf_38_clk _0191_ net813 VGND VGND VPWR VPWR u_pe_array.g_pe_row\[2\].g_pe_col\[0\].u_pe.move_reg\[12\]
+ sky130_fd_sc_hd__dfrtp_1
XFILLER_0_10_545 VPWR VGND VPWR VGND sky130_ef_sc_hd__decap_12
X_4332_ u_pe_array.g_pe_row\[2\].g_pe_col\[3\].u_pe.act_val\[3\] VGND VGND VPWR VPWR
+ _1436_ sky130_fd_sc_hd__inv_2
X_4263_ _1385_ _1386_ VGND VGND VPWR VPWR _1387_ sky130_fd_sc_hd__xnor2_1
X_7051_ clknet_leaf_91_clk _0126_ net819 VGND VGND VPWR VPWR u_pe_array.g_pe_row\[2\].g_pe_col\[2\].u_pe.act_val\[3\]
+ sky130_fd_sc_hd__dfrtp_1
XANTENNA__3514__A _0756_ VGND VGND VPWR VPWR sky130_fd_sc_hd__diode_2
XFILLER_0_66_53 VPWR VGND VPWR VGND sky130_ef_sc_hd__decap_12
X_6002_ _2740_ _2834_ _2835_ _2571_ net602 VGND VGND VPWR VPWR _0410_ sky130_fd_sc_hd__a32o_1
XFILLER_0_10_589 VPWR VGND VPWR VGND sky130_ef_sc_hd__decap_12
X_4194_ _1312_ _1315_ _1324_ VGND VGND VPWR VPWR _1325_ sky130_fd_sc_hd__o21ai_1
XFILLER_0_96_309 VPWR VGND VPWR VGND sky130_ef_sc_hd__decap_12
X_6904_ net306 _3126_ _3427_ VGND VGND VPWR VPWR _3436_ sky130_fd_sc_hd__mux2_1
XANTENNA__6036__S _0756_ VGND VGND VPWR VPWR sky130_fd_sc_hd__diode_2
XFILLER_0_49_225 VGND VGND VPWR VPWR sky130_fd_sc_hd__decap_4
XANTENNA__3632__A2 _0834_ VGND VGND VPWR VPWR sky130_fd_sc_hd__diode_2
XANTENNA__6031__B1 _2592_ VGND VGND VPWR VPWR sky130_fd_sc_hd__diode_2
X_6835_ _3399_ VGND VGND VPWR VPWR _0679_ sky130_fd_sc_hd__clkbuf_1
XFILLER_0_18_612 VPWR VGND VPWR VGND sky130_ef_sc_hd__decap_12
X_6766_ net239 _3128_ net62 VGND VGND VPWR VPWR _3362_ sky130_fd_sc_hd__mux2_1
XFILLER_0_92_537 VGND VGND VPWR VPWR sky130_fd_sc_hd__fill_2
X_3978_ u_pe_array.g_pe_row\[3\].g_pe_col\[1\].u_pe.w_reg\[0\] u_pe_array.g_pe_row\[3\].g_pe_col\[1\].u_pe.act_val\[0\]
+ u_pe_array.g_pe_row\[3\].g_pe_col\[1\].u_pe.psum_out\[0\] VGND VGND VPWR VPWR _1142_
+ sky130_fd_sc_hd__a21o_1
XFILLER_0_18_645 VPWR VGND VPWR VGND sky130_ef_sc_hd__decap_12
XANTENNA__4593__B1 _1258_ VGND VGND VPWR VPWR sky130_fd_sc_hd__diode_2
XFILLER_0_17_155 VGND VGND VPWR VPWR sky130_fd_sc_hd__fill_2
X_5717_ u_pe_array.g_pe_row\[0\].g_pe_col\[3\].u_pe.act_val\[4\] u_pe_array.g_pe_row\[0\].g_pe_col\[3\].u_pe.psum_out\[4\]
+ _0770_ VGND VGND VPWR VPWR _2597_ sky130_fd_sc_hd__mux2_1
X_6697_ _3326_ VGND VGND VPWR VPWR _0614_ sky130_fd_sc_hd__clkbuf_1
XANTENNA__6334__A1 _1787_ VGND VGND VPWR VPWR sky130_fd_sc_hd__diode_2
XFILLER_0_72_294 VGND VGND VPWR VPWR sky130_fd_sc_hd__fill_2
X_5648_ _2539_ _2540_ VGND VGND VPWR VPWR _2541_ sky130_fd_sc_hd__xnor2_1
XFILLER_0_5_561 VPWR VGND VPWR VGND sky130_ef_sc_hd__decap_12
XANTENNA__7261__RESET_B net812 VGND VGND VPWR VPWR sky130_fd_sc_hd__diode_2
X_5579_ _2258_ _2476_ _2477_ _2071_ net401 VGND VGND VPWR VPWR _0345_ sky130_fd_sc_hd__a32o_1
XFILLER_0_60_489 VGND VGND VPWR VPWR sky130_fd_sc_hd__fill_1
XANTENNA__4345__B1 _1144_ VGND VGND VPWR VPWR sky130_fd_sc_hd__diode_2
Xhold251 u_pe_array.u_fifo1.buffer\[1\]\[11\] VGND VGND VPWR VPWR net327 sky130_fd_sc_hd__dlygate4sd3_1
Xhold262 u_pe_array.u_fifo2.buffer\[3\]\[8\] VGND VGND VPWR VPWR net338 sky130_fd_sc_hd__dlygate4sd3_1
Xhold240 u_pe_array.u_fifo2.buffer\[2\]\[6\] VGND VGND VPWR VPWR net316 sky130_fd_sc_hd__dlygate4sd3_1
X_7318_ clknet_leaf_62_clk _0375_ net814 VGND VGND VPWR VPWR u_pe_array.g_pe_row\[0\].g_pe_col\[3\].u_pe.psum_out\[2\]
+ sky130_fd_sc_hd__dfrtp_1
Xhold273 u_pe_array.u_fifo1.buffer\[8\]\[7\] VGND VGND VPWR VPWR net349 sky130_fd_sc_hd__dlygate4sd3_1
X_7249_ clknet_leaf_56_clk net111 net75 VGND VGND VPWR VPWR u_pe_array.g_pe_row\[1\].g_pe_col\[0\].u_pe.move_reg\[8\]
+ sky130_fd_sc_hd__dfrtp_1
Xhold295 u_pe_array.g_pe_row\[1\].g_pe_col\[1\].u_pe.psum_out\[0\] VGND VGND VPWR
+ VPWR net371 sky130_fd_sc_hd__dlygate4sd3_1
Xhold284 u_pe_array.g_pe_row\[0\].g_pe_col\[3\].u_pe.psum_out\[6\] VGND VGND VPWR
+ VPWR net360 sky130_fd_sc_hd__dlygate4sd3_1
XFILLER_0_40_191 VGND VGND VPWR VPWR sky130_fd_sc_hd__fill_2
XANTENNA_fanout74_A net13 VGND VGND VPWR VPWR sky130_fd_sc_hd__diode_2
XFILLER_0_55_217 VGND VGND VPWR VPWR sky130_fd_sc_hd__decap_4
XFILLER_0_28_409 VGND VGND VPWR VPWR sky130_fd_sc_hd__fill_2
XFILLER_0_91_581 VGND VGND VPWR VPWR sky130_fd_sc_hd__decap_3
XFILLER_0_51_401 VGND VGND VPWR VPWR sky130_fd_sc_hd__fill_1
XANTENNA__7349__RESET_B net818 VGND VGND VPWR VPWR sky130_fd_sc_hd__diode_2
XFILLER_0_23_136 VGND VGND VPWR VPWR sky130_fd_sc_hd__fill_2
XFILLER_0_87_19 VGND VGND VPWR VPWR sky130_fd_sc_hd__fill_2
XANTENNA__6628__A2 _2738_ VGND VGND VPWR VPWR sky130_fd_sc_hd__diode_2
XANTENNA__6984__RESET_B net74 VGND VGND VPWR VPWR sky130_fd_sc_hd__diode_2
XANTENNA_output55_A net55 VGND VGND VPWR VPWR sky130_fd_sc_hd__diode_2
Xinput8 h_in1[1] VGND VGND VPWR VPWR net8 sky130_fd_sc_hd__buf_1
XFILLER_0_59_501 VGND VGND VPWR VPWR sky130_fd_sc_hd__decap_3
X_4950_ _1942_ _1944_ _1949_ VGND VGND VPWR VPWR _1950_ sky130_fd_sc_hd__o21ai_1
X_4881_ _1877_ _1886_ _0914_ VGND VGND VPWR VPWR _1888_ sky130_fd_sc_hd__a21o_1
XFILLER_0_74_515 VGND VGND VPWR VPWR sky130_fd_sc_hd__decap_3
XFILLER_0_59_567 VGND VGND VPWR VPWR sky130_fd_sc_hd__fill_1
X_3901_ _1045_ _1046_ _1057_ VGND VGND VPWR VPWR _1085_ sky130_fd_sc_hd__a21oi_1
XFILLER_0_46_239 VGND VGND VPWR VPWR sky130_fd_sc_hd__decap_3
X_6620_ _3279_ VGND VGND VPWR VPWR _0584_ sky130_fd_sc_hd__clkbuf_1
X_3832_ _1019_ _1021_ VGND VGND VPWR VPWR _1022_ sky130_fd_sc_hd__xnor2_1
XFILLER_0_6_325 VGND VGND VPWR VPWR sky130_fd_sc_hd__decap_4
XFILLER_0_27_453 VGND VGND VPWR VPWR sky130_fd_sc_hd__fill_2
X_6551_ net500 _1802_ _3239_ VGND VGND VPWR VPWR _3243_ sky130_fd_sc_hd__mux2_1
XFILLER_0_82_581 VGND VGND VPWR VPWR sky130_fd_sc_hd__fill_2
XFILLER_0_82_570 VGND VGND VPWR VPWR sky130_fd_sc_hd__decap_3
X_5502_ _2405_ _2412_ _2420_ VGND VGND VPWR VPWR _2421_ sky130_fd_sc_hd__a21oi_1
XFILLER_0_54_250 VGND VGND VPWR VPWR sky130_fd_sc_hd__fill_2
XANTENNA__3509__A _0766_ VGND VGND VPWR VPWR sky130_fd_sc_hd__diode_2
X_3763_ _0966_ _0971_ _0885_ VGND VGND VPWR VPWR _0973_ sky130_fd_sc_hd__o21ai_1
X_3694_ _0906_ _0907_ _0908_ VGND VGND VPWR VPWR _0910_ sky130_fd_sc_hd__a21oi_1
XANTENNA__7019__RESET_B net819 VGND VGND VPWR VPWR sky130_fd_sc_hd__diode_2
X_6482_ _3205_ VGND VGND VPWR VPWR _0520_ sky130_fd_sc_hd__clkbuf_1
XFILLER_0_112_333 VPWR VGND VPWR VGND sky130_ef_sc_hd__decap_12
X_5433_ _2353_ _2357_ VGND VGND VPWR VPWR _2358_ sky130_fd_sc_hd__xor2_1
XFILLER_0_2_531 VGND VGND VPWR VPWR sky130_fd_sc_hd__fill_1
XFILLER_0_23_670 VGND VGND VPWR VPWR sky130_fd_sc_hd__fill_2
XFILLER_0_42_489 VGND VGND VPWR VPWR sky130_fd_sc_hd__fill_2
X_5364_ u_pe_array.u_fifo1.buffer\[4\]\[2\] _2279_ _2280_ u_pe_array.u_fifo1.buffer\[7\]\[2\]
+ VGND VGND VPWR VPWR _2302_ sky130_fd_sc_hd__a22o_1
XANTENNA__3943__S _0828_ VGND VGND VPWR VPWR sky130_fd_sc_hd__diode_2
XFILLER_0_112_377 VPWR VGND VPWR VGND sky130_ef_sc_hd__decap_12
X_4315_ _1410_ _1413_ VGND VGND VPWR VPWR _1421_ sky130_fd_sc_hd__and2_1
X_7103_ clknet_leaf_88_clk _0174_ net74 VGND VGND VPWR VPWR u_pe_array.g_pe_row\[2\].g_pe_col\[2\].u_pe.psum_out\[10\]
+ sky130_fd_sc_hd__dfrtp_2
X_5295_ net714 VGND VGND VPWR VPWR _2242_ sky130_fd_sc_hd__inv_2
X_4246_ u_pe_array.g_pe_row\[3\].g_pe_col\[0\].u_pe.psum_out\[10\] VGND VGND VPWR
+ VPWR _1372_ sky130_fd_sc_hd__inv_2
X_7034_ clknet_leaf_16_clk _0109_ net816 VGND VGND VPWR VPWR u_pe_array.g_pe_row\[3\].g_pe_col\[0\].u_pe.psum_out\[1\]
+ sky130_fd_sc_hd__dfrtp_1
X_4177_ u_pe_array.g_pe_row\[3\].g_pe_col\[0\].u_pe.psum_out\[4\] _1307_ _1308_ VGND
+ VGND VPWR VPWR _1309_ sky130_fd_sc_hd__nand3_1
XFILLER_0_97_607 VGND VGND VPWR VPWR sky130_fd_sc_hd__decap_8
XFILLER_0_93_73 VGND VGND VPWR VPWR sky130_fd_sc_hd__decap_4
XANTENNA__3853__A2 _1009_ VGND VGND VPWR VPWR sky130_fd_sc_hd__diode_2
XANTENNA__6252__B1 _0885_ VGND VGND VPWR VPWR sky130_fd_sc_hd__diode_2
XTAP_1029 VGND VPWR sky130_fd_sc_hd__tapvpwrvgnd_1
XTAP_1018 VGND VPWR sky130_fd_sc_hd__tapvpwrvgnd_1
XTAP_1007 VGND VPWR sky130_fd_sc_hd__tapvpwrvgnd_1
XANTENNA__4802__B2 _1825_ VGND VGND VPWR VPWR sky130_fd_sc_hd__diode_2
X_6818_ net279 _3124_ _3382_ VGND VGND VPWR VPWR _3390_ sky130_fd_sc_hd__mux2_1
XFILLER_0_9_130 VGND VGND VPWR VPWR sky130_fd_sc_hd__fill_2
XANTENNA__6555__A1 _1806_ VGND VGND VPWR VPWR sky130_fd_sc_hd__diode_2
XFILLER_0_9_185 VGND VGND VPWR VPWR sky130_fd_sc_hd__decap_8
XFILLER_0_18_453 VGND VGND VPWR VPWR sky130_fd_sc_hd__fill_2
XFILLER_0_92_389 VGND VGND VPWR VPWR sky130_fd_sc_hd__fill_1
X_6749_ _3353_ VGND VGND VPWR VPWR _0639_ sky130_fd_sc_hd__clkbuf_1
XFILLER_0_73_570 VPWR VGND VPWR VGND sky130_ef_sc_hd__decap_12
XFILLER_0_18_464 VGND VGND VPWR VPWR sky130_fd_sc_hd__fill_2
XFILLER_0_33_445 VGND VGND VPWR VPWR sky130_fd_sc_hd__fill_1
XFILLER_0_60_253 VGND VGND VPWR VPWR sky130_fd_sc_hd__decap_4
XFILLER_0_5_391 VGND VGND VPWR VPWR sky130_fd_sc_hd__fill_1
XANTENNA__5046__A1 _1725_ VGND VGND VPWR VPWR sky130_fd_sc_hd__diode_2
XANTENNA__5597__A2 _2387_ VGND VGND VPWR VPWR sky130_fd_sc_hd__diode_2
XFILLER_0_68_320 VGND VGND VPWR VPWR sky130_fd_sc_hd__fill_1
XTAP_1541 VGND VPWR sky130_fd_sc_hd__tapvpwrvgnd_1
XTAP_1530 VGND VPWR sky130_fd_sc_hd__tapvpwrvgnd_1
XFILLER_0_113_27 VPWR VGND VPWR VGND sky130_ef_sc_hd__decap_12
XTAP_1585 VGND VPWR sky130_fd_sc_hd__tapvpwrvgnd_1
XTAP_1574 VGND VPWR sky130_fd_sc_hd__tapvpwrvgnd_1
XTAP_1563 VGND VPWR sky130_fd_sc_hd__tapvpwrvgnd_1
XTAP_1552 VGND VPWR sky130_fd_sc_hd__tapvpwrvgnd_1
XFILLER_0_95_172 VGND VGND VPWR VPWR sky130_fd_sc_hd__decap_3
XFILLER_0_68_386 VPWR VGND VPWR VGND sky130_ef_sc_hd__decap_12
XANTENNA__4713__A net72 VGND VGND VPWR VPWR sky130_fd_sc_hd__diode_2
XPHY_92 VGND VGND VPWR VPWR sky130_fd_sc_hd__decap_3
XPHY_70 VGND VGND VPWR VPWR sky130_fd_sc_hd__decap_3
XPHY_81 VGND VGND VPWR VPWR sky130_fd_sc_hd__decap_3
XTAP_1596 VGND VPWR sky130_fd_sc_hd__tapvpwrvgnd_1
XFILLER_0_83_345 VGND VGND VPWR VPWR sky130_fd_sc_hd__fill_2
XANTENNA__7183__RESET_B net73 VGND VGND VPWR VPWR sky130_fd_sc_hd__diode_2
XFILLER_0_98_29 VPWR VGND VPWR VGND sky130_ef_sc_hd__decap_12
XANTENNA__7112__RESET_B net76 VGND VGND VPWR VPWR sky130_fd_sc_hd__diode_2
XFILLER_0_106_160 VGND VGND VPWR VPWR sky130_fd_sc_hd__decap_6
X_4100_ u_pe_array.g_pe_row\[3\].g_pe_col\[1\].u_pe.psum_out\[12\] _1243_ VGND VGND
+ VPWR VPWR _1252_ sky130_fd_sc_hd__xor2_1
X_5080_ _2029_ _2058_ u_pe_array.g_pe_row\[1\].g_pe_col\[3\].u_pe.psum_out\[4\] VGND
+ VGND VPWR VPWR _2059_ sky130_fd_sc_hd__a21oi_1
X_4031_ u_pe_array.g_pe_row\[3\].g_pe_col\[1\].u_pe.psum_out\[5\] _1189_ VGND VGND
+ VPWR VPWR _1190_ sky130_fd_sc_hd__xnor2_2
XFILLER_0_37_9 VGND VGND VPWR VPWR sky130_fd_sc_hd__decap_8
XANTENNA__3835__A2 _0875_ VGND VGND VPWR VPWR sky130_fd_sc_hd__diode_2
XANTENNA__5037__B2 _1665_ VGND VGND VPWR VPWR sky130_fd_sc_hd__diode_2
XANTENNA__6785__A1 _3120_ VGND VGND VPWR VPWR sky130_fd_sc_hd__diode_2
XFILLER_0_78_128 VGND VGND VPWR VPWR sky130_fd_sc_hd__fill_1
X_5982_ _2791_ _2792_ _2804_ _2814_ VGND VGND VPWR VPWR _2817_ sky130_fd_sc_hd__or4_1
X_4933_ _1926_ _1928_ _1934_ VGND VGND VPWR VPWR _1935_ sky130_fd_sc_hd__o21ai_1
XFILLER_0_87_673 VGND VGND VPWR VPWR sky130_fd_sc_hd__fill_2
XFILLER_0_87_662 VGND VGND VPWR VPWR sky130_fd_sc_hd__fill_2
XFILLER_0_47_537 VGND VGND VPWR VPWR sky130_fd_sc_hd__fill_2
X_7652_ clknet_leaf_25_clk _0701_ VGND VGND VPWR VPWR u_pe_array.u_fifo1.buffer\[6\]\[10\]
+ sky130_fd_sc_hd__dfxtp_1
X_4864_ u_pe_array.g_pe_row\[2\].g_pe_col\[0\].u_pe.psum_out\[2\] _1858_ _1871_ VGND
+ VGND VPWR VPWR _1872_ sky130_fd_sc_hd__a21oi_1
XFILLER_0_86_194 VGND VGND VPWR VPWR sky130_fd_sc_hd__fill_2
XFILLER_0_74_345 VGND VGND VPWR VPWR sky130_fd_sc_hd__fill_2
XANTENNA__6537__A1 _1816_ VGND VGND VPWR VPWR sky130_fd_sc_hd__diode_2
X_7583_ clknet_leaf_27_clk _0632_ VGND VGND VPWR VPWR u_pe_array.u_fifo1.buffer\[1\]\[6\]
+ sky130_fd_sc_hd__dfxtp_1
X_4795_ _1821_ VGND VGND VPWR VPWR _0217_ sky130_fd_sc_hd__clkbuf_1
XFILLER_0_6_133 VGND VGND VPWR VPWR sky130_fd_sc_hd__decap_6
X_6603_ net590 _1798_ _3269_ VGND VGND VPWR VPWR _3271_ sky130_fd_sc_hd__mux2_1
X_3815_ u_pe_array.g_pe_row\[3\].g_pe_col\[2\].u_pe.act_val\[0\] u_pe_array.g_pe_row\[3\].g_pe_col\[2\].u_pe.w_reg\[0\]
+ u_pe_array.g_pe_row\[3\].g_pe_col\[2\].u_pe.psum_out\[0\] VGND VGND VPWR VPWR _1007_
+ sky130_fd_sc_hd__a21o_1
XFILLER_0_27_250 VGND VGND VPWR VPWR sky130_fd_sc_hd__fill_2
X_6534_ _3233_ VGND VGND VPWR VPWR _0544_ sky130_fd_sc_hd__clkbuf_1
XFILLER_0_6_177 VPWR VGND VPWR VGND sky130_ef_sc_hd__decap_12
X_3746_ net734 VGND VGND VPWR VPWR _0958_ sky130_fd_sc_hd__inv_2
XANTENNA__3771__A1 _0864_ VGND VGND VPWR VPWR sky130_fd_sc_hd__diode_2
X_6465_ net441 _1800_ _3194_ VGND VGND VPWR VPWR _3197_ sky130_fd_sc_hd__mux2_1
XFILLER_0_42_242 VGND VGND VPWR VPWR sky130_fd_sc_hd__fill_1
XFILLER_0_113_653 VPWR VGND VPWR VGND sky130_ef_sc_hd__decap_12
XFILLER_0_70_3 VPWR VGND VPWR VGND sky130_ef_sc_hd__decap_12
X_5416_ _2342_ VGND VGND VPWR VPWR _2343_ sky130_fd_sc_hd__inv_2
X_3677_ _0891_ _0893_ VGND VGND VPWR VPWR _0894_ sky130_fd_sc_hd__nand2_1
XFILLER_0_2_350 VPWR VGND VPWR VGND sky130_ef_sc_hd__decap_12
XFILLER_0_42_275 VGND VGND VPWR VPWR sky130_fd_sc_hd__fill_2
XANTENNA__6269__B _2992_ VGND VGND VPWR VPWR sky130_fd_sc_hd__diode_2
XFILLER_0_100_325 VGND VGND VPWR VPWR sky130_fd_sc_hd__fill_1
XFILLER_0_100_303 VGND VGND VPWR VPWR sky130_fd_sc_hd__fill_2
X_6396_ u_pe_array.u_fifo2.count\[2\] _3153_ _3157_ u_pe_array.u_fifo2.count\[0\]
+ VGND VGND VPWR VPWR _3158_ sky130_fd_sc_hd__o211ai_2
X_5347_ u_pe_array.u_fifo1.buffer\[5\]\[0\] _2284_ _2285_ u_pe_array.u_fifo1.buffer\[6\]\[0\]
+ _2286_ VGND VGND VPWR VPWR _2287_ sky130_fd_sc_hd__a221o_1
XFILLER_0_11_673 VGND VGND VPWR VPWR sky130_fd_sc_hd__decap_4
X_5278_ _2224_ _2225_ VGND VGND VPWR VPWR _2226_ sky130_fd_sc_hd__and2_1
XFILLER_0_10_183 VGND VGND VPWR VPWR sky130_fd_sc_hd__fill_1
X_7017_ clknet_leaf_31_clk _0094_ net817 VGND VGND VPWR VPWR u_pe_array.g_pe_row\[3\].g_pe_col\[0\].u_pe.w_buffer\[1\]
+ sky130_fd_sc_hd__dfrtp_1
X_4229_ _1347_ _1350_ _1355_ VGND VGND VPWR VPWR _1357_ sky130_fd_sc_hd__a21oi_1
XANTENNA__3702__A u_pe_array.g_pe_row\[3\].g_pe_col\[3\].u_pe.act_val\[5\] VGND VGND
+ VPWR VPWR sky130_fd_sc_hd__diode_2
XFILLER_0_78_662 VGND VGND VPWR VPWR sky130_fd_sc_hd__fill_2
XFILLER_0_93_610 VGND VGND VPWR VPWR sky130_fd_sc_hd__decap_4
XFILLER_0_38_548 VGND VGND VPWR VPWR sky130_fd_sc_hd__fill_2
XANTENNA__4252__B _1275_ VGND VGND VPWR VPWR sky130_fd_sc_hd__diode_2
XFILLER_0_18_250 VGND VGND VPWR VPWR sky130_fd_sc_hd__fill_2
XFILLER_0_18_272 VGND VGND VPWR VPWR sky130_fd_sc_hd__fill_2
XFILLER_0_33_220 VGND VGND VPWR VPWR sky130_fd_sc_hd__fill_2
XFILLER_0_104_620 VPWR VGND VPWR VGND sky130_ef_sc_hd__decap_12
XFILLER_0_21_437 VGND VGND VPWR VPWR sky130_fd_sc_hd__fill_2
XFILLER_0_103_163 VGND VGND VPWR VPWR sky130_fd_sc_hd__fill_2
XANTENNA__6894__S _3427_ VGND VGND VPWR VPWR sky130_fd_sc_hd__diode_2
XFILLER_0_108_27 VGND VGND VPWR VPWR sky130_fd_sc_hd__fill_1
XFILLER_0_69_673 VGND VGND VPWR VPWR sky130_fd_sc_hd__fill_2
XFILLER_0_69_662 VGND VGND VPWR VPWR sky130_fd_sc_hd__fill_2
XANTENNA__7364__RESET_B net75 VGND VGND VPWR VPWR sky130_fd_sc_hd__diode_2
XFILLER_0_8_409 VGND VGND VPWR VPWR sky130_fd_sc_hd__decap_8
XFILLER_0_33_57 VGND VGND VPWR VPWR sky130_fd_sc_hd__fill_1
XTAP_1393 VGND VPWR sky130_fd_sc_hd__tapvpwrvgnd_1
XTAP_1382 VGND VPWR sky130_fd_sc_hd__tapvpwrvgnd_1
XTAP_1371 VGND VPWR sky130_fd_sc_hd__tapvpwrvgnd_1
XTAP_1360 VGND VPWR sky130_fd_sc_hd__tapvpwrvgnd_1
XFILLER_0_83_175 VPWR VGND VPWR VGND sky130_ef_sc_hd__decap_12
XFILLER_0_83_164 VGND VGND VPWR VPWR sky130_fd_sc_hd__decap_4
XFILLER_0_114_417 VGND VGND VPWR VPWR sky130_fd_sc_hd__decap_3
X_3600_ _0832_ VGND VGND VPWR VPWR _0833_ sky130_fd_sc_hd__clkbuf_16
Xinput22 v_in1[1] VGND VGND VPWR VPWR net22 sky130_fd_sc_hd__buf_1
Xinput11 h_in1[4] VGND VGND VPWR VPWR net11 sky130_fd_sc_hd__buf_1
X_4580_ _1646_ _1647_ VGND VGND VPWR VPWR _1648_ sky130_fd_sc_hd__xnor2_1
XFILLER_0_37_592 VGND VGND VPWR VPWR sky130_fd_sc_hd__decap_3
XFILLER_0_114_439 VGND VGND VPWR VPWR sky130_fd_sc_hd__decap_8
Xinput33 w_in_flat[6] VGND VGND VPWR VPWR net33 sky130_fd_sc_hd__dlymetal6s2s_1
X_3531_ u_fsm.cnt\[2\] u_fsm.cnt\[1\] u_fsm.cnt\[0\] VGND VGND VPWR VPWR _0779_ sky130_fd_sc_hd__nand3_1
XFILLER_0_12_404 VPWR VGND VPWR VGND sky130_ef_sc_hd__decap_12
XFILLER_0_4_637 VGND VGND VPWR VPWR sky130_fd_sc_hd__decap_6
XFILLER_0_3_125 VPWR VGND VPWR VGND sky130_ef_sc_hd__decap_12
XFILLER_0_24_253 VGND VGND VPWR VPWR sky130_fd_sc_hd__fill_2
XFILLER_0_52_573 VGND VGND VPWR VPWR sky130_fd_sc_hd__decap_4
XFILLER_0_3_169 VPWR VGND VPWR VGND sky130_ef_sc_hd__decap_12
XFILLER_0_24_275 VGND VGND VPWR VPWR sky130_fd_sc_hd__fill_2
XFILLER_0_110_601 VPWR VGND VPWR VGND sky130_ef_sc_hd__decap_12
X_6250_ _3032_ _3033_ _3030_ VGND VGND VPWR VPWR _3043_ sky130_fd_sc_hd__o21ai_1
X_3462_ _0728_ _0735_ VGND VGND VPWR VPWR _0736_ sky130_fd_sc_hd__and2_1
XFILLER_0_110_645 VPWR VGND VPWR VGND sky130_ef_sc_hd__decap_12
X_6181_ u_pe_array.g_pe_row\[0\].g_pe_col\[1\].u_pe.psum_out\[12\] _2975_ VGND VGND
+ VPWR VPWR _2984_ sky130_fd_sc_hd__xor2_1
XFILLER_0_58_65 VPWR VGND VPWR VGND sky130_ef_sc_hd__decap_12
X_5201_ _2155_ VGND VGND VPWR VPWR _2156_ sky130_fd_sc_hd__inv_2
X_5132_ _2029_ u_pe_array.g_pe_row\[1\].g_pe_col\[3\].u_pe.psum_out\[7\] _2105_ _2106_
+ VGND VGND VPWR VPWR _2107_ sky130_fd_sc_hd__a22oi_1
X_5063_ _2042_ _2043_ VGND VGND VPWR VPWR _2044_ sky130_fd_sc_hd__xor2_1
X_4014_ _0864_ _1173_ _1174_ _1144_ net510 VGND VGND VPWR VPWR _0083_ sky130_fd_sc_hd__a32o_1
XANTENNA__6758__A1 _3120_ VGND VGND VPWR VPWR sky130_fd_sc_hd__diode_2
XFILLER_0_74_97 VGND VGND VPWR VPWR sky130_fd_sc_hd__fill_2
XFILLER_0_75_621 VGND VGND VPWR VPWR sky130_fd_sc_hd__decap_3
XFILLER_0_59_183 VGND VGND VPWR VPWR sky130_fd_sc_hd__decap_3
X_5965_ _2798_ _2799_ _2801_ VGND VGND VPWR VPWR _2802_ sky130_fd_sc_hd__and3_1
X_4916_ _1877_ _1886_ _1896_ _1918_ VGND VGND VPWR VPWR _1919_ sky130_fd_sc_hd__or4bb_1
XANTENNA__6044__S _2469_ VGND VGND VPWR VPWR sky130_fd_sc_hd__diode_2
XFILLER_0_90_85 VGND VGND VPWR VPWR sky130_fd_sc_hd__decap_4
XANTENNA__7034__RESET_B net816 VGND VGND VPWR VPWR sky130_fd_sc_hd__diode_2
X_5896_ net162 _2738_ _2739_ _0722_ VGND VGND VPWR VPWR _0400_ sky130_fd_sc_hd__a22o_1
X_7635_ clknet_leaf_26_clk _0684_ VGND VGND VPWR VPWR u_pe_array.u_fifo1.buffer\[5\]\[6\]
+ sky130_fd_sc_hd__dfxtp_1
X_4847_ u_pe_array.g_pe_row\[2\].g_pe_col\[0\].u_pe.act_val\[1\] _1847_ VGND VGND
+ VPWR VPWR _1856_ sky130_fd_sc_hd__and2b_1
XFILLER_0_74_175 VGND VGND VPWR VPWR sky130_fd_sc_hd__fill_1
XFILLER_0_62_304 VGND VGND VPWR VPWR sky130_fd_sc_hd__fill_2
XFILLER_0_47_389 VGND VGND VPWR VPWR sky130_fd_sc_hd__decap_3
XFILLER_0_28_570 VGND VGND VPWR VPWR sky130_fd_sc_hd__fill_2
XFILLER_0_105_417 VGND VGND VPWR VPWR sky130_fd_sc_hd__fill_2
XFILLER_0_15_220 VGND VGND VPWR VPWR sky130_fd_sc_hd__fill_2
XFILLER_0_90_668 VGND VGND VPWR VPWR sky130_fd_sc_hd__decap_6
X_7566_ clknet_leaf_16_clk _0615_ VGND VGND VPWR VPWR u_pe_array.u_fifo1.buffer\[0\]\[2\]
+ sky130_fd_sc_hd__dfxtp_1
X_4778_ _1787_ _0851_ _1000_ _0747_ VGND VGND VPWR VPWR _1810_ sky130_fd_sc_hd__a22o_2
XFILLER_0_43_540 VGND VGND VPWR VPWR sky130_fd_sc_hd__fill_2
XANTENNA__5733__A2 _2600_ VGND VGND VPWR VPWR sky130_fd_sc_hd__diode_2
XFILLER_0_43_595 VGND VGND VPWR VPWR sky130_fd_sc_hd__fill_2
X_7497_ clknet_leaf_2_clk _0546_ VGND VGND VPWR VPWR u_pe_array.u_fifo2.buffer\[4\]\[10\]
+ sky130_fd_sc_hd__dfxtp_1
X_3729_ _0940_ _0941_ VGND VGND VPWR VPWR _0942_ sky130_fd_sc_hd__and2_1
X_6517_ net454 _1788_ _3224_ VGND VGND VPWR VPWR _3225_ sky130_fd_sc_hd__mux2_1
XFILLER_0_113_461 VPWR VGND VPWR VGND sky130_ef_sc_hd__decap_12
X_6448_ net335 _1810_ _3180_ VGND VGND VPWR VPWR _3188_ sky130_fd_sc_hd__mux2_1
XFILLER_0_30_223 VGND VGND VPWR VPWR sky130_fd_sc_hd__decap_3
X_6379_ u_pe_array.u_fifo2.rd_ptr\[0\] _1960_ _3146_ VGND VGND VPWR VPWR _3147_ sky130_fd_sc_hd__o21ai_1
XFILLER_0_108_200 VGND VGND VPWR VPWR sky130_fd_sc_hd__fill_1
XFILLER_0_65_131 VGND VGND VPWR VPWR sky130_fd_sc_hd__fill_2
XFILLER_0_26_507 VGND VGND VPWR VPWR sky130_fd_sc_hd__fill_2
XFILLER_0_108_244 VGND VGND VPWR VPWR sky130_fd_sc_hd__fill_1
XFILLER_0_65_186 VGND VGND VPWR VPWR sky130_fd_sc_hd__decap_4
XFILLER_0_53_337 VGND VGND VPWR VPWR sky130_fd_sc_hd__decap_3
XFILLER_0_34_551 VGND VGND VPWR VPWR sky130_fd_sc_hd__fill_1
XFILLER_0_21_201 VGND VGND VPWR VPWR sky130_fd_sc_hd__fill_2
XFILLER_0_1_629 VPWR VGND VPWR VGND sky130_ef_sc_hd__decap_12
XTAP_418 VGND VPWR sky130_fd_sc_hd__tapvpwrvgnd_1
XTAP_407 VGND VPWR sky130_fd_sc_hd__tapvpwrvgnd_1
XTAP_429 VGND VPWR sky130_fd_sc_hd__tapvpwrvgnd_1
XANTENNA__4438__A _0832_ VGND VGND VPWR VPWR sky130_fd_sc_hd__diode_2
XANTENNA__5660__A1 _2258_ VGND VGND VPWR VPWR sky130_fd_sc_hd__diode_2
XANTENNA__7545__RESET_B net815 VGND VGND VPWR VPWR sky130_fd_sc_hd__diode_2
XANTENNA__6653__A _0788_ VGND VGND VPWR VPWR sky130_fd_sc_hd__diode_2
XFILLER_0_48_109 VGND VGND VPWR VPWR sky130_fd_sc_hd__fill_2
XFILLER_0_69_492 VGND VGND VPWR VPWR sky130_fd_sc_hd__fill_2
XFILLER_0_29_345 VGND VGND VPWR VPWR sky130_fd_sc_hd__fill_2
X_5750_ u_pe_array.g_pe_row\[0\].g_pe_col\[3\].u_pe.act_val\[0\] _2610_ _2611_ VGND
+ VGND VPWR VPWR _2619_ sky130_fd_sc_hd__a21bo_1
XANTENNA__6799__S _3366_ VGND VGND VPWR VPWR sky130_fd_sc_hd__diode_2
X_5681_ _0865_ VGND VGND VPWR VPWR _2571_ sky130_fd_sc_hd__buf_8
XTAP_1190 VGND VPWR sky130_fd_sc_hd__tapvpwrvgnd_1
X_4701_ _1734_ _1741_ VGND VGND VPWR VPWR _1745_ sky130_fd_sc_hd__nand2_1
XFILLER_0_17_518 VGND VGND VPWR VPWR sky130_fd_sc_hd__fill_2
X_7420_ clknet_leaf_30_clk _0469_ VGND VGND VPWR VPWR u_pe_array.u_fifo1.buffer\[8\]\[10\]
+ sky130_fd_sc_hd__dfxtp_1
X_4632_ u_pe_array.g_pe_row\[2\].g_pe_col\[1\].u_pe.w_reg\[0\] u_pe_array.g_pe_row\[2\].g_pe_col\[1\].u_pe.act_val\[2\]
+ VGND VGND VPWR VPWR _1682_ sky130_fd_sc_hd__nand2_1
XFILLER_0_71_134 VGND VGND VPWR VPWR sky130_fd_sc_hd__decap_4
XFILLER_0_60_77 VGND VGND VPWR VPWR sky130_fd_sc_hd__decap_6
XFILLER_0_56_197 VPWR VGND VPWR VGND sky130_ef_sc_hd__decap_12
XFILLER_0_56_175 VGND VGND VPWR VPWR sky130_fd_sc_hd__fill_2
XFILLER_0_114_225 VPWR VGND VPWR VGND sky130_ef_sc_hd__decap_12
XANTENNA__6912__A1 _3134_ VGND VGND VPWR VPWR sky130_fd_sc_hd__diode_2
XFILLER_0_44_359 VGND VGND VPWR VPWR sky130_fd_sc_hd__decap_3
Xhold603 u_pe_array.g_pe_row\[0\].g_pe_col\[0\].u_pe.psum_out\[9\] VGND VGND VPWR
+ VPWR net679 sky130_fd_sc_hd__dlygate4sd3_1
X_7351_ clknet_leaf_64_clk _0406_ net818 VGND VGND VPWR VPWR u_pe_array.g_pe_row\[0\].g_pe_col\[2\].u_pe.psum_out\[5\]
+ sky130_fd_sc_hd__dfrtp_1
XFILLER_0_4_445 VGND VGND VPWR VPWR sky130_fd_sc_hd__fill_2
X_4563_ net670 VGND VGND VPWR VPWR _1633_ sky130_fd_sc_hd__inv_2
Xhold636 u_pe_array.g_pe_row\[0\].g_pe_col\[0\].u_pe.psum_out\[6\] VGND VGND VPWR
+ VPWR net712 sky130_fd_sc_hd__dlygate4sd3_1
X_6302_ u_pe_array.g_pe_row\[0\].g_pe_col\[0\].u_pe.psum_out\[10\] _3089_ _3079_ VGND
+ VGND VPWR VPWR _3090_ sky130_fd_sc_hd__mux2_1
Xhold614 u_pe_array.g_pe_row\[3\].g_pe_col\[0\].u_pe.act_val\[0\] VGND VGND VPWR VPWR
+ net690 sky130_fd_sc_hd__dlygate4sd3_1
X_3514_ _0756_ VGND VGND VPWR VPWR _0770_ sky130_fd_sc_hd__buf_12
Xhold625 u_pe_array.g_pe_row\[1\].g_pe_col\[2\].u_pe.act_val\[3\] VGND VGND VPWR VPWR
+ net701 sky130_fd_sc_hd__dlygate4sd3_1
XFILLER_0_12_245 VGND VGND VPWR VPWR sky130_fd_sc_hd__decap_6
XFILLER_0_12_223 VGND VGND VPWR VPWR sky130_fd_sc_hd__decap_4
X_4494_ u_pe_array.g_pe_row\[2\].g_pe_col\[2\].u_pe.psum_out\[4\] _1568_ _1569_ VGND
+ VGND VPWR VPWR _1570_ sky130_fd_sc_hd__nand3_1
XFILLER_0_4_489 VPWR VGND VPWR VGND sky130_ef_sc_hd__decap_12
XANTENNA__4112__S _0769_ VGND VGND VPWR VPWR sky130_fd_sc_hd__diode_2
X_7282_ clknet_leaf_70_clk net294 net814 VGND VGND VPWR VPWR u_pe_array.g_pe_row\[0\].g_pe_col\[3\].u_pe.move_reg\[11\]
+ sky130_fd_sc_hd__dfrtp_1
X_6233_ u_pe_array.g_pe_row\[0\].g_pe_col\[0\].u_pe.act_val\[4\] u_pe_array.g_pe_row\[0\].g_pe_col\[0\].u_pe.w_reg\[0\]
+ _3024_ _3025_ VGND VGND VPWR VPWR _3027_ sky130_fd_sc_hd__o2bb2a_1
Xhold669 u_pe_array.g_pe_row\[0\].g_pe_col\[1\].u_pe.psum_out\[3\] VGND VGND VPWR
+ VPWR net745 sky130_fd_sc_hd__dlygate4sd3_1
XFILLER_0_100_83 VGND VGND VPWR VPWR sky130_fd_sc_hd__fill_1
X_3445_ _0720_ VGND VGND VPWR VPWR _0721_ sky130_fd_sc_hd__inv_2
Xhold647 u_pe_array.g_pe_row\[2\].g_pe_col\[1\].u_pe.psum_out\[8\] VGND VGND VPWR
+ VPWR net723 sky130_fd_sc_hd__dlygate4sd3_1
Xhold658 u_pe_array.g_pe_row\[3\].g_pe_col\[3\].u_pe.psum_out\[8\] VGND VGND VPWR
+ VPWR net734 sky130_fd_sc_hd__dlygate4sd3_1
XFILLER_0_110_475 VGND VGND VPWR VPWR sky130_fd_sc_hd__fill_1
XFILLER_0_100_94 VGND VGND VPWR VPWR sky130_fd_sc_hd__decap_3
XANTENNA__3951__S _0755_ VGND VGND VPWR VPWR sky130_fd_sc_hd__diode_2
XFILLER_0_0_673 VGND VGND VPWR VPWR sky130_fd_sc_hd__decap_4
X_6164_ _2967_ _2968_ _2957_ VGND VGND VPWR VPWR _2969_ sky130_fd_sc_hd__a21oi_1
XTAP_952 VGND VPWR sky130_fd_sc_hd__tapvpwrvgnd_1
XTAP_941 VGND VPWR sky130_fd_sc_hd__tapvpwrvgnd_1
XTAP_930 VGND VPWR sky130_fd_sc_hd__tapvpwrvgnd_1
X_6095_ u_pe_array.g_pe_row\[0\].g_pe_col\[1\].u_pe.w_reg\[0\] _2873_ _2904_ u_pe_array.g_pe_row\[0\].g_pe_col\[1\].u_pe.act_val\[4\]
+ VGND VGND VPWR VPWR _2906_ sky130_fd_sc_hd__nand4_1
XFILLER_0_85_85 VGND VGND VPWR VPWR sky130_fd_sc_hd__fill_1
XTAP_996 VGND VPWR sky130_fd_sc_hd__tapvpwrvgnd_1
XTAP_985 VGND VPWR sky130_fd_sc_hd__tapvpwrvgnd_1
XTAP_974 VGND VPWR sky130_fd_sc_hd__tapvpwrvgnd_1
XTAP_963 VGND VPWR sky130_fd_sc_hd__tapvpwrvgnd_1
X_5115_ _2077_ _2090_ _2083_ VGND VGND VPWR VPWR _2092_ sky130_fd_sc_hd__nor3_1
X_5046_ _1725_ _2027_ _2028_ _1534_ net408 VGND VGND VPWR VPWR _0261_ sky130_fd_sc_hd__a32o_1
XFILLER_0_33_3 VPWR VGND VPWR VGND sky130_ef_sc_hd__decap_12
XANTENNA__5878__S _0770_ VGND VGND VPWR VPWR sky130_fd_sc_hd__diode_2
XANTENNA__7286__RESET_B net813 VGND VGND VPWR VPWR sky130_fd_sc_hd__diode_2
XANTENNA__4782__S _1796_ VGND VGND VPWR VPWR sky130_fd_sc_hd__diode_2
XANTENNA__7215__RESET_B net75 VGND VGND VPWR VPWR sky130_fd_sc_hd__diode_2
XANTENNA__6282__B _2992_ VGND VGND VPWR VPWR sky130_fd_sc_hd__diode_2
X_6997_ clknet_leaf_33_clk _0076_ net817 VGND VGND VPWR VPWR u_pe_array.g_pe_row\[3\].g_pe_col\[0\].u_pe.move_reg\[9\]
+ sky130_fd_sc_hd__dfrtp_1
XFILLER_0_94_259 VGND VGND VPWR VPWR sky130_fd_sc_hd__decap_4
XFILLER_0_94_248 VGND VGND VPWR VPWR sky130_fd_sc_hd__fill_2
XANTENNA__4083__A _1145_ VGND VGND VPWR VPWR sky130_fd_sc_hd__diode_2
X_5948_ _2740_ _2785_ _2786_ _2571_ net395 VGND VGND VPWR VPWR _0405_ sky130_fd_sc_hd__a32o_1
XFILLER_0_48_676 VGND VGND VPWR VPWR sky130_fd_sc_hd__fill_1
X_5879_ net719 _2600_ _2592_ _2730_ VGND VGND VPWR VPWR _0392_ sky130_fd_sc_hd__a22o_1
XFILLER_0_35_337 VGND VGND VPWR VPWR sky130_fd_sc_hd__fill_2
XFILLER_0_105_225 VGND VGND VPWR VPWR sky130_fd_sc_hd__fill_1
X_7618_ clknet_leaf_21_clk _0667_ VGND VGND VPWR VPWR u_pe_array.u_fifo1.buffer\[4\]\[2\]
+ sky130_fd_sc_hd__dfxtp_1
XFILLER_0_62_145 VGND VGND VPWR VPWR sky130_fd_sc_hd__decap_8
XFILLER_0_50_307 VGND VGND VPWR VPWR sky130_fd_sc_hd__fill_1
XANTENNA__6502__S _3208_ VGND VGND VPWR VPWR sky130_fd_sc_hd__diode_2
XANTENNA__5167__B1 _0887_ VGND VGND VPWR VPWR sky130_fd_sc_hd__diode_2
XANTENNA__4914__B1 _1534_ VGND VGND VPWR VPWR sky130_fd_sc_hd__diode_2
XFILLER_0_16_584 VGND VGND VPWR VPWR sky130_fd_sc_hd__decap_4
X_7549_ clknet_leaf_80_clk _0598_ net815 VGND VGND VPWR VPWR u_pe_array.g_pe_row\[3\].g_pe_col\[3\].u_pe.move_reg\[10\]
+ sky130_fd_sc_hd__dfrtp_1
XFILLER_0_31_554 VGND VGND VPWR VPWR sky130_fd_sc_hd__decap_6
XFILLER_0_113_291 VPWR VGND VPWR VGND sky130_ef_sc_hd__decap_12
XFILLER_0_101_420 VGND VGND VPWR VPWR sky130_fd_sc_hd__fill_1
XANTENNA__6667__B1 _0787_ VGND VGND VPWR VPWR sky130_fd_sc_hd__diode_2
XANTENNA_input17_A v_in0[2] VGND VGND VPWR VPWR sky130_fd_sc_hd__diode_2
XFILLER_0_105_39 VPWR VGND VPWR VGND sky130_ef_sc_hd__decap_12
XFILLER_0_98_587 VGND VGND VPWR VPWR sky130_fd_sc_hd__fill_1
XFILLER_0_14_26 VGND VGND VPWR VPWR sky130_fd_sc_hd__fill_2
XFILLER_0_39_621 VGND VGND VPWR VPWR sky130_fd_sc_hd__fill_2
XFILLER_0_85_248 VGND VGND VPWR VPWR sky130_fd_sc_hd__fill_1
XFILLER_0_66_440 VGND VGND VPWR VPWR sky130_fd_sc_hd__decap_4
XFILLER_0_66_462 VGND VGND VPWR VPWR sky130_fd_sc_hd__fill_2
XANTENNA__6938__RESET_B net74 VGND VGND VPWR VPWR sky130_fd_sc_hd__diode_2
XFILLER_0_66_484 VGND VGND VPWR VPWR sky130_fd_sc_hd__decap_4
XFILLER_0_26_337 VGND VGND VPWR VPWR sky130_fd_sc_hd__fill_1
XFILLER_0_109_597 VPWR VGND VPWR VGND sky130_ef_sc_hd__decap_12
XFILLER_0_53_167 VGND VGND VPWR VPWR sky130_fd_sc_hd__fill_1
XFILLER_0_34_381 VGND VGND VPWR VPWR sky130_fd_sc_hd__fill_2
XFILLER_0_34_392 VGND VGND VPWR VPWR sky130_fd_sc_hd__fill_2
XFILLER_0_22_576 VGND VGND VPWR VPWR sky130_fd_sc_hd__fill_2
XTAP_237 VGND VPWR sky130_fd_sc_hd__tapvpwrvgnd_1
XTAP_248 VGND VPWR sky130_fd_sc_hd__tapvpwrvgnd_1
XANTENNA__4133__B2 _1004_ VGND VGND VPWR VPWR sky130_fd_sc_hd__diode_2
XFILLER_0_39_89 VGND VGND VPWR VPWR sky130_fd_sc_hd__decap_3
XTAP_259 VGND VPWR sky130_fd_sc_hd__tapvpwrvgnd_1
XFILLER_0_55_66 VGND VGND VPWR VPWR sky130_fd_sc_hd__decap_6
XFILLER_0_55_55 VGND VGND VPWR VPWR sky130_fd_sc_hd__fill_1
XFILLER_0_55_88 VGND VGND VPWR VPWR sky130_fd_sc_hd__decap_8
X_6920_ clknet_leaf_82_clk _0006_ net73 VGND VGND VPWR VPWR u_fsm.v_cnt\[0\] sky130_fd_sc_hd__dfrtp_1
X_6851_ _3407_ VGND VGND VPWR VPWR _0687_ sky130_fd_sc_hd__clkbuf_1
XANTENNA__4107__S _0769_ VGND VGND VPWR VPWR sky130_fd_sc_hd__diode_2
X_5802_ _2611_ _2665_ u_pe_array.g_pe_row\[0\].g_pe_col\[3\].u_pe.psum_out\[6\] VGND
+ VGND VPWR VPWR _2667_ sky130_fd_sc_hd__a21oi_1
XFILLER_0_91_207 VGND VGND VPWR VPWR sky130_fd_sc_hd__fill_2
X_6782_ _3370_ VGND VGND VPWR VPWR _0655_ sky130_fd_sc_hd__clkbuf_1
X_3994_ _1153_ _1155_ VGND VGND VPWR VPWR _1156_ sky130_fd_sc_hd__xnor2_2
XANTENNA__5936__A2 _2743_ VGND VGND VPWR VPWR sky130_fd_sc_hd__diode_2
XFILLER_0_9_559 VGND VGND VPWR VPWR sky130_fd_sc_hd__fill_1
XFILLER_0_17_304 VGND VGND VPWR VPWR sky130_fd_sc_hd__decap_3
XANTENNA__3946__S _0819_ VGND VGND VPWR VPWR sky130_fd_sc_hd__diode_2
XFILLER_0_91_229 VGND VGND VPWR VPWR sky130_fd_sc_hd__fill_2
XFILLER_0_72_432 VGND VGND VPWR VPWR sky130_fd_sc_hd__decap_3
XFILLER_0_45_646 VGND VGND VPWR VPWR sky130_fd_sc_hd__decap_3
XFILLER_0_17_337 VGND VGND VPWR VPWR sky130_fd_sc_hd__fill_1
X_5733_ net185 _2600_ _2605_ _2336_ VGND VGND VPWR VPWR _0371_ sky130_fd_sc_hd__a22o_1
XFILLER_0_72_443 VGND VGND VPWR VPWR sky130_fd_sc_hd__fill_2
X_5664_ _2527_ _2539_ _2549_ _2554_ VGND VGND VPWR VPWR _2555_ sky130_fd_sc_hd__or4_1
X_7403_ clknet_leaf_45_clk _0453_ net817 VGND VGND VPWR VPWR u_pe_array.g_pe_row\[0\].g_pe_col\[0\].u_pe.psum_out\[7\]
+ sky130_fd_sc_hd__dfrtp_4
X_4615_ net182 _1666_ _1667_ _1665_ VGND VGND VPWR VPWR _0191_ sky130_fd_sc_hd__a22o_1
X_5595_ _2481_ _2484_ VGND VGND VPWR VPWR _2492_ sky130_fd_sc_hd__and2_1
XFILLER_0_25_370 VGND VGND VPWR VPWR sky130_fd_sc_hd__fill_2
XFILLER_0_102_206 VGND VGND VPWR VPWR sky130_fd_sc_hd__decap_3
Xhold411 u_pe_array.u_fifo1.buffer\[7\]\[1\] VGND VGND VPWR VPWR net487 sky130_fd_sc_hd__dlygate4sd3_1
X_7334_ clknet_leaf_48_clk _0391_ net812 VGND VGND VPWR VPWR u_pe_array.g_pe_row\[0\].g_pe_col\[1\].u_pe.act_val\[3\]
+ sky130_fd_sc_hd__dfrtp_2
Xhold400 u_pe_array.g_pe_row\[2\].g_pe_col\[1\].u_pe.psum_out\[1\] VGND VGND VPWR
+ VPWR net476 sky130_fd_sc_hd__dlygate4sd3_1
XFILLER_0_4_253 VGND VGND VPWR VPWR sky130_fd_sc_hd__fill_2
X_4546_ _1608_ _1611_ _1616_ VGND VGND VPWR VPWR _1618_ sky130_fd_sc_hd__a21oi_1
Xhold433 u_pe_array.g_pe_row\[1\].g_pe_col\[2\].u_pe.act_val\[4\] VGND VGND VPWR VPWR
+ net509 sky130_fd_sc_hd__dlygate4sd3_1
Xhold422 u_pe_array.u_fifo2.buffer\[4\]\[5\] VGND VGND VPWR VPWR net498 sky130_fd_sc_hd__dlygate4sd3_1
Xhold444 u_pe_array.u_fifo2.buffer\[3\]\[0\] VGND VGND VPWR VPWR net520 sky130_fd_sc_hd__dlygate4sd3_1
Xhold455 u_pe_array.u_fifo1.buffer\[3\]\[0\] VGND VGND VPWR VPWR net531 sky130_fd_sc_hd__dlygate4sd3_1
X_7265_ clknet_leaf_50_clk _0326_ net812 VGND VGND VPWR VPWR u_pe_array.g_pe_row\[1\].g_pe_col\[1\].u_pe.psum_out\[9\]
+ sky130_fd_sc_hd__dfrtp_2
X_4477_ u_pe_array.g_pe_row\[2\].g_pe_col\[2\].u_pe.act_val\[2\] VGND VGND VPWR VPWR
+ _1554_ sky130_fd_sc_hd__inv_2
Xhold466 u_pe_array.g_pe_row\[2\].g_pe_col\[3\].u_pe.psum_out\[9\] VGND VGND VPWR
+ VPWR net542 sky130_fd_sc_hd__dlygate4sd3_1
Xhold477 u_pe_array.u_fifo2.buffer\[6\]\[5\] VGND VGND VPWR VPWR net553 sky130_fd_sc_hd__dlygate4sd3_1
X_6216_ u_pe_array.g_pe_row\[0\].g_pe_col\[0\].u_pe.act_val\[2\] u_pe_array.g_pe_row\[0\].g_pe_col\[0\].u_pe.w_reg\[0\]
+ _3001_ VGND VGND VPWR VPWR _3011_ sky130_fd_sc_hd__and3_1
Xhold499 u_pe_array.g_pe_row\[0\].g_pe_col\[0\].u_pe.psum_out\[1\] VGND VGND VPWR
+ VPWR net575 sky130_fd_sc_hd__dlygate4sd3_1
XANTENNA__5321__B1 _2071_ VGND VGND VPWR VPWR sky130_fd_sc_hd__diode_2
X_7196_ clknet_leaf_79_clk _0261_ net815 VGND VGND VPWR VPWR u_pe_array.g_pe_row\[1\].g_pe_col\[3\].u_pe.psum_out\[0\]
+ sky130_fd_sc_hd__dfrtp_1
Xhold488 u_pe_array.u_fifo2.buffer\[7\]\[5\] VGND VGND VPWR VPWR net564 sky130_fd_sc_hd__dlygate4sd3_1
X_6147_ _2945_ _2948_ _2953_ VGND VGND VPWR VPWR _2954_ sky130_fd_sc_hd__and3_1
XTAP_760 VGND VPWR sky130_fd_sc_hd__tapvpwrvgnd_1
XANTENNA_input9_A h_in1[2] VGND VGND VPWR VPWR sky130_fd_sc_hd__diode_2
XFILLER_0_99_318 VPWR VGND VPWR VGND sky130_ef_sc_hd__decap_12
XFILLER_0_99_307 VGND VGND VPWR VPWR sky130_fd_sc_hd__fill_2
XTAP_793 VGND VPWR sky130_fd_sc_hd__tapvpwrvgnd_1
XTAP_782 VGND VPWR sky130_fd_sc_hd__tapvpwrvgnd_1
XTAP_771 VGND VPWR sky130_fd_sc_hd__tapvpwrvgnd_1
X_6078_ _2880_ _2886_ _2889_ VGND VGND VPWR VPWR _2890_ sky130_fd_sc_hd__a21o_1
XANTENNA__4427__A2 _1392_ VGND VGND VPWR VPWR sky130_fd_sc_hd__diode_2
XANTENNA__5401__S _1661_ VGND VGND VPWR VPWR sky130_fd_sc_hd__diode_2
X_5029_ _0836_ _2017_ _2019_ _0833_ net676 VGND VGND VPWR VPWR _0253_ sky130_fd_sc_hd__a32o_1
XFILLER_0_67_215 VGND VGND VPWR VPWR sky130_fd_sc_hd__fill_2
XFILLER_0_75_281 VGND VGND VPWR VPWR sky130_fd_sc_hd__fill_1
XFILLER_0_36_624 VGND VGND VPWR VPWR sky130_fd_sc_hd__decap_3
XFILLER_0_8_581 VGND VGND VPWR VPWR sky130_fd_sc_hd__decap_6
XANTENNA__4541__A _1536_ VGND VGND VPWR VPWR sky130_fd_sc_hd__diode_2
XFILLER_0_90_284 VGND VGND VPWR VPWR sky130_fd_sc_hd__fill_2
XFILLER_0_63_487 VGND VGND VPWR VPWR sky130_fd_sc_hd__fill_2
XFILLER_0_35_167 VGND VGND VPWR VPWR sky130_fd_sc_hd__fill_1
XFILLER_0_106_589 VPWR VGND VPWR VGND sky130_ef_sc_hd__decap_12
XFILLER_0_106_578 VGND VGND VPWR VPWR sky130_fd_sc_hd__decap_8
XANTENNA__5312__B1 _0885_ VGND VGND VPWR VPWR sky130_fd_sc_hd__diode_2
XFILLER_0_98_351 VPWR VGND VPWR VGND sky130_ef_sc_hd__decap_12
XANTENNA__4716__A _1672_ VGND VGND VPWR VPWR sky130_fd_sc_hd__diode_2
XFILLER_0_98_373 VGND VGND VPWR VPWR sky130_fd_sc_hd__decap_8
XFILLER_0_86_579 VGND VGND VPWR VPWR sky130_fd_sc_hd__fill_2
XFILLER_0_73_218 VGND VGND VPWR VPWR sky130_fd_sc_hd__fill_2
XANTENNA__5918__A2 _2387_ VGND VGND VPWR VPWR sky130_fd_sc_hd__diode_2
XFILLER_0_54_421 VGND VGND VPWR VPWR sky130_fd_sc_hd__fill_2
XFILLER_0_39_484 VGND VGND VPWR VPWR sky130_fd_sc_hd__fill_2
XFILLER_0_41_57 VGND VGND VPWR VPWR sky130_fd_sc_hd__fill_2
XFILLER_0_81_273 VGND VGND VPWR VPWR sky130_fd_sc_hd__fill_2
XFILLER_0_81_251 VGND VGND VPWR VPWR sky130_fd_sc_hd__fill_1
XFILLER_0_14_329 VGND VGND VPWR VPWR sky130_fd_sc_hd__fill_1
X_4400_ _1407_ u_pe_array.g_pe_row\[2\].g_pe_col\[3\].u_pe.psum_out\[10\] VGND VGND
+ VPWR VPWR _1498_ sky130_fd_sc_hd__or2_1
X_5380_ _0836_ _2314_ _2316_ _0833_ net547 VGND VGND VPWR VPWR _0307_ sky130_fd_sc_hd__a32o_1
XFILLER_0_1_223 VGND VGND VPWR VPWR sky130_fd_sc_hd__fill_1
XFILLER_0_22_362 VGND VGND VPWR VPWR sky130_fd_sc_hd__fill_2
XFILLER_0_41_159 VGND VGND VPWR VPWR sky130_fd_sc_hd__decap_3
XANTENNA__4597__S _0770_ VGND VGND VPWR VPWR sky130_fd_sc_hd__diode_2
XFILLER_0_10_513 VPWR VGND VPWR VGND sky130_ef_sc_hd__decap_12
X_4331_ _1273_ _1434_ _1435_ _1144_ net497 VGND VGND VPWR VPWR _0139_ sky130_fd_sc_hd__a32o_1
XFILLER_0_22_373 VGND VGND VPWR VPWR sky130_fd_sc_hd__fill_2
X_4262_ u_pe_array.g_pe_row\[3\].g_pe_col\[0\].u_pe.psum_out\[12\] _1377_ VGND VGND
+ VPWR VPWR _1386_ sky130_fd_sc_hd__xor2_1
XFILLER_0_10_557 VPWR VGND VPWR VGND sky130_ef_sc_hd__decap_12
X_7050_ clknet_leaf_91_clk _0125_ net819 VGND VGND VPWR VPWR u_pe_array.g_pe_row\[2\].g_pe_col\[2\].u_pe.act_val\[2\]
+ sky130_fd_sc_hd__dfrtp_2
XANTENNA__7560__RESET_B net816 VGND VGND VPWR VPWR sky130_fd_sc_hd__diode_2
X_6001_ _2825_ _2828_ _2833_ VGND VGND VPWR VPWR _2835_ sky130_fd_sc_hd__or3_1
XFILLER_0_5_57 VPWR VGND VPWR VGND sky130_ef_sc_hd__decap_12
X_4193_ _1322_ _1323_ VGND VGND VPWR VPWR _1324_ sky130_fd_sc_hd__and2b_1
XFILLER_0_66_65 VPWR VGND VPWR VGND sky130_ef_sc_hd__decap_12
XANTENNA__3865__B1 _0867_ VGND VGND VPWR VPWR sky130_fd_sc_hd__diode_2
X_6903_ _3435_ VGND VGND VPWR VPWR _0711_ sky130_fd_sc_hd__clkbuf_1
XFILLER_0_89_384 VGND VGND VPWR VPWR sky130_fd_sc_hd__decap_6
XFILLER_0_89_373 VGND VGND VPWR VPWR sky130_fd_sc_hd__decap_4
XFILLER_0_82_53 VGND VGND VPWR VPWR sky130_fd_sc_hd__decap_4
XFILLER_0_77_535 VGND VGND VPWR VPWR sky130_fd_sc_hd__fill_2
X_6834_ net469 _3112_ _3397_ VGND VGND VPWR VPWR _3399_ sky130_fd_sc_hd__mux2_1
XFILLER_0_49_259 VGND VGND VPWR VPWR sky130_fd_sc_hd__fill_1
XFILLER_0_107_309 VGND VGND VPWR VPWR sky130_fd_sc_hd__fill_2
X_6765_ _3361_ VGND VGND VPWR VPWR _0647_ sky130_fd_sc_hd__clkbuf_1
X_3977_ net114 _1138_ _1141_ _1004_ VGND VGND VPWR VPWR _0079_ sky130_fd_sc_hd__a22o_1
XFILLER_0_57_281 VGND VGND VPWR VPWR sky130_fd_sc_hd__decap_4
XANTENNA__6052__S _0729_ VGND VGND VPWR VPWR sky130_fd_sc_hd__diode_2
XFILLER_0_18_657 VPWR VGND VPWR VGND sky130_ef_sc_hd__decap_12
X_5716_ net788 _2463_ _2592_ _2596_ VGND VGND VPWR VPWR _0363_ sky130_fd_sc_hd__a22o_1
X_6696_ net506 _3112_ _3324_ VGND VGND VPWR VPWR _3326_ sky130_fd_sc_hd__mux2_1
XFILLER_0_45_498 VGND VGND VPWR VPWR sky130_fd_sc_hd__fill_2
XFILLER_0_17_167 VGND VGND VPWR VPWR sky130_fd_sc_hd__fill_1
XFILLER_0_33_638 VGND VGND VPWR VPWR sky130_fd_sc_hd__fill_2
X_5647_ _2526_ _2529_ _2527_ VGND VGND VPWR VPWR _2540_ sky130_fd_sc_hd__o21ba_1
XFILLER_0_60_446 VGND VGND VPWR VPWR sky130_fd_sc_hd__decap_6
XFILLER_0_5_573 VPWR VGND VPWR VGND sky130_ef_sc_hd__decap_12
XANTENNA__4345__A1 _1273_ VGND VGND VPWR VPWR sky130_fd_sc_hd__diode_2
X_5578_ u_pe_array.g_pe_row\[1\].g_pe_col\[0\].u_pe.act_val\[0\] u_pe_array.g_pe_row\[1\].g_pe_col\[0\].u_pe.psum_out\[0\]
+ u_pe_array.g_pe_row\[1\].g_pe_col\[0\].u_pe.w_reg\[0\] VGND VGND VPWR VPWR _2477_
+ sky130_fd_sc_hd__nand3_1
Xhold230 u_pe_array.u_fifo1.buffer\[7\]\[8\] VGND VGND VPWR VPWR net306 sky130_fd_sc_hd__dlygate4sd3_1
XANTENNA__4896__A2 _1847_ VGND VGND VPWR VPWR sky130_fd_sc_hd__diode_2
Xhold252 u_pe_array.u_fifo2.buffer\[4\]\[8\] VGND VGND VPWR VPWR net328 sky130_fd_sc_hd__dlygate4sd3_1
X_4529_ _1536_ u_pe_array.g_pe_row\[2\].g_pe_col\[2\].u_pe.psum_out\[7\] VGND VGND
+ VPWR VPWR _1602_ sky130_fd_sc_hd__xor2_1
X_7317_ clknet_leaf_79_clk _0374_ net814 VGND VGND VPWR VPWR u_pe_array.g_pe_row\[0\].g_pe_col\[3\].u_pe.psum_out\[1\]
+ sky130_fd_sc_hd__dfrtp_1
Xhold241 u_pe_array.g_pe_row\[0\].g_pe_col\[3\].u_pe.psum_out\[11\] VGND VGND VPWR
+ VPWR net317 sky130_fd_sc_hd__dlygate4sd3_1
XFILLER_0_40_170 VGND VGND VPWR VPWR sky130_fd_sc_hd__fill_1
Xhold285 u_pe_array.u_fifo1.buffer\[1\]\[10\] VGND VGND VPWR VPWR net361 sky130_fd_sc_hd__dlygate4sd3_1
X_7248_ clknet_leaf_56_clk net127 net75 VGND VGND VPWR VPWR u_pe_array.g_pe_row\[1\].g_pe_col\[0\].u_pe.move_reg\[7\]
+ sky130_fd_sc_hd__dfrtp_1
Xhold296 u_pe_array.g_pe_row\[2\].g_pe_col\[1\].u_pe.psum_out\[0\] VGND VGND VPWR
+ VPWR net372 sky130_fd_sc_hd__dlygate4sd3_1
Xhold263 u_pe_array.u_fifo1.buffer\[8\]\[11\] VGND VGND VPWR VPWR net339 sky130_fd_sc_hd__dlygate4sd3_1
Xhold274 u_pe_array.u_fifo2.buffer\[7\]\[10\] VGND VGND VPWR VPWR net350 sky130_fd_sc_hd__dlygate4sd3_1
XANTENNA__7230__RESET_B net813 VGND VGND VPWR VPWR sky130_fd_sc_hd__diode_2
X_7179_ clknet_leaf_75_clk _0246_ net815 VGND VGND VPWR VPWR u_pe_array.g_pe_row\[1\].g_pe_col\[3\].u_pe.w_buffer\[0\]
+ sky130_fd_sc_hd__dfrtp_1
XTAP_590 VGND VPWR sky130_fd_sc_hd__tapvpwrvgnd_1
XFILLER_0_99_159 VGND VGND VPWR VPWR sky130_fd_sc_hd__decap_3
XANTENNA__4281__B1 _1258_ VGND VGND VPWR VPWR sky130_fd_sc_hd__diode_2
XFILLER_0_95_365 VPWR VGND VPWR VGND sky130_ef_sc_hd__decap_12
Xclkbuf_leaf_80_clk clknet_3_4__leaf_clk VGND VGND VPWR VPWR clknet_leaf_80_clk sky130_fd_sc_hd__clkbuf_16
XFILLER_0_48_281 VGND VGND VPWR VPWR sky130_fd_sc_hd__decap_3
XFILLER_0_102_29 VPWR VGND VPWR VGND sky130_ef_sc_hd__decap_12
XFILLER_0_24_605 VGND VGND VPWR VPWR sky130_fd_sc_hd__fill_2
XFILLER_0_24_627 VGND VGND VPWR VPWR sky130_fd_sc_hd__fill_2
XANTENNA__7389__RESET_B net817 VGND VGND VPWR VPWR sky130_fd_sc_hd__diode_2
XFILLER_0_32_671 VGND VGND VPWR VPWR sky130_fd_sc_hd__fill_2
XFILLER_0_31_181 VGND VGND VPWR VPWR sky130_fd_sc_hd__decap_4
XANTENNA__7318__RESET_B net814 VGND VGND VPWR VPWR sky130_fd_sc_hd__diode_2
XANTENNA__6645__B _0833_ VGND VGND VPWR VPWR sky130_fd_sc_hd__diode_2
XFILLER_0_36_79 VGND VGND VPWR VPWR sky130_fd_sc_hd__decap_4
Xinput9 h_in1[2] VGND VGND VPWR VPWR net9 sky130_fd_sc_hd__buf_1
XANTENNA__5064__A2 _1714_ VGND VGND VPWR VPWR sky130_fd_sc_hd__diode_2
XANTENNA__6953__RESET_B net815 VGND VGND VPWR VPWR sky130_fd_sc_hd__diode_2
XFILLER_0_59_557 VGND VGND VPWR VPWR sky130_fd_sc_hd__decap_3
XANTENNA__4272__B1 _1258_ VGND VGND VPWR VPWR sky130_fd_sc_hd__diode_2
XANTENNA__4811__A2 _1666_ VGND VGND VPWR VPWR sky130_fd_sc_hd__diode_2
X_4880_ _1877_ _1886_ VGND VGND VPWR VPWR _1887_ sky130_fd_sc_hd__nor2_1
XFILLER_0_86_354 VGND VGND VPWR VPWR sky130_fd_sc_hd__fill_2
XFILLER_0_46_207 VGND VGND VPWR VPWR sky130_fd_sc_hd__fill_2
X_3900_ _1049_ _1050_ _1083_ VGND VGND VPWR VPWR _1084_ sky130_fd_sc_hd__or3_1
Xclkbuf_leaf_71_clk clknet_3_5__leaf_clk VGND VGND VPWR VPWR clknet_leaf_71_clk sky130_fd_sc_hd__clkbuf_16
XFILLER_0_74_527 VGND VGND VPWR VPWR sky130_fd_sc_hd__fill_2
XFILLER_0_27_421 VGND VGND VPWR VPWR sky130_fd_sc_hd__fill_2
X_3831_ _1020_ u_pe_array.g_pe_row\[3\].g_pe_col\[2\].u_pe.psum_out\[1\] _1009_ VGND
+ VGND VPWR VPWR _1021_ sky130_fd_sc_hd__o21a_1
XFILLER_0_54_240 VGND VGND VPWR VPWR sky130_fd_sc_hd__decap_3
X_3762_ _0966_ _0971_ VGND VGND VPWR VPWR _0972_ sky130_fd_sc_hd__and2_1
X_6550_ _3242_ VGND VGND VPWR VPWR _0551_ sky130_fd_sc_hd__clkbuf_1
XFILLER_0_39_281 VGND VGND VPWR VPWR sky130_fd_sc_hd__fill_2
X_5501_ _2406_ _2407_ _2413_ _2401_ _2419_ VGND VGND VPWR VPWR _2420_ sky130_fd_sc_hd__a32o_1
XFILLER_0_54_262 VGND VGND VPWR VPWR sky130_fd_sc_hd__fill_1
XFILLER_0_15_605 VGND VGND VPWR VPWR sky130_fd_sc_hd__decap_6
XFILLER_0_27_465 VGND VGND VPWR VPWR sky130_fd_sc_hd__fill_1
X_3693_ _0906_ _0907_ _0908_ VGND VGND VPWR VPWR _0909_ sky130_fd_sc_hd__and3_1
XFILLER_0_14_137 VGND VGND VPWR VPWR sky130_fd_sc_hd__decap_3
X_6481_ net343 _1816_ net67 VGND VGND VPWR VPWR _3205_ sky130_fd_sc_hd__mux2_1
XFILLER_0_42_446 VGND VGND VPWR VPWR sky130_fd_sc_hd__fill_2
XFILLER_0_112_301 VGND VGND VPWR VPWR sky130_fd_sc_hd__decap_6
X_5432_ u_pe_array.g_pe_row\[1\].g_pe_col\[1\].u_pe.psum_out\[2\] _2356_ VGND VGND
+ VPWR VPWR _2357_ sky130_fd_sc_hd__xnor2_1
XFILLER_0_112_345 VPWR VGND VPWR VGND sky130_ef_sc_hd__decap_12
XFILLER_0_100_507 VGND VGND VPWR VPWR sky130_fd_sc_hd__fill_2
X_5363_ u_pe_array.u_fifo1.buffer\[0\]\[2\] _2275_ VGND VGND VPWR VPWR _2301_ sky130_fd_sc_hd__or2_1
XFILLER_0_112_389 VGND VGND VPWR VPWR sky130_fd_sc_hd__decap_3
XFILLER_0_77_53 VGND VGND VPWR VPWR sky130_fd_sc_hd__decap_3
X_4314_ _1417_ _1419_ VGND VGND VPWR VPWR _1420_ sky130_fd_sc_hd__xnor2_2
XFILLER_0_2_587 VGND VGND VPWR VPWR sky130_fd_sc_hd__fill_1
XANTENNA__4120__S _0855_ VGND VGND VPWR VPWR sky130_fd_sc_hd__diode_2
X_7102_ clknet_leaf_86_clk _0173_ net819 VGND VGND VPWR VPWR u_pe_array.g_pe_row\[2\].g_pe_col\[2\].u_pe.psum_out\[9\]
+ sky130_fd_sc_hd__dfrtp_1
XANTENNA__7059__RESET_B net74 VGND VGND VPWR VPWR sky130_fd_sc_hd__diode_2
X_5294_ _2231_ _2234_ _2239_ VGND VGND VPWR VPWR _2241_ sky130_fd_sc_hd__and3_1
X_4245_ _1369_ _1370_ _1359_ VGND VGND VPWR VPWR _1371_ sky130_fd_sc_hd__a21oi_1
X_7033_ clknet_leaf_15_clk _0108_ net816 VGND VGND VPWR VPWR u_pe_array.g_pe_row\[3\].g_pe_col\[0\].u_pe.psum_out\[0\]
+ sky130_fd_sc_hd__dfrtp_1
X_4176_ u_pe_array.g_pe_row\[3\].g_pe_col\[0\].u_pe.w_reg\[0\] _1275_ _1306_ u_pe_array.g_pe_row\[3\].g_pe_col\[0\].u_pe.act_val\[4\]
+ VGND VGND VPWR VPWR _1308_ sky130_fd_sc_hd__nand4_1
XFILLER_0_93_96 VGND VGND VPWR VPWR sky130_fd_sc_hd__fill_2
XANTENNA__5886__S _2469_ VGND VGND VPWR VPWR sky130_fd_sc_hd__diode_2
XTAP_1019 VGND VPWR sky130_fd_sc_hd__tapvpwrvgnd_1
XTAP_1008 VGND VPWR sky130_fd_sc_hd__tapvpwrvgnd_1
XANTENNA__4802__A2 _1666_ VGND VGND VPWR VPWR sky130_fd_sc_hd__diode_2
XANTENNA_clkbuf_leaf_60_clk_A clknet_3_4__leaf_clk VGND VGND VPWR VPWR sky130_fd_sc_hd__diode_2
Xclkbuf_leaf_62_clk clknet_3_4__leaf_clk VGND VGND VPWR VPWR clknet_leaf_62_clk sky130_fd_sc_hd__clkbuf_16
XANTENNA__4790__S _0747_ VGND VGND VPWR VPWR sky130_fd_sc_hd__diode_2
X_6817_ _3389_ VGND VGND VPWR VPWR _0671_ sky130_fd_sc_hd__clkbuf_1
XANTENNA__6290__B _2992_ VGND VGND VPWR VPWR sky130_fd_sc_hd__diode_2
X_6748_ net473 _3103_ net63 VGND VGND VPWR VPWR _3353_ sky130_fd_sc_hd__mux2_1
XFILLER_0_73_582 VGND VGND VPWR VPWR sky130_fd_sc_hd__decap_3
XFILLER_0_33_413 VGND VGND VPWR VPWR sky130_fd_sc_hd__fill_2
XFILLER_0_73_593 VGND VGND VPWR VPWR sky130_fd_sc_hd__fill_2
X_6679_ _0819_ _3104_ VGND VGND VPWR VPWR _3314_ sky130_fd_sc_hd__nor2_1
XANTENNA_clkbuf_leaf_75_clk_A clknet_3_4__leaf_clk VGND VGND VPWR VPWR sky130_fd_sc_hd__diode_2
XANTENNA__6510__S _3208_ VGND VGND VPWR VPWR sky130_fd_sc_hd__diode_2
XFILLER_0_33_457 VGND VGND VPWR VPWR sky130_fd_sc_hd__fill_1
XANTENNA__4869__A2 _1714_ VGND VGND VPWR VPWR sky130_fd_sc_hd__diode_2
XANTENNA__3526__C1 _0754_ VGND VGND VPWR VPWR sky130_fd_sc_hd__diode_2
XFILLER_0_103_389 VGND VGND VPWR VPWR sky130_fd_sc_hd__decap_3
XANTENNA_clkbuf_leaf_13_clk_A clknet_3_1__leaf_clk VGND VGND VPWR VPWR sky130_fd_sc_hd__diode_2
XTAP_1542 VGND VPWR sky130_fd_sc_hd__tapvpwrvgnd_1
XTAP_1531 VGND VPWR sky130_fd_sc_hd__tapvpwrvgnd_1
XTAP_1520 VGND VPWR sky130_fd_sc_hd__tapvpwrvgnd_1
XFILLER_0_96_674 VGND VGND VPWR VPWR sky130_fd_sc_hd__decap_3
XANTENNA_clkbuf_leaf_28_clk_A clknet_3_3__leaf_clk VGND VGND VPWR VPWR sky130_fd_sc_hd__diode_2
XFILLER_0_68_365 VGND VGND VPWR VPWR sky130_fd_sc_hd__decap_6
Xclkbuf_leaf_53_clk clknet_3_7__leaf_clk VGND VGND VPWR VPWR clknet_leaf_53_clk sky130_fd_sc_hd__clkbuf_16
XTAP_1575 VGND VPWR sky130_fd_sc_hd__tapvpwrvgnd_1
XTAP_1564 VGND VPWR sky130_fd_sc_hd__tapvpwrvgnd_1
XTAP_1553 VGND VPWR sky130_fd_sc_hd__tapvpwrvgnd_1
XFILLER_0_68_398 VGND VGND VPWR VPWR sky130_fd_sc_hd__decap_4
XPHY_60 VGND VGND VPWR VPWR sky130_fd_sc_hd__decap_3
XPHY_71 VGND VGND VPWR VPWR sky130_fd_sc_hd__decap_3
XPHY_82 VGND VGND VPWR VPWR sky130_fd_sc_hd__decap_3
XTAP_1597 VGND VPWR sky130_fd_sc_hd__tapvpwrvgnd_1
XTAP_1586 VGND VPWR sky130_fd_sc_hd__tapvpwrvgnd_1
XFILLER_0_113_39 VPWR VGND VPWR VGND sky130_ef_sc_hd__decap_12
XPHY_93 VGND VGND VPWR VPWR sky130_fd_sc_hd__decap_3
XANTENNA__4570__A_N _1536_ VGND VGND VPWR VPWR sky130_fd_sc_hd__diode_2
XFILLER_0_107_673 VGND VGND VPWR VPWR sky130_fd_sc_hd__decap_4
XFILLER_0_91_390 VGND VGND VPWR VPWR sky130_fd_sc_hd__fill_2
XANTENNA__5825__A _2611_ VGND VGND VPWR VPWR sky130_fd_sc_hd__diode_2
XANTENNA__5036__S _1661_ VGND VGND VPWR VPWR sky130_fd_sc_hd__diode_2
XANTENNA__7152__RESET_B net814 VGND VGND VPWR VPWR sky130_fd_sc_hd__diode_2
XANTENNA__5263__C _2158_ VGND VGND VPWR VPWR sky130_fd_sc_hd__diode_2
X_4030_ u_pe_array.g_pe_row\[3\].g_pe_col\[1\].u_pe.act_val\[4\] _1145_ VGND VGND
+ VPWR VPWR _1189_ sky130_fd_sc_hd__and2b_1
XANTENNA__4176__A u_pe_array.g_pe_row\[3\].g_pe_col\[0\].u_pe.w_reg\[0\] VGND VGND
+ VPWR VPWR sky130_fd_sc_hd__diode_2
XANTENNA__5037__A2 _1666_ VGND VGND VPWR VPWR sky130_fd_sc_hd__diode_2
XFILLER_0_63_55 VGND VGND VPWR VPWR sky130_fd_sc_hd__fill_1
X_5981_ _2740_ _2815_ _2816_ _2571_ net630 VGND VGND VPWR VPWR _0408_ sky130_fd_sc_hd__a32o_1
Xclkbuf_leaf_44_clk clknet_3_6__leaf_clk VGND VGND VPWR VPWR clknet_leaf_44_clk sky130_fd_sc_hd__clkbuf_16
X_4932_ _1923_ _1931_ _1932_ _1933_ VGND VGND VPWR VPWR _1934_ sky130_fd_sc_hd__a31o_1
XFILLER_0_63_77 VGND VGND VPWR VPWR sky130_fd_sc_hd__fill_2
X_7651_ clknet_leaf_25_clk _0700_ VGND VGND VPWR VPWR u_pe_array.u_fifo1.buffer\[6\]\[9\]
+ sky130_fd_sc_hd__dfxtp_1
X_4863_ u_pe_array.g_pe_row\[2\].g_pe_col\[0\].u_pe.act_val\[2\] u_pe_array.g_pe_row\[2\].g_pe_col\[0\].u_pe.w_reg\[0\]
+ _1856_ VGND VGND VPWR VPWR _1871_ sky130_fd_sc_hd__and3_1
X_6602_ _3270_ VGND VGND VPWR VPWR _0575_ sky130_fd_sc_hd__clkbuf_1
X_7582_ clknet_leaf_22_clk _0631_ VGND VGND VPWR VPWR u_pe_array.u_fifo1.buffer\[1\]\[5\]
+ sky130_fd_sc_hd__dfxtp_1
XFILLER_0_62_519 VGND VGND VPWR VPWR sky130_fd_sc_hd__fill_2
X_3814_ net173 _0996_ _1006_ _1004_ VGND VGND VPWR VPWR _0051_ sky130_fd_sc_hd__a22o_1
X_4794_ _1820_ net383 _1796_ VGND VGND VPWR VPWR _1821_ sky130_fd_sc_hd__mux2_1
XANTENNA__4548__B2 _0916_ VGND VGND VPWR VPWR sky130_fd_sc_hd__diode_2
XANTENNA__3954__S _0755_ VGND VGND VPWR VPWR sky130_fd_sc_hd__diode_2
X_6533_ net328 _1812_ _3224_ VGND VGND VPWR VPWR _3233_ sky130_fd_sc_hd__mux2_1
X_3745_ _0947_ _0950_ _0955_ VGND VGND VPWR VPWR _0957_ sky130_fd_sc_hd__and3_1
XFILLER_0_27_273 VGND VGND VPWR VPWR sky130_fd_sc_hd__fill_1
XFILLER_0_27_295 VGND VGND VPWR VPWR sky130_fd_sc_hd__decap_3
XFILLER_0_42_210 VPWR VGND VPWR VGND sky130_ef_sc_hd__decap_12
X_6464_ _3196_ VGND VGND VPWR VPWR _0511_ sky130_fd_sc_hd__clkbuf_1
XFILLER_0_113_665 VGND VGND VPWR VPWR sky130_fd_sc_hd__decap_6
X_5415_ u_pe_array.g_pe_row\[1\].g_pe_col\[1\].u_pe.w_reg\[0\] u_pe_array.g_pe_row\[1\].g_pe_col\[1\].u_pe.act_val\[0\]
+ u_pe_array.g_pe_row\[1\].g_pe_col\[1\].u_pe.psum_out\[0\] VGND VGND VPWR VPWR _2342_
+ sky130_fd_sc_hd__and3_1
X_3676_ _0892_ VGND VGND VPWR VPWR _0893_ sky130_fd_sc_hd__inv_2
XFILLER_0_42_265 VGND VGND VPWR VPWR sky130_fd_sc_hd__fill_2
XANTENNA__6170__B1 _0861_ VGND VGND VPWR VPWR sky130_fd_sc_hd__diode_2
XFILLER_0_63_3 VPWR VGND VPWR VGND sky130_ef_sc_hd__decap_12
X_6395_ _3155_ _3157_ VGND VGND VPWR VPWR _0481_ sky130_fd_sc_hd__xnor2_1
XFILLER_0_11_641 VPWR VGND VPWR VGND sky130_ef_sc_hd__decap_12
XFILLER_0_112_197 VGND VGND VPWR VPWR sky130_fd_sc_hd__fill_2
X_5346_ _2273_ _2274_ VGND VGND VPWR VPWR _2286_ sky130_fd_sc_hd__nor2_2
X_5277_ u_pe_array.g_pe_row\[1\].g_pe_col\[2\].u_pe.psum_out\[7\] _2158_ VGND VGND
+ VPWR VPWR _2225_ sky130_fd_sc_hd__or2_1
XANTENNA__4785__S _1796_ VGND VGND VPWR VPWR sky130_fd_sc_hd__diode_2
X_7016_ clknet_leaf_29_clk _0093_ net817 VGND VGND VPWR VPWR u_pe_array.g_pe_row\[3\].g_pe_col\[0\].u_pe.w_buffer\[0\]
+ sky130_fd_sc_hd__dfrtp_1
X_4228_ _1347_ _1350_ _1355_ VGND VGND VPWR VPWR _1356_ sky130_fd_sc_hd__and3_1
XANTENNA__6473__A1 _1808_ VGND VGND VPWR VPWR sky130_fd_sc_hd__diode_2
XFILLER_0_97_405 VGND VGND VPWR VPWR sky130_fd_sc_hd__fill_1
X_4159_ _1282_ _1288_ _1291_ VGND VGND VPWR VPWR _1292_ sky130_fd_sc_hd__a21o_1
XFILLER_0_97_438 VGND VGND VPWR VPWR sky130_fd_sc_hd__fill_2
XFILLER_0_97_427 VGND VGND VPWR VPWR sky130_fd_sc_hd__fill_1
XANTENNA__4787__A1 _1787_ VGND VGND VPWR VPWR sky130_fd_sc_hd__diode_2
XANTENNA__4787__B2 _0747_ VGND VGND VPWR VPWR sky130_fd_sc_hd__diode_2
XFILLER_0_93_633 VGND VGND VPWR VPWR sky130_fd_sc_hd__decap_3
XFILLER_0_93_600 VGND VGND VPWR VPWR sky130_fd_sc_hd__decap_3
Xclkbuf_leaf_35_clk clknet_3_3__leaf_clk VGND VGND VPWR VPWR clknet_leaf_35_clk sky130_fd_sc_hd__clkbuf_16
XFILLER_0_65_313 VGND VGND VPWR VPWR sky130_fd_sc_hd__fill_2
XANTENNA__5629__B _2478_ VGND VGND VPWR VPWR sky130_fd_sc_hd__diode_2
XFILLER_0_93_644 VGND VGND VPWR VPWR sky130_fd_sc_hd__fill_2
XFILLER_0_65_357 VGND VGND VPWR VPWR sky130_fd_sc_hd__fill_2
XFILLER_0_92_165 VGND VGND VPWR VPWR sky130_fd_sc_hd__fill_2
XFILLER_0_46_571 VGND VGND VPWR VPWR sky130_fd_sc_hd__fill_1
XFILLER_0_18_262 VGND VGND VPWR VPWR sky130_fd_sc_hd__fill_2
XFILLER_0_104_632 VPWR VGND VPWR VGND sky130_ef_sc_hd__decap_12
XFILLER_0_61_585 VGND VGND VPWR VPWR sky130_fd_sc_hd__fill_2
XFILLER_0_88_449 VGND VGND VPWR VPWR sky130_fd_sc_hd__fill_2
XANTENNA__4778__A1 _1787_ VGND VGND VPWR VPWR sky130_fd_sc_hd__diode_2
XANTENNA__4778__B2 _0747_ VGND VGND VPWR VPWR sky130_fd_sc_hd__diode_2
Xclkbuf_leaf_26_clk clknet_3_2__leaf_clk VGND VGND VPWR VPWR clknet_leaf_26_clk sky130_fd_sc_hd__clkbuf_16
XTAP_1350 VGND VPWR sky130_fd_sc_hd__tapvpwrvgnd_1
XFILLER_0_84_622 VGND VGND VPWR VPWR sky130_fd_sc_hd__fill_2
XFILLER_0_84_600 VGND VGND VPWR VPWR sky130_fd_sc_hd__fill_2
XFILLER_0_56_313 VGND VGND VPWR VPWR sky130_fd_sc_hd__fill_2
XFILLER_0_29_516 VGND VGND VPWR VPWR sky130_fd_sc_hd__fill_1
XTAP_1383 VGND VPWR sky130_fd_sc_hd__tapvpwrvgnd_1
XTAP_1372 VGND VPWR sky130_fd_sc_hd__tapvpwrvgnd_1
XTAP_1361 VGND VPWR sky130_fd_sc_hd__tapvpwrvgnd_1
XFILLER_0_84_655 VGND VGND VPWR VPWR sky130_fd_sc_hd__fill_2
XFILLER_0_29_549 VGND VGND VPWR VPWR sky130_fd_sc_hd__fill_2
XTAP_1394 VGND VPWR sky130_fd_sc_hd__tapvpwrvgnd_1
XANTENNA__4162__C u_pe_array.g_pe_row\[3\].g_pe_col\[0\].u_pe.w_reg\[0\] VGND VGND
+ VPWR VPWR sky130_fd_sc_hd__diode_2
XFILLER_0_83_198 VGND VGND VPWR VPWR sky130_fd_sc_hd__decap_4
XFILLER_0_83_187 VGND VGND VPWR VPWR sky130_fd_sc_hd__decap_3
Xinput12 h_in1[5] VGND VGND VPWR VPWR net12 sky130_fd_sc_hd__dlymetal6s2s_1
XANTENNA__7333__RESET_B net812 VGND VGND VPWR VPWR sky130_fd_sc_hd__diode_2
X_3530_ net291 _0778_ VGND VGND VPWR VPWR u_fsm.en sky130_fd_sc_hd__nor2_1
Xinput34 w_in_flat[7] VGND VGND VPWR VPWR net34 sky130_fd_sc_hd__buf_1
Xinput23 v_in1[2] VGND VGND VPWR VPWR net23 sky130_fd_sc_hd__buf_1
XFILLER_0_12_416 VGND VGND VPWR VPWR sky130_fd_sc_hd__decap_4
XFILLER_0_3_137 VPWR VGND VPWR VGND sky130_ef_sc_hd__decap_12
XFILLER_0_110_613 VPWR VGND VPWR VGND sky130_ef_sc_hd__decap_12
X_3461_ u_pe_array.g_pe_row\[3\].g_pe_col\[0\].u_pe.psum_out\[1\] u_pe_array.g_pe_row\[3\].g_pe_col\[0\].u_pe.act_val\[1\]
+ _0734_ VGND VGND VPWR VPWR _0735_ sky130_fd_sc_hd__mux2_1
XFILLER_0_110_657 VPWR VGND VPWR VGND sky130_ef_sc_hd__decap_12
X_6180_ _2974_ _2979_ _2982_ _2977_ VGND VGND VPWR VPWR _2983_ sky130_fd_sc_hd__a22oi_1
X_5200_ u_pe_array.g_pe_row\[1\].g_pe_col\[2\].u_pe.act_val\[0\] u_pe_array.g_pe_row\[1\].g_pe_col\[2\].u_pe.psum_out\[0\]
+ u_pe_array.g_pe_row\[1\].g_pe_col\[2\].u_pe.w_reg\[0\] VGND VGND VPWR VPWR _2155_
+ sky130_fd_sc_hd__and3_1
XFILLER_0_58_77 VGND VGND VPWR VPWR sky130_fd_sc_hd__decap_6
X_5131_ _2029_ u_pe_array.g_pe_row\[1\].g_pe_col\[3\].u_pe.psum_out\[8\] VGND VGND
+ VPWR VPWR _2106_ sky130_fd_sc_hd__or2_1
X_5062_ _2032_ _2035_ VGND VGND VPWR VPWR _2043_ sky130_fd_sc_hd__and2_1
XANTENNA_clkbuf_3_6__f_clk_A clknet_0_clk VGND VGND VPWR VPWR sky130_fd_sc_hd__diode_2
X_4013_ _1170_ _1172_ _1163_ VGND VGND VPWR VPWR _1174_ sky130_fd_sc_hd__o21ai_1
XFILLER_0_74_54 VGND VGND VPWR VPWR sky130_fd_sc_hd__fill_2
XANTENNA__3949__S _0819_ VGND VGND VPWR VPWR sky130_fd_sc_hd__diode_2
XFILLER_0_94_408 VGND VGND VPWR VPWR sky130_fd_sc_hd__fill_2
XANTENNA__4769__A1 _1787_ VGND VGND VPWR VPWR sky130_fd_sc_hd__diode_2
XFILLER_0_87_460 VGND VGND VPWR VPWR sky130_fd_sc_hd__decap_3
XFILLER_0_75_600 VGND VGND VPWR VPWR sky130_fd_sc_hd__fill_2
Xclkbuf_leaf_17_clk clknet_3_2__leaf_clk VGND VGND VPWR VPWR clknet_leaf_17_clk sky130_fd_sc_hd__clkbuf_16
X_5964_ u_pe_array.g_pe_row\[0\].g_pe_col\[2\].u_pe.act_val\[4\] _2800_ _2789_ _2787_
+ VGND VGND VPWR VPWR _2801_ sky130_fd_sc_hd__o22ai_1
XANTENNA__4769__B2 _0747_ VGND VGND VPWR VPWR sky130_fd_sc_hd__diode_2
X_4915_ _1905_ _1915_ VGND VGND VPWR VPWR _1918_ sky130_fd_sc_hd__and2_1
X_5895_ u_pe_array.g_pe_row\[1\].g_pe_col\[1\].u_pe.psum_out\[12\] u_pe_array.g_pe_row\[1\].g_pe_col\[1\].u_pe.move_reg\[12\]
+ _2469_ VGND VGND VPWR VPWR _2739_ sky130_fd_sc_hd__mux2_1
X_4846_ u_pe_array.g_pe_row\[2\].g_pe_col\[0\].u_pe.act_val\[0\] _1846_ _1847_ VGND
+ VGND VPWR VPWR _1855_ sky130_fd_sc_hd__a21bo_1
X_7634_ clknet_leaf_23_clk _0683_ VGND VGND VPWR VPWR u_pe_array.u_fifo1.buffer\[5\]\[5\]
+ sky130_fd_sc_hd__dfxtp_1
XANTENNA__5718__B1 _2592_ VGND VGND VPWR VPWR sky130_fd_sc_hd__diode_2
X_7565_ clknet_leaf_27_clk _0614_ VGND VGND VPWR VPWR u_pe_array.u_fifo1.buffer\[0\]\[1\]
+ sky130_fd_sc_hd__dfxtp_1
XANTENNA__5194__B2 _1665_ VGND VGND VPWR VPWR sky130_fd_sc_hd__diode_2
XFILLER_0_105_429 VGND VGND VPWR VPWR sky130_fd_sc_hd__fill_2
XANTENNA__5465__A _0866_ VGND VGND VPWR VPWR sky130_fd_sc_hd__diode_2
XFILLER_0_99_73 VGND VGND VPWR VPWR sky130_fd_sc_hd__decap_3
X_6516_ _3223_ VGND VGND VPWR VPWR _3224_ sky130_fd_sc_hd__buf_4
X_4777_ _1809_ VGND VGND VPWR VPWR _0211_ sky130_fd_sc_hd__clkbuf_1
XANTENNA__7074__RESET_B net74 VGND VGND VPWR VPWR sky130_fd_sc_hd__diode_2
XANTENNA__7003__RESET_B net816 VGND VGND VPWR VPWR sky130_fd_sc_hd__diode_2
XFILLER_0_70_371 VGND VGND VPWR VPWR sky130_fd_sc_hd__fill_2
X_7496_ clknet_leaf_93_clk _0545_ VGND VGND VPWR VPWR u_pe_array.u_fifo2.buffer\[4\]\[9\]
+ sky130_fd_sc_hd__dfxtp_1
XFILLER_0_15_276 VGND VGND VPWR VPWR sky130_fd_sc_hd__fill_2
X_3728_ u_pe_array.g_pe_row\[3\].g_pe_col\[3\].u_pe.psum_out\[7\] _0869_ VGND VGND
+ VPWR VPWR _0941_ sky130_fd_sc_hd__or2_1
XFILLER_0_113_473 VPWR VGND VPWR VGND sky130_ef_sc_hd__decap_12
XANTENNA_load_slew2_A net75 VGND VGND VPWR VPWR sky130_fd_sc_hd__diode_2
XFILLER_0_3_671 VGND VGND VPWR VPWR sky130_fd_sc_hd__fill_1
X_3659_ u_pe_array.g_pe_row\[3\].g_pe_col\[3\].u_pe.psum_out\[1\] _0872_ _0876_ VGND
+ VGND VPWR VPWR _0877_ sky130_fd_sc_hd__a21o_1
X_6447_ _3187_ VGND VGND VPWR VPWR _0503_ sky130_fd_sc_hd__clkbuf_1
X_6378_ u_pe_array.u_fifo2.count\[1\] u_pe_array.u_fifo2.count\[2\] u_pe_array.u_fifo2.count\[0\]
+ u_pe_array.u_fifo2.count\[3\] _1787_ VGND VGND VPWR VPWR _3146_ sky130_fd_sc_hd__o41a_2
XFILLER_0_30_257 VGND VGND VPWR VPWR sky130_fd_sc_hd__fill_1
X_5329_ u_pe_array.g_pe_row\[0\].g_pe_col\[1\].u_pe.w_buffer\[1\] u_pe_array.g_pe_row\[1\].g_pe_col\[1\].u_pe.w_buffer\[1\]
+ _0828_ VGND VGND VPWR VPWR _2270_ sky130_fd_sc_hd__mux2_1
XANTENNA__6446__A1 _1808_ VGND VGND VPWR VPWR sky130_fd_sc_hd__diode_2
XANTENNA__3713__A u_pe_array.g_pe_row\[3\].g_pe_col\[3\].u_pe.act_val\[5\] VGND VGND
+ VPWR VPWR sky130_fd_sc_hd__diode_2
XFILLER_0_97_279 VGND VGND VPWR VPWR sky130_fd_sc_hd__fill_1
XFILLER_0_38_313 VGND VGND VPWR VPWR sky130_fd_sc_hd__fill_1
XFILLER_0_108_212 VGND VGND VPWR VPWR sky130_fd_sc_hd__fill_2
XANTENNA__3983__A2 _1145_ VGND VGND VPWR VPWR sky130_fd_sc_hd__diode_2
XFILLER_0_93_496 VGND VGND VPWR VPWR sky130_fd_sc_hd__decap_8
XANTENNA__3594__S _0828_ VGND VGND VPWR VPWR sky130_fd_sc_hd__diode_2
XFILLER_0_110_29 VPWR VGND VPWR VGND sky130_ef_sc_hd__decap_12
XFILLER_0_104_451 VPWR VGND VPWR VGND sky130_ef_sc_hd__decap_12
XFILLER_0_61_393 VGND VGND VPWR VPWR sky130_fd_sc_hd__fill_1
XTAP_419 VGND VPWR sky130_fd_sc_hd__tapvpwrvgnd_1
XTAP_408 VGND VPWR sky130_fd_sc_hd__tapvpwrvgnd_1
XANTENNA__4630__B1_N _1672_ VGND VGND VPWR VPWR sky130_fd_sc_hd__diode_2
XFILLER_0_88_202 VGND VGND VPWR VPWR sky130_fd_sc_hd__fill_2
XFILLER_0_88_268 VGND VGND VPWR VPWR sky130_fd_sc_hd__fill_2
XFILLER_0_88_246 VGND VGND VPWR VPWR sky130_fd_sc_hd__decap_4
XFILLER_0_69_460 VGND VGND VPWR VPWR sky130_fd_sc_hd__decap_6
XFILLER_0_57_622 VGND VGND VPWR VPWR sky130_fd_sc_hd__fill_2
XFILLER_0_57_611 VGND VGND VPWR VPWR sky130_fd_sc_hd__decap_3
XANTENNA__5948__B1 _2571_ VGND VGND VPWR VPWR sky130_fd_sc_hd__diode_2
XFILLER_0_57_644 VGND VGND VPWR VPWR sky130_fd_sc_hd__fill_1
XTAP_1191 VGND VPWR sky130_fd_sc_hd__tapvpwrvgnd_1
XTAP_1180 VGND VPWR sky130_fd_sc_hd__tapvpwrvgnd_1
X_5680_ _2560_ _2563_ _2568_ VGND VGND VPWR VPWR _2570_ sky130_fd_sc_hd__or3_1
X_4700_ _1722_ VGND VGND VPWR VPWR _1744_ sky130_fd_sc_hd__inv_2
XFILLER_0_56_165 VGND VGND VPWR VPWR sky130_fd_sc_hd__fill_2
XFILLER_0_29_379 VGND VGND VPWR VPWR sky130_fd_sc_hd__fill_2
XFILLER_0_72_636 VGND VGND VPWR VPWR sky130_fd_sc_hd__fill_2
XFILLER_0_72_625 VGND VGND VPWR VPWR sky130_fd_sc_hd__fill_2
X_4631_ u_pe_array.g_pe_row\[2\].g_pe_col\[1\].u_pe.act_val\[1\] _1672_ VGND VGND
+ VPWR VPWR _1681_ sky130_fd_sc_hd__and2b_1
XFILLER_0_71_113 VGND VGND VPWR VPWR sky130_fd_sc_hd__fill_1
XFILLER_0_56_187 VGND VGND VPWR VPWR sky130_fd_sc_hd__decap_3
XFILLER_0_25_530 VGND VGND VPWR VPWR sky130_fd_sc_hd__fill_2
XFILLER_0_114_237 VGND VGND VPWR VPWR sky130_fd_sc_hd__fill_2
XFILLER_0_69_10 VPWR VGND VPWR VGND sky130_ef_sc_hd__decap_12
X_7350_ clknet_leaf_63_clk _0405_ net818 VGND VGND VPWR VPWR u_pe_array.g_pe_row\[0\].g_pe_col\[2\].u_pe.psum_out\[4\]
+ sky130_fd_sc_hd__dfrtp_1
X_4562_ _1630_ _1631_ _1620_ VGND VGND VPWR VPWR _1632_ sky130_fd_sc_hd__a21oi_1
X_6301_ _3087_ _3088_ VGND VGND VPWR VPWR _3089_ sky130_fd_sc_hd__and2_1
XANTENNA__3517__B _0770_ VGND VGND VPWR VPWR sky130_fd_sc_hd__diode_2
Xhold615 u_pe_array.g_pe_row\[1\].g_pe_col\[0\].u_pe.psum_out\[8\] VGND VGND VPWR
+ VPWR net691 sky130_fd_sc_hd__dlygate4sd3_1
X_3513_ _0745_ VGND VGND VPWR VPWR _0769_ sky130_fd_sc_hd__buf_12
XFILLER_0_69_54 VGND VGND VPWR VPWR sky130_fd_sc_hd__fill_2
Xhold626 u_pe_array.g_pe_row\[2\].g_pe_col\[1\].u_pe.act_val\[2\] VGND VGND VPWR VPWR
+ net702 sky130_fd_sc_hd__dlygate4sd3_1
XFILLER_0_52_393 VGND VGND VPWR VPWR sky130_fd_sc_hd__fill_2
X_4493_ u_pe_array.g_pe_row\[2\].g_pe_col\[2\].u_pe.w_reg\[0\] _1536_ _1567_ u_pe_array.g_pe_row\[2\].g_pe_col\[2\].u_pe.act_val\[4\]
+ VGND VGND VPWR VPWR _1569_ sky130_fd_sc_hd__nand4_1
Xhold604 u_pe_array.g_pe_row\[3\].g_pe_col\[2\].u_pe.act_val\[2\] VGND VGND VPWR VPWR
+ net680 sky130_fd_sc_hd__dlygate4sd3_1
X_7281_ clknet_leaf_71_clk net157 net814 VGND VGND VPWR VPWR u_pe_array.g_pe_row\[0\].g_pe_col\[3\].u_pe.move_reg\[10\]
+ sky130_fd_sc_hd__dfrtp_1
XFILLER_0_110_421 VGND VGND VPWR VPWR sky130_fd_sc_hd__decap_3
X_6232_ _3024_ _3025_ u_pe_array.g_pe_row\[0\].g_pe_col\[0\].u_pe.act_val\[4\] u_pe_array.g_pe_row\[0\].g_pe_col\[0\].u_pe.w_reg\[0\]
+ VGND VGND VPWR VPWR _3026_ sky130_fd_sc_hd__and4bb_1
Xhold637 u_pe_array.g_pe_row\[2\].g_pe_col\[0\].u_pe.psum_out\[4\] VGND VGND VPWR
+ VPWR net713 sky130_fd_sc_hd__dlygate4sd3_1
Xhold648 u_pe_array.g_pe_row\[2\].g_pe_col\[1\].u_pe.psum_out\[10\] VGND VGND VPWR
+ VPWR net724 sky130_fd_sc_hd__dlygate4sd3_1
X_3444_ _0717_ _0719_ VGND VGND VPWR VPWR _0720_ sky130_fd_sc_hd__nand2_4
Xclkbuf_leaf_6_clk clknet_3_0__leaf_clk VGND VGND VPWR VPWR clknet_leaf_6_clk sky130_fd_sc_hd__clkbuf_16
XFILLER_0_12_268 VGND VGND VPWR VPWR sky130_fd_sc_hd__fill_2
Xhold659 _0032_ VGND VGND VPWR VPWR net735 sky130_fd_sc_hd__dlygate4sd3_1
X_6163_ _2873_ u_pe_array.g_pe_row\[0\].g_pe_col\[1\].u_pe.psum_out\[10\] VGND VGND
+ VPWR VPWR _2968_ sky130_fd_sc_hd__or2_1
XTAP_953 VGND VPWR sky130_fd_sc_hd__tapvpwrvgnd_1
XTAP_942 VGND VPWR sky130_fd_sc_hd__tapvpwrvgnd_1
XTAP_931 VGND VPWR sky130_fd_sc_hd__tapvpwrvgnd_1
XTAP_920 VGND VPWR sky130_fd_sc_hd__tapvpwrvgnd_1
XFILLER_0_20_290 VGND VGND VPWR VPWR sky130_fd_sc_hd__fill_1
X_6094_ _2873_ _2904_ u_pe_array.g_pe_row\[0\].g_pe_col\[1\].u_pe.act_val\[4\] u_pe_array.g_pe_row\[0\].g_pe_col\[1\].u_pe.w_reg\[0\]
+ VGND VGND VPWR VPWR _2905_ sky130_fd_sc_hd__a22o_1
XTAP_986 VGND VPWR sky130_fd_sc_hd__tapvpwrvgnd_1
XTAP_975 VGND VPWR sky130_fd_sc_hd__tapvpwrvgnd_1
XTAP_964 VGND VPWR sky130_fd_sc_hd__tapvpwrvgnd_1
X_5114_ _2077_ _2083_ _2090_ VGND VGND VPWR VPWR _2091_ sky130_fd_sc_hd__o21ai_1
XTAP_997 VGND VPWR sky130_fd_sc_hd__tapvpwrvgnd_1
X_5045_ u_pe_array.g_pe_row\[1\].g_pe_col\[3\].u_pe.w_reg\[0\] u_pe_array.g_pe_row\[1\].g_pe_col\[3\].u_pe.act_val\[0\]
+ u_pe_array.g_pe_row\[1\].g_pe_col\[3\].u_pe.psum_out\[0\] VGND VGND VPWR VPWR _2028_
+ sky130_fd_sc_hd__nand3_1
X_6996_ clknet_leaf_34_clk _0075_ net817 VGND VGND VPWR VPWR u_pe_array.g_pe_row\[3\].g_pe_col\[0\].u_pe.move_reg\[8\]
+ sky130_fd_sc_hd__dfrtp_1
XFILLER_0_79_279 VGND VGND VPWR VPWR sky130_fd_sc_hd__fill_1
XFILLER_0_79_268 VGND VGND VPWR VPWR sky130_fd_sc_hd__fill_2
XFILLER_0_87_290 VGND VGND VPWR VPWR sky130_fd_sc_hd__fill_2
XANTENNA__7255__RESET_B net813 VGND VGND VPWR VPWR sky130_fd_sc_hd__diode_2
X_5947_ _2783_ _2784_ VGND VGND VPWR VPWR _2786_ sky130_fd_sc_hd__or2_1
XFILLER_0_48_633 VGND VGND VPWR VPWR sky130_fd_sc_hd__fill_2
XFILLER_0_75_463 VGND VGND VPWR VPWR sky130_fd_sc_hd__decap_8
X_7617_ clknet_leaf_22_clk _0666_ VGND VGND VPWR VPWR u_pe_array.u_fifo1.buffer\[4\]\[1\]
+ sky130_fd_sc_hd__dfxtp_1
XFILLER_0_90_411 VGND VGND VPWR VPWR sky130_fd_sc_hd__fill_2
X_5878_ u_pe_array.g_pe_row\[1\].g_pe_col\[1\].u_pe.act_val\[4\] u_pe_array.g_pe_row\[1\].g_pe_col\[1\].u_pe.psum_out\[4\]
+ _0770_ VGND VGND VPWR VPWR _2730_ sky130_fd_sc_hd__mux2_1
XFILLER_0_75_485 VGND VGND VPWR VPWR sky130_fd_sc_hd__fill_2
XFILLER_0_47_198 VGND VGND VPWR VPWR sky130_fd_sc_hd__fill_2
XFILLER_0_35_327 VGND VGND VPWR VPWR sky130_fd_sc_hd__decap_6
XFILLER_0_105_215 VGND VGND VPWR VPWR sky130_fd_sc_hd__decap_3
XFILLER_0_62_157 VGND VGND VPWR VPWR sky130_fd_sc_hd__decap_6
XFILLER_0_7_284 VGND VGND VPWR VPWR sky130_fd_sc_hd__decap_8
XFILLER_0_16_530 VGND VGND VPWR VPWR sky130_fd_sc_hd__fill_2
XFILLER_0_16_541 VGND VGND VPWR VPWR sky130_fd_sc_hd__fill_2
X_4829_ _1841_ VGND VGND VPWR VPWR _0231_ sky130_fd_sc_hd__clkbuf_1
XANTENNA__4914__A1 _1725_ VGND VGND VPWR VPWR sky130_fd_sc_hd__diode_2
XFILLER_0_90_477 VGND VGND VPWR VPWR sky130_fd_sc_hd__fill_2
XFILLER_0_7_295 VGND VGND VPWR VPWR sky130_fd_sc_hd__decap_8
X_7548_ clknet_leaf_78_clk _0597_ net815 VGND VGND VPWR VPWR u_pe_array.g_pe_row\[3\].g_pe_col\[3\].u_pe.move_reg\[9\]
+ sky130_fd_sc_hd__dfrtp_1
XFILLER_0_31_511 VGND VGND VPWR VPWR sky130_fd_sc_hd__fill_2
XFILLER_0_43_393 VGND VGND VPWR VPWR sky130_fd_sc_hd__fill_1
X_7479_ clknet_leaf_3_clk _0528_ VGND VGND VPWR VPWR u_pe_array.u_fifo2.buffer\[3\]\[5\]
+ sky130_fd_sc_hd__dfxtp_1
XFILLER_0_113_281 VGND VGND VPWR VPWR sky130_fd_sc_hd__decap_3
XFILLER_0_101_465 VGND VGND VPWR VPWR sky130_fd_sc_hd__decap_8
XANTENNA__5642__B _2478_ VGND VGND VPWR VPWR sky130_fd_sc_hd__diode_2
XANTENNA__6419__A1 _1808_ VGND VGND VPWR VPWR sky130_fd_sc_hd__diode_2
XANTENNA__3956__A2 _0996_ VGND VGND VPWR VPWR sky130_fd_sc_hd__diode_2
XFILLER_0_54_614 VGND VGND VPWR VPWR sky130_fd_sc_hd__decap_3
XFILLER_0_39_666 VGND VGND VPWR VPWR sky130_fd_sc_hd__fill_2
XFILLER_0_66_474 VGND VGND VPWR VPWR sky130_fd_sc_hd__fill_2
XFILLER_0_54_625 VGND VGND VPWR VPWR sky130_fd_sc_hd__fill_2
XANTENNA__6355__B1 net50 VGND VGND VPWR VPWR sky130_fd_sc_hd__diode_2
XFILLER_0_19_390 VGND VGND VPWR VPWR sky130_fd_sc_hd__fill_2
XFILLER_0_26_349 VGND VGND VPWR VPWR sky130_fd_sc_hd__decap_4
XFILLER_0_81_499 VGND VGND VPWR VPWR sky130_fd_sc_hd__fill_2
XFILLER_0_53_179 VPWR VGND VPWR VGND sky130_ef_sc_hd__decap_12
XFILLER_0_30_48 VGND VGND VPWR VPWR sky130_fd_sc_hd__decap_3
XANTENNA__6978__RESET_B net819 VGND VGND VPWR VPWR sky130_fd_sc_hd__diode_2
XFILLER_0_111_218 VGND VGND VPWR VPWR sky130_fd_sc_hd__decap_4
XFILLER_0_1_405 VPWR VGND VPWR VGND sky130_ef_sc_hd__decap_12
XFILLER_0_22_533 VGND VGND VPWR VPWR sky130_fd_sc_hd__fill_1
XFILLER_0_104_281 VGND VGND VPWR VPWR sky130_fd_sc_hd__fill_1
XFILLER_0_1_449 VPWR VGND VPWR VGND sky130_ef_sc_hd__decap_12
XANTENNA__5833__A _2611_ VGND VGND VPWR VPWR sky130_fd_sc_hd__diode_2
XFILLER_0_39_57 VGND VGND VPWR VPWR sky130_fd_sc_hd__fill_1
XTAP_238 VGND VPWR sky130_fd_sc_hd__tapvpwrvgnd_1
XANTENNA__4133__A2 _1138_ VGND VGND VPWR VPWR sky130_fd_sc_hd__diode_2
XANTENNA__5881__A2 _2600_ VGND VGND VPWR VPWR sky130_fd_sc_hd__diode_2
XTAP_249 VGND VPWR sky130_fd_sc_hd__tapvpwrvgnd_1
Xhold1 u_pe_array.g_pe_row\[3\].g_pe_col\[0\].u_pe.w_buffer\[1\] VGND VGND VPWR VPWR
+ net77 sky130_fd_sc_hd__dlygate4sd3_1
XFILLER_0_89_522 VGND VGND VPWR VPWR sky130_fd_sc_hd__fill_2
X_6850_ net199 _3128_ _3397_ VGND VGND VPWR VPWR _3407_ sky130_fd_sc_hd__mux2_1
X_6781_ net442 _3116_ _3366_ VGND VGND VPWR VPWR _3370_ sky130_fd_sc_hd__mux2_1
XFILLER_0_9_505 VPWR VGND VPWR VGND sky130_ef_sc_hd__decap_12
XFILLER_0_29_110 VGND VGND VPWR VPWR sky130_fd_sc_hd__fill_2
X_5801_ _2611_ _2665_ u_pe_array.g_pe_row\[0\].g_pe_col\[3\].u_pe.psum_out\[6\] VGND
+ VGND VPWR VPWR _2666_ sky130_fd_sc_hd__and3_1
XANTENNA__3947__A2 _0996_ VGND VGND VPWR VPWR sky130_fd_sc_hd__diode_2
X_3993_ u_pe_array.g_pe_row\[3\].g_pe_col\[1\].u_pe.psum_out\[2\] _1154_ VGND VGND
+ VPWR VPWR _1155_ sky130_fd_sc_hd__xnor2_2
XANTENNA__6603__S _3269_ VGND VGND VPWR VPWR sky130_fd_sc_hd__diode_2
X_5732_ u_pe_array.g_pe_row\[0\].g_pe_col\[3\].u_pe.psum_out\[11\] net807 _2469_ VGND
+ VGND VPWR VPWR _2605_ sky130_fd_sc_hd__mux2_1
XFILLER_0_72_400 VPWR VGND VPWR VGND sky130_ef_sc_hd__decap_12
XFILLER_0_17_327 VGND VGND VPWR VPWR sky130_fd_sc_hd__fill_2
XFILLER_0_72_455 VGND VGND VPWR VPWR sky130_fd_sc_hd__fill_1
XANTENNA__4631__B _1672_ VGND VGND VPWR VPWR sky130_fd_sc_hd__diode_2
X_5663_ _2514_ _2515_ _2526_ VGND VGND VPWR VPWR _2554_ sky130_fd_sc_hd__a21oi_1
XFILLER_0_45_658 VGND VGND VPWR VPWR sky130_fd_sc_hd__fill_2
X_7402_ clknet_leaf_46_clk _0452_ net817 VGND VGND VPWR VPWR u_pe_array.g_pe_row\[0\].g_pe_col\[0\].u_pe.psum_out\[6\]
+ sky130_fd_sc_hd__dfrtp_2
XFILLER_0_72_477 VGND VGND VPWR VPWR sky130_fd_sc_hd__fill_2
X_4614_ u_pe_array.g_pe_row\[2\].g_pe_col\[1\].u_pe.psum_out\[12\] u_pe_array.g_pe_row\[2\].g_pe_col\[1\].u_pe.move_reg\[12\]
+ _1661_ VGND VGND VPWR VPWR _1667_ sky130_fd_sc_hd__mux2_1
X_5594_ _2488_ _2490_ VGND VGND VPWR VPWR _2491_ sky130_fd_sc_hd__xnor2_1
XFILLER_0_60_628 VGND VGND VPWR VPWR sky130_fd_sc_hd__fill_2
XFILLER_0_4_210 VGND VGND VPWR VPWR sky130_fd_sc_hd__decap_3
X_7333_ clknet_leaf_48_clk net419 net812 VGND VGND VPWR VPWR u_pe_array.g_pe_row\[0\].g_pe_col\[1\].u_pe.act_val\[2\]
+ sky130_fd_sc_hd__dfrtp_2
Xhold401 u_pe_array.g_pe_row\[2\].g_pe_col\[0\].u_pe.move_reg\[9\] VGND VGND VPWR
+ VPWR net477 sky130_fd_sc_hd__dlygate4sd3_1
X_4545_ _1608_ _1611_ _1616_ VGND VGND VPWR VPWR _1617_ sky130_fd_sc_hd__and3_1
Xhold412 u_pe_array.g_pe_row\[2\].g_pe_col\[0\].u_pe.psum_out\[11\] VGND VGND VPWR
+ VPWR net488 sky130_fd_sc_hd__dlygate4sd3_1
Xhold434 u_pe_array.g_pe_row\[3\].g_pe_col\[1\].u_pe.psum_out\[3\] VGND VGND VPWR
+ VPWR net510 sky130_fd_sc_hd__dlygate4sd3_1
XFILLER_0_13_566 VGND VGND VPWR VPWR sky130_fd_sc_hd__fill_2
Xhold423 u_pe_array.u_fifo2.buffer\[5\]\[2\] VGND VGND VPWR VPWR net499 sky130_fd_sc_hd__dlygate4sd3_1
Xhold445 u_pe_array.u_fifo2.buffer\[1\]\[2\] VGND VGND VPWR VPWR net521 sky130_fd_sc_hd__dlygate4sd3_1
Xhold456 u_pe_array.u_fifo1.buffer\[2\]\[5\] VGND VGND VPWR VPWR net532 sky130_fd_sc_hd__dlygate4sd3_1
X_7264_ clknet_leaf_49_clk _0325_ net812 VGND VGND VPWR VPWR u_pe_array.g_pe_row\[1\].g_pe_col\[1\].u_pe.psum_out\[8\]
+ sky130_fd_sc_hd__dfrtp_2
Xhold478 u_pe_array.g_pe_row\[1\].g_pe_col\[2\].u_pe.act_val\[2\] VGND VGND VPWR VPWR
+ net554 sky130_fd_sc_hd__dlygate4sd3_1
X_4476_ _1543_ _1549_ _1552_ VGND VGND VPWR VPWR _1553_ sky130_fd_sc_hd__a21o_1
Xhold467 u_pe_array.g_pe_row\[2\].g_pe_col\[3\].u_pe.psum_out\[1\] VGND VGND VPWR
+ VPWR net543 sky130_fd_sc_hd__dlygate4sd3_1
X_6215_ u_pe_array.g_pe_row\[0\].g_pe_col\[0\].u_pe.act_val\[1\] u_pe_array.g_pe_row\[0\].g_pe_col\[0\].u_pe.psum_out\[2\]
+ _2992_ VGND VGND VPWR VPWR _3010_ sky130_fd_sc_hd__and3b_1
XFILLER_0_96_85 VGND VGND VPWR VPWR sky130_fd_sc_hd__fill_2
Xhold489 u_pe_array.u_fifo1.buffer\[8\]\[4\] VGND VGND VPWR VPWR net565 sky130_fd_sc_hd__dlygate4sd3_1
XANTENNA__5321__A1 _2258_ VGND VGND VPWR VPWR sky130_fd_sc_hd__diode_2
X_7195_ clknet_leaf_75_clk net89 net815 VGND VGND VPWR VPWR u_pe_array.g_pe_row\[1\].g_pe_col\[3\].u_pe.w_reg\[1\]
+ sky130_fd_sc_hd__dfrtp_1
X_6146_ _2951_ _2952_ VGND VGND VPWR VPWR _2953_ sky130_fd_sc_hd__or2_1
XTAP_761 VGND VPWR sky130_fd_sc_hd__tapvpwrvgnd_1
XTAP_750 VGND VPWR sky130_fd_sc_hd__tapvpwrvgnd_1
XTAP_794 VGND VPWR sky130_fd_sc_hd__tapvpwrvgnd_1
XTAP_783 VGND VPWR sky130_fd_sc_hd__tapvpwrvgnd_1
XTAP_772 VGND VPWR sky130_fd_sc_hd__tapvpwrvgnd_1
XANTENNA__4793__S _0747_ VGND VGND VPWR VPWR sky130_fd_sc_hd__diode_2
X_6077_ _2881_ _2885_ VGND VGND VPWR VPWR _2889_ sky130_fd_sc_hd__nor2_1
X_5028_ _1787_ _2018_ VGND VGND VPWR VPWR _2019_ sky130_fd_sc_hd__or2_1
XANTENNA__3635__B2 u_fsm.psum_shift_en VGND VGND VPWR VPWR sky130_fd_sc_hd__diode_2
XFILLER_0_67_205 VGND VGND VPWR VPWR sky130_fd_sc_hd__decap_4
XFILLER_0_95_558 VGND VGND VPWR VPWR sky130_fd_sc_hd__fill_2
X_6979_ clknet_leaf_85_clk _0058_ net819 VGND VGND VPWR VPWR u_pe_array.g_pe_row\[3\].g_pe_col\[2\].u_pe.psum_out\[6\]
+ sky130_fd_sc_hd__dfrtp_1
XFILLER_0_48_485 VGND VGND VPWR VPWR sky130_fd_sc_hd__fill_2
XFILLER_0_35_113 VGND VGND VPWR VPWR sky130_fd_sc_hd__fill_1
XANTENNA__6337__B1 net56 VGND VGND VPWR VPWR sky130_fd_sc_hd__diode_2
XFILLER_0_16_360 VGND VGND VPWR VPWR sky130_fd_sc_hd__fill_2
XFILLER_0_31_352 VGND VGND VPWR VPWR sky130_fd_sc_hd__fill_2
XANTENNA__4115__A2 _1138_ VGND VGND VPWR VPWR sky130_fd_sc_hd__diode_2
XANTENNA__5615__A2 _2478_ VGND VGND VPWR VPWR sky130_fd_sc_hd__diode_2
XANTENNA__7177__RESET_B net817 VGND VGND VPWR VPWR sky130_fd_sc_hd__diode_2
XANTENNA__3626__B2 u_fsm.psum_shift_en VGND VGND VPWR VPWR sky130_fd_sc_hd__diode_2
XFILLER_0_98_363 VGND VGND VPWR VPWR sky130_fd_sc_hd__fill_1
XFILLER_0_98_385 VGND VGND VPWR VPWR sky130_fd_sc_hd__fill_2
XFILLER_0_86_558 VGND VGND VPWR VPWR sky130_fd_sc_hd__fill_1
XANTENNA__7106__RESET_B net813 VGND VGND VPWR VPWR sky130_fd_sc_hd__diode_2
XFILLER_0_27_603 VGND VGND VPWR VPWR sky130_fd_sc_hd__fill_2
XFILLER_0_39_430 VGND VGND VPWR VPWR sky130_fd_sc_hd__fill_2
XFILLER_0_39_496 VGND VGND VPWR VPWR sky130_fd_sc_hd__fill_1
XFILLER_0_66_293 VGND VGND VPWR VPWR sky130_fd_sc_hd__decap_6
XFILLER_0_26_135 VGND VGND VPWR VPWR sky130_fd_sc_hd__decap_3
XFILLER_0_41_138 VGND VGND VPWR VPWR sky130_fd_sc_hd__decap_8
XANTENNA__3782__S _0754_ VGND VGND VPWR VPWR sky130_fd_sc_hd__diode_2
XFILLER_0_10_525 VGND VGND VPWR VPWR sky130_fd_sc_hd__decap_6
X_4330_ _1431_ _1433_ _1424_ VGND VGND VPWR VPWR _1435_ sky130_fd_sc_hd__o21ai_1
X_4261_ _1376_ _1381_ _1384_ _1379_ VGND VGND VPWR VPWR _1385_ sky130_fd_sc_hd__a22oi_1
XFILLER_0_10_569 VPWR VGND VPWR VGND sky130_ef_sc_hd__decap_12
XFILLER_0_1_279 VGND VGND VPWR VPWR sky130_fd_sc_hd__fill_1
X_6000_ _2825_ _2828_ _2833_ VGND VGND VPWR VPWR _2834_ sky130_fd_sc_hd__o21ai_1
XFILLER_0_5_69 VPWR VGND VPWR VGND sky130_ef_sc_hd__decap_12
X_4192_ _1320_ _1321_ VGND VGND VPWR VPWR _1323_ sky130_fd_sc_hd__nand2_1
XFILLER_0_66_77 VGND VGND VPWR VPWR sky130_fd_sc_hd__decap_4
XANTENNA__3865__A1 _0864_ VGND VGND VPWR VPWR sky130_fd_sc_hd__diode_2
XFILLER_0_89_330 VGND VGND VPWR VPWR sky130_fd_sc_hd__decap_3
XFILLER_0_82_21 VGND VGND VPWR VPWR sky130_fd_sc_hd__fill_2
XANTENNA__4814__B1 _1655_ VGND VGND VPWR VPWR sky130_fd_sc_hd__diode_2
X_6902_ net347 _3124_ _3427_ VGND VGND VPWR VPWR _3435_ sky130_fd_sc_hd__mux2_1
XFILLER_0_10_6 VGND VGND VPWR VPWR sky130_fd_sc_hd__fill_2
XANTENNA__4118__S _0769_ VGND VGND VPWR VPWR sky130_fd_sc_hd__diode_2
X_6833_ _3398_ VGND VGND VPWR VPWR _0678_ sky130_fd_sc_hd__clkbuf_1
XANTENNA__4290__B2 _1399_ VGND VGND VPWR VPWR sky130_fd_sc_hd__diode_2
XFILLER_0_106_94 VGND VGND VPWR VPWR sky130_fd_sc_hd__fill_1
XANTENNA__6031__A2 _2738_ VGND VGND VPWR VPWR sky130_fd_sc_hd__diode_2
XANTENNA__3957__S _0755_ VGND VGND VPWR VPWR sky130_fd_sc_hd__diode_2
XFILLER_0_18_603 VGND VGND VPWR VPWR sky130_fd_sc_hd__decap_3
X_6764_ net242 _3126_ net62 VGND VGND VPWR VPWR _3361_ sky130_fd_sc_hd__mux2_1
X_3976_ u_pe_array.g_pe_row\[2\].g_pe_col\[0\].u_pe.move_reg\[12\] u_pe_array.g_pe_row\[2\].g_pe_col\[0\].u_pe.psum_out\[12\]
+ _0755_ VGND VGND VPWR VPWR _1141_ sky130_fd_sc_hd__mux2_1
XFILLER_0_9_368 VGND VGND VPWR VPWR sky130_fd_sc_hd__fill_1
XFILLER_0_17_113 VGND VGND VPWR VPWR sky130_fd_sc_hd__decap_3
XFILLER_0_18_636 VGND VGND VPWR VPWR sky130_fd_sc_hd__fill_2
XFILLER_0_85_591 VGND VGND VPWR VPWR sky130_fd_sc_hd__fill_2
X_6695_ _3325_ VGND VGND VPWR VPWR _0613_ sky130_fd_sc_hd__clkbuf_1
XANTENNA__4593__A2 _1524_ VGND VGND VPWR VPWR sky130_fd_sc_hd__diode_2
XFILLER_0_17_135 VGND VGND VPWR VPWR sky130_fd_sc_hd__decap_3
XFILLER_0_18_669 VGND VGND VPWR VPWR sky130_fd_sc_hd__decap_8
X_5715_ u_pe_array.g_pe_row\[0\].g_pe_col\[3\].u_pe.act_val\[3\] u_pe_array.g_pe_row\[0\].g_pe_col\[3\].u_pe.psum_out\[3\]
+ _0770_ VGND VGND VPWR VPWR _2596_ sky130_fd_sc_hd__mux2_1
XFILLER_0_93_3 VPWR VGND VPWR VGND sky130_ef_sc_hd__decap_12
X_5646_ _2537_ _2538_ VGND VGND VPWR VPWR _2539_ sky130_fd_sc_hd__or2_2
XFILLER_0_5_541 VPWR VGND VPWR VGND sky130_ef_sc_hd__decap_12
XFILLER_0_32_105 VGND VGND VPWR VPWR sky130_fd_sc_hd__decap_3
XFILLER_0_103_505 VGND VGND VPWR VPWR sky130_fd_sc_hd__fill_1
XFILLER_0_60_425 VGND VGND VPWR VPWR sky130_fd_sc_hd__fill_2
X_5577_ u_pe_array.g_pe_row\[1\].g_pe_col\[0\].u_pe.act_val\[0\] u_pe_array.g_pe_row\[1\].g_pe_col\[0\].u_pe.w_reg\[0\]
+ u_pe_array.g_pe_row\[1\].g_pe_col\[0\].u_pe.psum_out\[0\] VGND VGND VPWR VPWR _2476_
+ sky130_fd_sc_hd__a21o_1
Xhold220 u_pe_array.u_fifo2.buffer\[0\]\[12\] VGND VGND VPWR VPWR net296 sky130_fd_sc_hd__dlygate4sd3_1
XFILLER_0_5_585 VPWR VGND VPWR VGND sky130_ef_sc_hd__decap_12
XANTENNA__4788__S _1796_ VGND VGND VPWR VPWR sky130_fd_sc_hd__diode_2
Xhold242 u_pe_array.u_fifo1.buffer\[8\]\[8\] VGND VGND VPWR VPWR net318 sky130_fd_sc_hd__dlygate4sd3_1
Xhold253 u_pe_array.u_fifo1.buffer\[3\]\[8\] VGND VGND VPWR VPWR net329 sky130_fd_sc_hd__dlygate4sd3_1
Xhold231 u_pe_array.u_fifo2.buffer\[1\]\[9\] VGND VGND VPWR VPWR net307 sky130_fd_sc_hd__dlygate4sd3_1
X_4528_ _1273_ _1599_ _1601_ _1534_ net444 VGND VGND VPWR VPWR _0170_ sky130_fd_sc_hd__a32o_1
X_7316_ clknet_leaf_79_clk _0373_ net814 VGND VGND VPWR VPWR u_pe_array.g_pe_row\[0\].g_pe_col\[3\].u_pe.psum_out\[0\]
+ sky130_fd_sc_hd__dfrtp_1
Xhold286 u_pe_array.u_fifo1.buffer\[8\]\[10\] VGND VGND VPWR VPWR net362 sky130_fd_sc_hd__dlygate4sd3_1
Xhold275 u_pe_array.g_pe_row\[2\].g_pe_col\[0\].u_pe.psum_out\[0\] VGND VGND VPWR
+ VPWR net351 sky130_fd_sc_hd__dlygate4sd3_1
Xhold264 u_pe_array.u_fifo1.buffer\[2\]\[10\] VGND VGND VPWR VPWR net340 sky130_fd_sc_hd__dlygate4sd3_1
X_7247_ clknet_leaf_54_clk _0310_ net75 VGND VGND VPWR VPWR u_pe_array.g_pe_row\[1\].g_pe_col\[0\].u_pe.move_reg\[6\]
+ sky130_fd_sc_hd__dfrtp_1
X_4459_ _1535_ _1537_ VGND VGND VPWR VPWR _1538_ sky130_fd_sc_hd__xor2_1
Xhold297 u_pe_array.u_fifo2.buffer\[7\]\[11\] VGND VGND VPWR VPWR net373 sky130_fd_sc_hd__dlygate4sd3_1
X_7178_ clknet_leaf_39_clk _0245_ net813 VGND VGND VPWR VPWR u_pe_array.g_pe_row\[2\].g_pe_col\[0\].u_pe.psum_out\[12\]
+ sky130_fd_sc_hd__dfrtp_1
X_6129_ _2937_ VGND VGND VPWR VPWR _2938_ sky130_fd_sc_hd__inv_2
XANTENNA__5412__S _1661_ VGND VGND VPWR VPWR sky130_fd_sc_hd__diode_2
XANTENNA__6508__S _3208_ VGND VGND VPWR VPWR sky130_fd_sc_hd__diode_2
XTAP_580 VGND VPWR sky130_fd_sc_hd__tapvpwrvgnd_1
XTAP_591 VGND VPWR sky130_fd_sc_hd__tapvpwrvgnd_1
XANTENNA__7270__RESET_B net75 VGND VGND VPWR VPWR sky130_fd_sc_hd__diode_2
XFILLER_0_95_300 VPWR VGND VPWR VGND sky130_ef_sc_hd__decap_12
XFILLER_0_68_503 VGND VGND VPWR VPWR sky130_fd_sc_hd__fill_2
XANTENNA__4805__B1 _1655_ VGND VGND VPWR VPWR sky130_fd_sc_hd__diode_2
XFILLER_0_95_322 VPWR VGND VPWR VGND sky130_ef_sc_hd__decap_12
XFILLER_0_95_377 VGND VGND VPWR VPWR sky130_fd_sc_hd__fill_1
XANTENNA__3792__B1 _0837_ VGND VGND VPWR VPWR sky130_fd_sc_hd__diode_2
XFILLER_0_36_477 VGND VGND VPWR VPWR sky130_fd_sc_hd__fill_2
XFILLER_0_63_296 VGND VGND VPWR VPWR sky130_fd_sc_hd__fill_1
XFILLER_0_24_639 VGND VGND VPWR VPWR sky130_fd_sc_hd__fill_2
XFILLER_0_23_149 VGND VGND VPWR VPWR sky130_fd_sc_hd__fill_2
XFILLER_0_31_193 VGND VGND VPWR VPWR sky130_fd_sc_hd__decap_4
XANTENNA__7358__RESET_B net818 VGND VGND VPWR VPWR sky130_fd_sc_hd__diode_2
XANTENNA__4727__A _1672_ VGND VGND VPWR VPWR sky130_fd_sc_hd__diode_2
XFILLER_0_99_661 VGND VGND VPWR VPWR sky130_fd_sc_hd__decap_8
XFILLER_0_59_547 VGND VGND VPWR VPWR sky130_fd_sc_hd__fill_1
XFILLER_0_52_13 VPWR VGND VPWR VGND sky130_ef_sc_hd__decap_12
XANTENNA__3777__S _0828_ VGND VGND VPWR VPWR sky130_fd_sc_hd__diode_2
XANTENNA__6993__RESET_B net817 VGND VGND VPWR VPWR sky130_fd_sc_hd__diode_2
X_3830_ u_pe_array.g_pe_row\[3\].g_pe_col\[2\].u_pe.act_val\[0\] VGND VGND VPWR VPWR
+ _1020_ sky130_fd_sc_hd__inv_2
XANTENNA__5277__B _2158_ VGND VGND VPWR VPWR sky130_fd_sc_hd__diode_2
XANTENNA__6922__RESET_B net73 VGND VGND VPWR VPWR sky130_fd_sc_hd__diode_2
X_3761_ _0959_ _0969_ _0970_ VGND VGND VPWR VPWR _0971_ sky130_fd_sc_hd__a21oi_1
X_5500_ u_pe_array.g_pe_row\[1\].g_pe_col\[1\].u_pe.psum_out\[7\] VGND VGND VPWR VPWR
+ _2419_ sky130_fd_sc_hd__inv_2
XANTENNA__3783__B1 _0837_ VGND VGND VPWR VPWR sky130_fd_sc_hd__diode_2
XFILLER_0_15_617 VGND VGND VPWR VPWR sky130_fd_sc_hd__fill_2
X_3692_ u_pe_array.g_pe_row\[3\].g_pe_col\[3\].u_pe.psum_out\[3\] _0891_ _0892_ VGND
+ VGND VPWR VPWR _0908_ sky130_fd_sc_hd__a21o_1
X_6480_ _3204_ VGND VGND VPWR VPWR _0519_ sky130_fd_sc_hd__clkbuf_1
X_5431_ _2354_ _2355_ VGND VGND VPWR VPWR _2356_ sky130_fd_sc_hd__xnor2_1
XANTENNA__6389__A _0819_ VGND VGND VPWR VPWR sky130_fd_sc_hd__diode_2
XFILLER_0_2_533 VPWR VGND VPWR VGND sky130_ef_sc_hd__decap_12
XFILLER_0_112_357 VGND VGND VPWR VPWR sky130_fd_sc_hd__decap_6
X_5362_ _0836_ _2298_ _2300_ _0833_ net594 VGND VGND VPWR VPWR _0305_ sky130_fd_sc_hd__a32o_1
XANTENNA__3525__B _0770_ VGND VGND VPWR VPWR sky130_fd_sc_hd__diode_2
X_4313_ _1418_ u_pe_array.g_pe_row\[2\].g_pe_col\[3\].u_pe.psum_out\[1\] _1407_ VGND
+ VGND VPWR VPWR _1419_ sky130_fd_sc_hd__o21a_1
X_7101_ clknet_leaf_87_clk _0172_ net819 VGND VGND VPWR VPWR u_pe_array.g_pe_row\[2\].g_pe_col\[2\].u_pe.psum_out\[8\]
+ sky130_fd_sc_hd__dfrtp_2
X_7032_ clknet_leaf_32_clk net77 net817 VGND VGND VPWR VPWR u_pe_array.g_pe_row\[3\].g_pe_col\[0\].u_pe.w_reg\[1\]
+ sky130_fd_sc_hd__dfrtp_1
X_5293_ _2231_ _2234_ _2239_ VGND VGND VPWR VPWR _2240_ sky130_fd_sc_hd__a21oi_2
X_4244_ _1275_ u_pe_array.g_pe_row\[3\].g_pe_col\[0\].u_pe.psum_out\[10\] VGND VGND
+ VPWR VPWR _1370_ sky130_fd_sc_hd__or2_1
XANTENNA__7099__RESET_B net819 VGND VGND VPWR VPWR sky130_fd_sc_hd__diode_2
X_4175_ _1275_ _1306_ u_pe_array.g_pe_row\[3\].g_pe_col\[0\].u_pe.act_val\[4\] u_pe_array.g_pe_row\[3\].g_pe_col\[0\].u_pe.w_reg\[0\]
+ VGND VGND VPWR VPWR _1307_ sky130_fd_sc_hd__a22o_1
XANTENNA__7028__RESET_B net815 VGND VGND VPWR VPWR sky130_fd_sc_hd__diode_2
XFILLER_0_93_53 VGND VGND VPWR VPWR sky130_fd_sc_hd__decap_3
XFILLER_0_96_119 VGND VGND VPWR VPWR sky130_fd_sc_hd__decap_4
XFILLER_0_93_86 VGND VGND VPWR VPWR sky130_fd_sc_hd__fill_1
XFILLER_0_77_333 VGND VGND VPWR VPWR sky130_fd_sc_hd__decap_3
XTAP_1009 VGND VPWR sky130_fd_sc_hd__tapvpwrvgnd_1
X_6816_ net261 _3122_ _3382_ VGND VGND VPWR VPWR _3389_ sky130_fd_sc_hd__mux2_1
XFILLER_0_92_325 VGND VGND VPWR VPWR sky130_fd_sc_hd__fill_1
X_6747_ _3106_ _3300_ _3323_ VGND VGND VPWR VPWR _3352_ sky130_fd_sc_hd__nor3_1
X_3959_ net710 _0996_ _0837_ _1131_ VGND VGND VPWR VPWR _0071_ sky130_fd_sc_hd__a22o_1
X_6678_ _3312_ VGND VGND VPWR VPWR _3313_ sky130_fd_sc_hd__inv_2
XFILLER_0_33_425 VGND VGND VPWR VPWR sky130_fd_sc_hd__fill_2
X_5629_ u_pe_array.g_pe_row\[1\].g_pe_col\[0\].u_pe.act_val\[4\] _2478_ VGND VGND
+ VPWR VPWR _2523_ sky130_fd_sc_hd__and2b_1
XFILLER_0_5_393 VGND VGND VPWR VPWR sky130_fd_sc_hd__fill_2
XFILLER_0_20_119 VGND VGND VPWR VPWR sky130_fd_sc_hd__decap_3
XFILLER_0_13_182 VGND VGND VPWR VPWR sky130_fd_sc_hd__fill_2
XANTENNA__4547__A net72 VGND VGND VPWR VPWR sky130_fd_sc_hd__diode_2
XFILLER_0_87_108 VGND VGND VPWR VPWR sky130_fd_sc_hd__fill_2
XANTENNA__5451__B1 _2174_ VGND VGND VPWR VPWR sky130_fd_sc_hd__diode_2
XTAP_1532 VGND VPWR sky130_fd_sc_hd__tapvpwrvgnd_1
XTAP_1510 VGND VPWR sky130_fd_sc_hd__tapvpwrvgnd_1
XTAP_1521 VGND VPWR sky130_fd_sc_hd__tapvpwrvgnd_1
XFILLER_0_68_355 VGND VGND VPWR VPWR sky130_fd_sc_hd__fill_2
XFILLER_0_68_333 VGND VGND VPWR VPWR sky130_fd_sc_hd__fill_2
XTAP_1576 VGND VPWR sky130_fd_sc_hd__tapvpwrvgnd_1
XTAP_1565 VGND VPWR sky130_fd_sc_hd__tapvpwrvgnd_1
XTAP_1554 VGND VPWR sky130_fd_sc_hd__tapvpwrvgnd_1
XTAP_1543 VGND VPWR sky130_fd_sc_hd__tapvpwrvgnd_1
XFILLER_0_56_517 VGND VGND VPWR VPWR sky130_fd_sc_hd__decap_4
XPHY_50 VGND VGND VPWR VPWR sky130_fd_sc_hd__decap_3
XPHY_61 VGND VGND VPWR VPWR sky130_fd_sc_hd__decap_3
XPHY_72 VGND VGND VPWR VPWR sky130_fd_sc_hd__decap_3
XPHY_83 VGND VGND VPWR VPWR sky130_fd_sc_hd__decap_3
XTAP_1587 VGND VPWR sky130_fd_sc_hd__tapvpwrvgnd_1
XTAP_1598 VGND VPWR sky130_fd_sc_hd__tapvpwrvgnd_1
XPHY_94 VGND VGND VPWR VPWR sky130_fd_sc_hd__decap_3
XFILLER_0_22_38 VGND VGND VPWR VPWR sky130_fd_sc_hd__fill_2
XFILLER_0_107_641 VPWR VGND VPWR VGND sky130_ef_sc_hd__decap_12
XFILLER_0_24_414 VGND VGND VPWR VPWR sky130_fd_sc_hd__fill_2
XFILLER_0_51_277 VGND VGND VPWR VPWR sky130_fd_sc_hd__fill_1
XFILLER_0_20_642 VGND VGND VPWR VPWR sky130_fd_sc_hd__fill_2
XANTENNA__7539__RESET_B net815 VGND VGND VPWR VPWR sky130_fd_sc_hd__diode_2
XANTENNA_output60_A net60 VGND VGND VPWR VPWR sky130_fd_sc_hd__diode_2
XANTENNA__7192__RESET_B net812 VGND VGND VPWR VPWR sky130_fd_sc_hd__diode_2
XANTENNA__7121__RESET_B net816 VGND VGND VPWR VPWR sky130_fd_sc_hd__diode_2
XFILLER_0_2_15 VPWR VGND VPWR VGND sky130_ef_sc_hd__decap_12
XANTENNA__4176__B _1275_ VGND VGND VPWR VPWR sky130_fd_sc_hd__diode_2
X_5980_ _2808_ _2814_ VGND VGND VPWR VPWR _2816_ sky130_fd_sc_hd__or2_1
X_4931_ _1930_ _1931_ VGND VGND VPWR VPWR _1933_ sky130_fd_sc_hd__nor2_1
X_7650_ clknet_leaf_25_clk _0699_ VGND VGND VPWR VPWR u_pe_array.u_fifo1.buffer\[6\]\[8\]
+ sky130_fd_sc_hd__dfxtp_1
X_4862_ u_pe_array.g_pe_row\[2\].g_pe_col\[0\].u_pe.psum_out\[3\] _1869_ VGND VGND
+ VPWR VPWR _1870_ sky130_fd_sc_hd__xor2_1
X_3813_ u_pe_array.g_pe_row\[3\].g_pe_col\[2\].u_pe.psum_out\[12\] u_pe_array.g_pe_row\[3\].g_pe_col\[2\].u_pe.move_reg\[12\]
+ _0734_ VGND VGND VPWR VPWR _1006_ sky130_fd_sc_hd__mux2_1
X_6601_ net539 _1788_ _3269_ VGND VGND VPWR VPWR _3270_ sky130_fd_sc_hd__mux2_1
XFILLER_0_103_51 VGND VGND VPWR VPWR sky130_fd_sc_hd__decap_4
X_7581_ clknet_leaf_22_clk _0630_ VGND VGND VPWR VPWR u_pe_array.u_fifo1.buffer\[1\]\[4\]
+ sky130_fd_sc_hd__dfxtp_1
XFILLER_0_55_561 VGND VGND VPWR VPWR sky130_fd_sc_hd__fill_2
X_4793_ u_pe_array.g_pe_row\[2\].g_pe_col\[2\].u_pe.move_reg\[12\] _1006_ _0747_ VGND
+ VGND VPWR VPWR _1820_ sky130_fd_sc_hd__mux2_4
XFILLER_0_15_403 VGND VGND VPWR VPWR sky130_fd_sc_hd__fill_1
X_6532_ _3232_ VGND VGND VPWR VPWR _0543_ sky130_fd_sc_hd__clkbuf_1
X_3744_ _0947_ _0950_ _0955_ VGND VGND VPWR VPWR _0956_ sky130_fd_sc_hd__a21oi_2
XANTENNA__6611__S _3269_ VGND VGND VPWR VPWR sky130_fd_sc_hd__diode_2
XFILLER_0_42_222 VPWR VGND VPWR VGND sky130_ef_sc_hd__decap_12
XFILLER_0_70_553 VGND VGND VPWR VPWR sky130_fd_sc_hd__fill_2
X_3675_ u_pe_array.g_pe_row\[3\].g_pe_col\[3\].u_pe.act_val\[2\] u_pe_array.g_pe_row\[3\].g_pe_col\[3\].u_pe.act_val\[3\]
+ u_pe_array.g_pe_row\[3\].g_pe_col\[3\].u_pe.w_reg\[0\] _0869_ VGND VGND VPWR VPWR
+ _0892_ sky130_fd_sc_hd__and4b_1
X_6463_ net457 _1798_ net67 VGND VGND VPWR VPWR _3196_ sky130_fd_sc_hd__mux2_1
XANTENNA__6170__A1 _0914_ VGND VGND VPWR VPWR sky130_fd_sc_hd__diode_2
X_5414_ u_pe_array.g_pe_row\[1\].g_pe_col\[1\].u_pe.w_reg\[0\] u_pe_array.g_pe_row\[1\].g_pe_col\[1\].u_pe.act_val\[0\]
+ u_pe_array.g_pe_row\[1\].g_pe_col\[1\].u_pe.psum_out\[0\] VGND VGND VPWR VPWR _2341_
+ sky130_fd_sc_hd__a21o_1
X_6394_ _3156_ u_pe_array.u_fifo2.count\[0\] u_pe_array.u_fifo2.count\[3\] _1787_
+ u_pe_array.u_fifo2.count\[1\] VGND VGND VPWR VPWR _3157_ sky130_fd_sc_hd__a41o_1
X_5345_ u_pe_array.u_fifo1.rd_ptr\[0\] _2271_ u_pe_array.u_fifo1.rd_ptr\[2\] u_pe_array.u_fifo1.rd_ptr\[1\]
+ VGND VGND VPWR VPWR _2285_ sky130_fd_sc_hd__and4b_2
XFILLER_0_56_3 VPWR VGND VPWR VGND sky130_ef_sc_hd__decap_12
XFILLER_0_11_653 VPWR VGND VPWR VGND sky130_ef_sc_hd__decap_12
XFILLER_0_2_385 VGND VGND VPWR VPWR sky130_fd_sc_hd__fill_1
XANTENNA__7209__RESET_B net815 VGND VGND VPWR VPWR sky130_fd_sc_hd__diode_2
X_5276_ u_pe_array.g_pe_row\[1\].g_pe_col\[2\].u_pe.psum_out\[7\] _2158_ VGND VGND
+ VPWR VPWR _2224_ sky130_fd_sc_hd__nand2_1
X_4227_ _1353_ _1354_ VGND VGND VPWR VPWR _1355_ sky130_fd_sc_hd__or2_1
X_7015_ clknet_leaf_83_clk _0092_ net818 VGND VGND VPWR VPWR u_pe_array.g_pe_row\[3\].g_pe_col\[1\].u_pe.psum_out\[12\]
+ sky130_fd_sc_hd__dfrtp_1
X_4158_ _1283_ _1287_ VGND VGND VPWR VPWR _1291_ sky130_fd_sc_hd__nor2_1
X_4089_ _1241_ _1242_ net779 _0916_ VGND VGND VPWR VPWR _0090_ sky130_fd_sc_hd__a2bb2o_1
XFILLER_0_78_653 VGND VGND VPWR VPWR sky130_fd_sc_hd__fill_1
XFILLER_0_93_623 VGND VGND VPWR VPWR sky130_fd_sc_hd__fill_2
XFILLER_0_92_100 VGND VGND VPWR VPWR sky130_fd_sc_hd__decap_3
XFILLER_0_77_174 VGND VGND VPWR VPWR sky130_fd_sc_hd__fill_2
XFILLER_0_65_303 VGND VGND VPWR VPWR sky130_fd_sc_hd__fill_1
XFILLER_0_38_506 VGND VGND VPWR VPWR sky130_fd_sc_hd__decap_8
XFILLER_0_108_405 VGND VGND VPWR VPWR sky130_fd_sc_hd__fill_2
XFILLER_0_80_306 VGND VGND VPWR VPWR sky130_fd_sc_hd__fill_2
XFILLER_0_18_230 VGND VGND VPWR VPWR sky130_fd_sc_hd__fill_1
XFILLER_0_46_583 VGND VGND VPWR VPWR sky130_fd_sc_hd__decap_4
XANTENNA__3747__B1 _0861_ VGND VGND VPWR VPWR sky130_fd_sc_hd__diode_2
XANTENNA__6521__S _3224_ VGND VGND VPWR VPWR sky130_fd_sc_hd__diode_2
XFILLER_0_103_121 VGND VGND VPWR VPWR sky130_fd_sc_hd__decap_3
XANTENNA__4172__B1 _0887_ VGND VGND VPWR VPWR sky130_fd_sc_hd__diode_2
XFILLER_0_108_29 VPWR VGND VPWR VGND sky130_ef_sc_hd__decap_12
XFILLER_0_33_15 VGND VGND VPWR VPWR sky130_fd_sc_hd__decap_4
XTAP_1340 VGND VPWR sky130_fd_sc_hd__tapvpwrvgnd_1
XFILLER_0_68_141 VGND VGND VPWR VPWR sky130_fd_sc_hd__fill_2
XTAP_1384 VGND VPWR sky130_fd_sc_hd__tapvpwrvgnd_1
XTAP_1373 VGND VPWR sky130_fd_sc_hd__tapvpwrvgnd_1
XTAP_1351 VGND VPWR sky130_fd_sc_hd__tapvpwrvgnd_1
XTAP_1362 VGND VPWR sky130_fd_sc_hd__tapvpwrvgnd_1
XFILLER_0_84_645 VGND VGND VPWR VPWR sky130_fd_sc_hd__decap_3
XTAP_1395 VGND VPWR sky130_fd_sc_hd__tapvpwrvgnd_1
XANTENNA__4162__D _1275_ VGND VGND VPWR VPWR sky130_fd_sc_hd__diode_2
XFILLER_0_37_561 VGND VGND VPWR VPWR sky130_fd_sc_hd__fill_2
XANTENNA__5727__B2 _2336_ VGND VGND VPWR VPWR sky130_fd_sc_hd__diode_2
Xinput13 rst_n VGND VGND VPWR VPWR net13 sky130_fd_sc_hd__clkbuf_16
XFILLER_0_24_211 VPWR VGND VPWR VGND sky130_ef_sc_hd__decap_12
XFILLER_0_37_572 VGND VGND VPWR VPWR sky130_fd_sc_hd__fill_2
Xinput24 v_in1[3] VGND VGND VPWR VPWR net24 sky130_fd_sc_hd__buf_1
XFILLER_0_3_105 VGND VGND VPWR VPWR sky130_fd_sc_hd__decap_6
XFILLER_0_107_493 VGND VGND VPWR VPWR sky130_fd_sc_hd__fill_2
XFILLER_0_3_149 VPWR VGND VPWR VGND sky130_ef_sc_hd__decap_12
XFILLER_0_12_428 VGND VGND VPWR VPWR sky130_fd_sc_hd__decap_3
XANTENNA__7373__RESET_B net812 VGND VGND VPWR VPWR sky130_fd_sc_hd__diode_2
X_3460_ _0733_ VGND VGND VPWR VPWR _0734_ sky130_fd_sc_hd__clkbuf_8
XFILLER_0_110_625 VPWR VGND VPWR VGND sky130_ef_sc_hd__decap_12
XANTENNA__7302__RESET_B net814 VGND VGND VPWR VPWR sky130_fd_sc_hd__diode_2
XANTENNA__3790__S _0745_ VGND VGND VPWR VPWR sky130_fd_sc_hd__diode_2
XFILLER_0_110_669 VGND VGND VPWR VPWR sky130_fd_sc_hd__decap_8
X_5130_ _2029_ u_pe_array.g_pe_row\[1\].g_pe_col\[3\].u_pe.psum_out\[8\] VGND VGND
+ VPWR VPWR _2105_ sky130_fd_sc_hd__nand2_1
X_5061_ _2039_ _2041_ VGND VGND VPWR VPWR _2042_ sky130_fd_sc_hd__xnor2_2
X_4012_ _1163_ _1170_ _1172_ VGND VGND VPWR VPWR _1173_ sky130_fd_sc_hd__or3_1
XANTENNA_clkbuf_leaf_74_clk_A clknet_3_4__leaf_clk VGND VGND VPWR VPWR sky130_fd_sc_hd__diode_2
XFILLER_0_28_7 VGND VGND VPWR VPWR sky130_fd_sc_hd__fill_1
XFILLER_0_90_21 VGND VGND VPWR VPWR sky130_fd_sc_hd__fill_1
X_5963_ u_pe_array.g_pe_row\[0\].g_pe_col\[2\].u_pe.psum_out\[5\] _2743_ VGND VGND
+ VPWR VPWR _2800_ sky130_fd_sc_hd__nand2_1
X_4914_ _1725_ _1916_ _1917_ _1534_ u_pe_array.g_pe_row\[2\].g_pe_col\[0\].u_pe.psum_out\[7\]
+ VGND VGND VPWR VPWR _0240_ sky130_fd_sc_hd__a32o_1
XANTENNA__4126__S _0855_ VGND VGND VPWR VPWR sky130_fd_sc_hd__diode_2
X_5894_ _0832_ VGND VGND VPWR VPWR _2738_ sky130_fd_sc_hd__buf_6
XANTENNA_clkbuf_leaf_89_clk_A clknet_3_1__leaf_clk VGND VGND VPWR VPWR sky130_fd_sc_hd__diode_2
X_4845_ u_pe_array.g_pe_row\[2\].g_pe_col\[0\].u_pe.psum_out\[1\] _1850_ _1853_ VGND
+ VGND VPWR VPWR _1854_ sky130_fd_sc_hd__a21o_1
XANTENNA__3965__S _0755_ VGND VGND VPWR VPWR sky130_fd_sc_hd__diode_2
X_7633_ clknet_leaf_23_clk _0682_ VGND VGND VPWR VPWR u_pe_array.u_fifo1.buffer\[5\]\[4\]
+ sky130_fd_sc_hd__dfxtp_1
XFILLER_0_90_626 VGND VGND VPWR VPWR sky130_fd_sc_hd__fill_2
XANTENNA__6341__S _3110_ VGND VGND VPWR VPWR sky130_fd_sc_hd__diode_2
X_7564_ clknet_leaf_21_clk _0613_ VGND VGND VPWR VPWR u_pe_array.u_fifo1.buffer\[0\]\[0\]
+ sky130_fd_sc_hd__dfxtp_1
XANTENNA__5194__A2 _2144_ VGND VGND VPWR VPWR sky130_fd_sc_hd__diode_2
X_4776_ _1808_ net368 _1796_ VGND VGND VPWR VPWR _1809_ sky130_fd_sc_hd__mux2_1
XFILLER_0_15_211 VGND VGND VPWR VPWR sky130_fd_sc_hd__decap_4
XFILLER_0_28_583 VGND VGND VPWR VPWR sky130_fd_sc_hd__decap_4
XFILLER_0_99_63 VGND VGND VPWR VPWR sky130_fd_sc_hd__fill_1
XANTENNA_clkbuf_leaf_12_clk_A clknet_3_1__leaf_clk VGND VGND VPWR VPWR sky130_fd_sc_hd__diode_2
X_6515_ _1793_ _3222_ VGND VGND VPWR VPWR _3223_ sky130_fd_sc_hd__and2_1
XFILLER_0_7_477 VPWR VGND VPWR VGND sky130_ef_sc_hd__decap_12
X_3727_ u_pe_array.g_pe_row\[3\].g_pe_col\[3\].u_pe.psum_out\[7\] _0869_ VGND VGND
+ VPWR VPWR _0940_ sky130_fd_sc_hd__nand2_1
XFILLER_0_113_441 VGND VGND VPWR VPWR sky130_fd_sc_hd__decap_6
XFILLER_0_70_361 VGND VGND VPWR VPWR sky130_fd_sc_hd__decap_3
X_7495_ clknet_leaf_93_clk _0544_ VGND VGND VPWR VPWR u_pe_array.u_fifo2.buffer\[4\]\[8\]
+ sky130_fd_sc_hd__dfxtp_1
XFILLER_0_15_288 VGND VGND VPWR VPWR sky130_fd_sc_hd__fill_2
XFILLER_0_101_603 VGND VGND VPWR VPWR sky130_fd_sc_hd__decap_4
X_3658_ _0859_ _0871_ VGND VGND VPWR VPWR _0876_ sky130_fd_sc_hd__and2_1
X_6446_ net305 _1808_ net68 VGND VGND VPWR VPWR _3187_ sky130_fd_sc_hd__mux2_1
XFILLER_0_113_485 VPWR VGND VPWR VGND sky130_ef_sc_hd__decap_12
XANTENNA__4796__S _0828_ VGND VGND VPWR VPWR sky130_fd_sc_hd__diode_2
XFILLER_0_101_625 VGND VGND VPWR VPWR sky130_fd_sc_hd__fill_1
XANTENNA__7043__RESET_B net817 VGND VGND VPWR VPWR sky130_fd_sc_hd__diode_2
X_6377_ net200 _3142_ _3145_ VGND VGND VPWR VPWR _0475_ sky130_fd_sc_hd__a21oi_1
X_3589_ u_fsm.v_cnt\[0\] u_fsm.v_cnt\[1\] _0820_ u_fsm.v_cnt\[2\] VGND VGND VPWR VPWR
+ _0825_ sky130_fd_sc_hd__a31o_1
XFILLER_0_30_269 VGND VGND VPWR VPWR sky130_fd_sc_hd__decap_4
X_5328_ _2269_ VGND VGND VPWR VPWR _0302_ sky130_fd_sc_hd__clkbuf_1
XANTENNA_clkbuf_leaf_27_clk_A clknet_3_2__leaf_clk VGND VGND VPWR VPWR sky130_fd_sc_hd__diode_2
X_5259_ _2196_ _2199_ _2208_ VGND VGND VPWR VPWR _2209_ sky130_fd_sc_hd__o21ai_1
XFILLER_0_97_203 VGND VGND VPWR VPWR sky130_fd_sc_hd__fill_2
XFILLER_0_97_247 VGND VGND VPWR VPWR sky130_fd_sc_hd__fill_2
XFILLER_0_93_431 VGND VGND VPWR VPWR sky130_fd_sc_hd__fill_1
XFILLER_0_66_645 VGND VGND VPWR VPWR sky130_fd_sc_hd__fill_2
XFILLER_0_65_111 VGND VGND VPWR VPWR sky130_fd_sc_hd__fill_1
XFILLER_0_38_347 VGND VGND VPWR VPWR sky130_fd_sc_hd__fill_2
XFILLER_0_93_475 VGND VGND VPWR VPWR sky130_fd_sc_hd__fill_2
XFILLER_0_65_155 VGND VGND VPWR VPWR sky130_fd_sc_hd__decap_4
XFILLER_0_81_637 VGND VGND VPWR VPWR sky130_fd_sc_hd__fill_2
XFILLER_0_53_317 VGND VGND VPWR VPWR sky130_fd_sc_hd__fill_2
XANTENNA__4560__A _1536_ VGND VGND VPWR VPWR sky130_fd_sc_hd__diode_2
XFILLER_0_104_463 VGND VGND VPWR VPWR sky130_fd_sc_hd__fill_1
XFILLER_0_104_496 VGND VGND VPWR VPWR sky130_fd_sc_hd__fill_1
XFILLER_0_0_119 VGND VGND VPWR VPWR sky130_fd_sc_hd__fill_1
XTAP_409 VGND VPWR sky130_fd_sc_hd__tapvpwrvgnd_1
XANTENNA__4448__B2 _1399_ VGND VGND VPWR VPWR sky130_fd_sc_hd__diode_2
XANTENNA__5948__A1 _2740_ VGND VGND VPWR VPWR sky130_fd_sc_hd__diode_2
XANTENNA__3959__B1 _0837_ VGND VGND VPWR VPWR sky130_fd_sc_hd__diode_2
XFILLER_0_69_483 VGND VGND VPWR VPWR sky130_fd_sc_hd__fill_2
XFILLER_0_60_13 VPWR VGND VPWR VGND sky130_ef_sc_hd__decap_12
XTAP_1192 VGND VPWR sky130_fd_sc_hd__tapvpwrvgnd_1
XTAP_1181 VGND VPWR sky130_fd_sc_hd__tapvpwrvgnd_1
XTAP_1170 VGND VPWR sky130_fd_sc_hd__tapvpwrvgnd_1
XFILLER_0_72_604 VGND VGND VPWR VPWR sky130_fd_sc_hd__fill_1
XANTENNA__3785__S _0754_ VGND VGND VPWR VPWR sky130_fd_sc_hd__diode_2
XFILLER_0_17_509 VGND VGND VPWR VPWR sky130_fd_sc_hd__decap_6
XFILLER_0_84_475 VGND VGND VPWR VPWR sky130_fd_sc_hd__fill_1
X_4630_ u_pe_array.g_pe_row\[2\].g_pe_col\[1\].u_pe.act_val\[0\] _1671_ _1672_ VGND
+ VGND VPWR VPWR _1680_ sky130_fd_sc_hd__a21bo_1
XFILLER_0_71_103 VGND VGND VPWR VPWR sky130_fd_sc_hd__fill_2
XFILLER_0_44_317 VGND VGND VPWR VPWR sky130_fd_sc_hd__fill_2
XANTENNA__7554__RESET_B net816 VGND VGND VPWR VPWR sky130_fd_sc_hd__diode_2
XFILLER_0_4_403 VGND VGND VPWR VPWR sky130_fd_sc_hd__fill_2
XFILLER_0_37_391 VGND VGND VPWR VPWR sky130_fd_sc_hd__fill_1
X_6300_ u_pe_array.g_pe_row\[0\].g_pe_col\[0\].u_pe.psum_out\[10\] _2992_ VGND VGND
+ VPWR VPWR _3088_ sky130_fd_sc_hd__or2_1
XFILLER_0_69_22 VPWR VGND VPWR VGND sky130_ef_sc_hd__decap_12
XFILLER_0_52_350 VGND VGND VPWR VPWR sky130_fd_sc_hd__fill_2
XFILLER_0_8_36 VGND VGND VPWR VPWR sky130_fd_sc_hd__fill_2
X_4561_ _1536_ u_pe_array.g_pe_row\[2\].g_pe_col\[2\].u_pe.psum_out\[10\] VGND VGND
+ VPWR VPWR _1631_ sky130_fd_sc_hd__or2_1
XFILLER_0_40_501 VGND VGND VPWR VPWR sky130_fd_sc_hd__fill_2
X_4492_ _1536_ _1567_ u_pe_array.g_pe_row\[2\].g_pe_col\[2\].u_pe.act_val\[4\] u_pe_array.g_pe_row\[2\].g_pe_col\[2\].u_pe.w_reg\[0\]
+ VGND VGND VPWR VPWR _1568_ sky130_fd_sc_hd__a22o_1
X_3512_ _0768_ VGND VGND VPWR VPWR net44 sky130_fd_sc_hd__clkbuf_1
Xhold627 u_pe_array.g_pe_row\[1\].g_pe_col\[3\].u_pe.act_val\[5\] VGND VGND VPWR VPWR
+ net703 sky130_fd_sc_hd__dlygate4sd3_1
Xhold616 u_pe_array.g_pe_row\[3\].g_pe_col\[3\].u_pe.move_reg\[8\] VGND VGND VPWR
+ VPWR net692 sky130_fd_sc_hd__dlygate4sd3_1
Xhold605 u_pe_array.g_pe_row\[2\].g_pe_col\[2\].u_pe.psum_out\[9\] VGND VGND VPWR
+ VPWR net681 sky130_fd_sc_hd__dlygate4sd3_1
X_7280_ clknet_leaf_71_clk net137 net814 VGND VGND VPWR VPWR u_pe_array.g_pe_row\[0\].g_pe_col\[3\].u_pe.move_reg\[9\]
+ sky130_fd_sc_hd__dfrtp_1
X_6231_ _3023_ u_pe_array.g_pe_row\[0\].g_pe_col\[0\].u_pe.psum_out\[4\] _2992_ VGND
+ VGND VPWR VPWR _3025_ sky130_fd_sc_hd__and3_1
Xhold649 _0202_ VGND VGND VPWR VPWR net725 sky130_fd_sc_hd__dlygate4sd3_1
X_3443_ _0718_ u_fsm.state\[1\] VGND VGND VPWR VPWR _0719_ sky130_fd_sc_hd__and2_2
Xhold638 u_pe_array.g_pe_row\[1\].g_pe_col\[2\].u_pe.psum_out\[8\] VGND VGND VPWR
+ VPWR net714 sky130_fd_sc_hd__dlygate4sd3_1
X_6162_ _2873_ u_pe_array.g_pe_row\[0\].g_pe_col\[1\].u_pe.psum_out\[10\] VGND VGND
+ VPWR VPWR _2967_ sky130_fd_sc_hd__nand2_1
XTAP_910 VGND VPWR sky130_fd_sc_hd__tapvpwrvgnd_1
XFILLER_0_110_477 VGND VGND VPWR VPWR sky130_fd_sc_hd__decap_4
XTAP_943 VGND VPWR sky130_fd_sc_hd__tapvpwrvgnd_1
XTAP_932 VGND VPWR sky130_fd_sc_hd__tapvpwrvgnd_1
XTAP_921 VGND VPWR sky130_fd_sc_hd__tapvpwrvgnd_1
X_5113_ _2087_ _2089_ VGND VGND VPWR VPWR _2090_ sky130_fd_sc_hd__xor2_2
X_6093_ u_pe_array.g_pe_row\[0\].g_pe_col\[1\].u_pe.act_val\[3\] VGND VGND VPWR VPWR
+ _2904_ sky130_fd_sc_hd__inv_2
XTAP_987 VGND VPWR sky130_fd_sc_hd__tapvpwrvgnd_1
XTAP_976 VGND VPWR sky130_fd_sc_hd__tapvpwrvgnd_1
XTAP_954 VGND VPWR sky130_fd_sc_hd__tapvpwrvgnd_1
XTAP_965 VGND VPWR sky130_fd_sc_hd__tapvpwrvgnd_1
XTAP_998 VGND VPWR sky130_fd_sc_hd__tapvpwrvgnd_1
X_5044_ u_pe_array.g_pe_row\[1\].g_pe_col\[3\].u_pe.w_reg\[0\] u_pe_array.g_pe_row\[1\].g_pe_col\[3\].u_pe.act_val\[0\]
+ u_pe_array.g_pe_row\[1\].g_pe_col\[3\].u_pe.psum_out\[0\] VGND VGND VPWR VPWR _2027_
+ sky130_fd_sc_hd__a21o_1
XFILLER_0_79_225 VGND VGND VPWR VPWR sky130_fd_sc_hd__decap_3
X_6995_ clknet_leaf_29_clk _0074_ net817 VGND VGND VPWR VPWR u_pe_array.g_pe_row\[3\].g_pe_col\[0\].u_pe.move_reg\[7\]
+ sky130_fd_sc_hd__dfrtp_1
XFILLER_0_67_409 VPWR VGND VPWR VGND sky130_ef_sc_hd__decap_12
X_5946_ _2783_ _2784_ VGND VGND VPWR VPWR _2785_ sky130_fd_sc_hd__nand2_1
X_5877_ net658 _2600_ _2592_ _2729_ VGND VGND VPWR VPWR _0391_ sky130_fd_sc_hd__a22o_1
XFILLER_0_75_453 VGND VGND VPWR VPWR sky130_fd_sc_hd__fill_2
XFILLER_0_63_604 VGND VGND VPWR VPWR sky130_fd_sc_hd__fill_2
X_7616_ clknet_leaf_21_clk _0665_ VGND VGND VPWR VPWR u_pe_array.u_fifo1.buffer\[4\]\[0\]
+ sky130_fd_sc_hd__dfxtp_1
XFILLER_0_47_166 VGND VGND VPWR VPWR sky130_fd_sc_hd__fill_2
X_4828_ net596 _0833_ VGND VGND VPWR VPWR _1841_ sky130_fd_sc_hd__and2_1
XFILLER_0_35_306 VGND VGND VPWR VPWR sky130_fd_sc_hd__fill_2
XANTENNA__7295__RESET_B net75 VGND VGND VPWR VPWR sky130_fd_sc_hd__diode_2
XANTENNA__4375__B1 _1144_ VGND VGND VPWR VPWR sky130_fd_sc_hd__diode_2
XANTENNA__5167__A2 _1714_ VGND VGND VPWR VPWR sky130_fd_sc_hd__diode_2
XANTENNA__7224__RESET_B net73 VGND VGND VPWR VPWR sky130_fd_sc_hd__diode_2
XFILLER_0_16_575 VGND VGND VPWR VPWR sky130_fd_sc_hd__decap_6
X_7547_ clknet_leaf_78_clk _0596_ net815 VGND VGND VPWR VPWR u_pe_array.g_pe_row\[3\].g_pe_col\[3\].u_pe.move_reg\[8\]
+ sky130_fd_sc_hd__dfrtp_1
X_4759_ _1797_ VGND VGND VPWR VPWR _0205_ sky130_fd_sc_hd__clkbuf_1
XFILLER_0_70_180 VGND VGND VPWR VPWR sky130_fd_sc_hd__fill_1
X_7478_ clknet_leaf_1_clk _0527_ VGND VGND VPWR VPWR u_pe_array.u_fifo2.buffer\[3\]\[4\]
+ sky130_fd_sc_hd__dfxtp_1
XFILLER_0_31_545 VGND VGND VPWR VPWR sky130_fd_sc_hd__decap_6
X_6429_ net332 _1818_ net70 VGND VGND VPWR VPWR _3178_ sky130_fd_sc_hd__mux2_1
XFILLER_0_101_444 VGND VGND VPWR VPWR sky130_fd_sc_hd__decap_4
XFILLER_0_101_433 VGND VGND VPWR VPWR sky130_fd_sc_hd__fill_2
XANTENNA__5875__B1 _2592_ VGND VGND VPWR VPWR sky130_fd_sc_hd__diode_2
XANTENNA__5627__B1 _2071_ VGND VGND VPWR VPWR sky130_fd_sc_hd__diode_2
XFILLER_0_98_545 VGND VGND VPWR VPWR sky130_fd_sc_hd__fill_2
XFILLER_0_98_589 VGND VGND VPWR VPWR sky130_fd_sc_hd__decap_4
XFILLER_0_66_431 VGND VGND VPWR VPWR sky130_fd_sc_hd__fill_2
XPHY_220 VGND VGND VPWR VPWR sky130_fd_sc_hd__decap_3
XANTENNA__4602__B2 _1399_ VGND VGND VPWR VPWR sky130_fd_sc_hd__diode_2
XFILLER_0_81_401 VGND VGND VPWR VPWR sky130_fd_sc_hd__fill_1
XFILLER_0_38_177 VGND VGND VPWR VPWR sky130_fd_sc_hd__decap_8
XANTENNA__6355__A1 _1787_ VGND VGND VPWR VPWR sky130_fd_sc_hd__diode_2
XFILLER_0_81_445 VGND VGND VPWR VPWR sky130_fd_sc_hd__decap_3
XFILLER_0_30_27 VGND VGND VPWR VPWR sky130_fd_sc_hd__fill_1
XFILLER_0_22_501 VGND VGND VPWR VPWR sky130_fd_sc_hd__decap_4
XFILLER_0_1_417 VPWR VGND VPWR VGND sky130_ef_sc_hd__decap_12
XANTENNA__6947__RESET_B net815 VGND VGND VPWR VPWR sky130_fd_sc_hd__diode_2
XANTENNA__5866__A0 net31 VGND VGND VPWR VPWR sky130_fd_sc_hd__diode_2
XFILLER_0_39_47 VGND VGND VPWR VPWR sky130_fd_sc_hd__fill_1
XTAP_239 VGND VPWR sky130_fd_sc_hd__tapvpwrvgnd_1
Xhold2 u_pe_array.g_pe_row\[3\].g_pe_col\[3\].u_pe.w_buffer\[0\] VGND VGND VPWR VPWR
+ net78 sky130_fd_sc_hd__dlygate4sd3_1
XFILLER_0_55_57 VGND VGND VPWR VPWR sky130_fd_sc_hd__fill_2
XFILLER_0_55_79 VGND VGND VPWR VPWR sky130_fd_sc_hd__fill_1
XFILLER_0_76_228 VGND VGND VPWR VPWR sky130_fd_sc_hd__fill_2
X_6780_ _3369_ VGND VGND VPWR VPWR _0654_ sky130_fd_sc_hd__clkbuf_1
X_3992_ u_pe_array.g_pe_row\[3\].g_pe_col\[1\].u_pe.act_val\[1\] _1145_ VGND VGND
+ VPWR VPWR _1154_ sky130_fd_sc_hd__or2b_1
XFILLER_0_9_517 VPWR VGND VPWR VGND sky130_ef_sc_hd__decap_12
X_5800_ u_pe_array.g_pe_row\[0\].g_pe_col\[3\].u_pe.act_val\[5\] VGND VGND VPWR VPWR
+ _2665_ sky130_fd_sc_hd__inv_2
XFILLER_0_71_78 VGND VGND VPWR VPWR sky130_fd_sc_hd__fill_2
X_5731_ net174 _2600_ _2604_ _2336_ VGND VGND VPWR VPWR _0370_ sky130_fd_sc_hd__a22o_1
XFILLER_0_72_412 VGND VGND VPWR VPWR sky130_fd_sc_hd__fill_1
XFILLER_0_57_475 VGND VGND VPWR VPWR sky130_fd_sc_hd__fill_2
XANTENNA__6346__A1 _1787_ VGND VGND VPWR VPWR sky130_fd_sc_hd__diode_2
X_5662_ _2518_ _2519_ _2552_ VGND VGND VPWR VPWR _2553_ sky130_fd_sc_hd__or3_1
XFILLER_0_44_147 VGND VGND VPWR VPWR sky130_fd_sc_hd__fill_2
XFILLER_0_44_136 VGND VGND VPWR VPWR sky130_fd_sc_hd__fill_2
X_7401_ clknet_leaf_43_clk _0451_ net817 VGND VGND VPWR VPWR u_pe_array.g_pe_row\[0\].g_pe_col\[0\].u_pe.psum_out\[5\]
+ sky130_fd_sc_hd__dfrtp_1
X_5593_ _2489_ u_pe_array.g_pe_row\[1\].g_pe_col\[0\].u_pe.psum_out\[1\] _2478_ VGND
+ VGND VPWR VPWR _2490_ sky130_fd_sc_hd__o21a_1
X_4613_ _0832_ VGND VGND VPWR VPWR _1666_ sky130_fd_sc_hd__buf_6
XFILLER_0_32_309 VGND VGND VPWR VPWR sky130_fd_sc_hd__decap_3
XFILLER_0_111_51 VGND VGND VPWR VPWR sky130_fd_sc_hd__decap_4
X_7332_ clknet_leaf_45_clk _0389_ net812 VGND VGND VPWR VPWR u_pe_array.g_pe_row\[0\].g_pe_col\[1\].u_pe.act_val\[1\]
+ sky130_fd_sc_hd__dfrtp_1
Xhold402 u_pe_array.u_fifo2.buffer\[0\]\[1\] VGND VGND VPWR VPWR net478 sky130_fd_sc_hd__dlygate4sd3_1
X_4544_ _1614_ _1615_ VGND VGND VPWR VPWR _1616_ sky130_fd_sc_hd__or2_1
Xhold413 u_pe_array.g_pe_row\[0\].g_pe_col\[1\].u_pe.psum_out\[1\] VGND VGND VPWR
+ VPWR net489 sky130_fd_sc_hd__dlygate4sd3_1
X_7263_ clknet_leaf_49_clk _0324_ net812 VGND VGND VPWR VPWR u_pe_array.g_pe_row\[1\].g_pe_col\[1\].u_pe.psum_out\[7\]
+ sky130_fd_sc_hd__dfrtp_4
Xhold435 u_pe_array.u_fifo2.buffer\[4\]\[3\] VGND VGND VPWR VPWR net511 sky130_fd_sc_hd__dlygate4sd3_1
Xhold424 u_pe_array.u_fifo2.buffer\[5\]\[3\] VGND VGND VPWR VPWR net500 sky130_fd_sc_hd__dlygate4sd3_1
X_6214_ _3005_ _3006_ _3008_ VGND VGND VPWR VPWR _3009_ sky130_fd_sc_hd__o21a_1
Xhold446 u_pe_array.u_fifo1.buffer\[1\]\[5\] VGND VGND VPWR VPWR net522 sky130_fd_sc_hd__dlygate4sd3_1
Xhold457 u_pe_array.u_fifo2.buffer\[8\]\[3\] VGND VGND VPWR VPWR net533 sky130_fd_sc_hd__dlygate4sd3_1
X_4475_ _1544_ _1548_ VGND VGND VPWR VPWR _1552_ sky130_fd_sc_hd__nor2_1
Xhold468 u_pe_array.g_pe_row\[2\].g_pe_col\[3\].u_pe.psum_out\[6\] VGND VGND VPWR
+ VPWR net544 sky130_fd_sc_hd__dlygate4sd3_1
XFILLER_0_96_75 VGND VGND VPWR VPWR sky130_fd_sc_hd__decap_4
Xhold479 u_pe_array.g_pe_row\[0\].g_pe_col\[1\].u_pe.act_val\[1\] VGND VGND VPWR VPWR
+ net555 sky130_fd_sc_hd__dlygate4sd3_1
XFILLER_0_0_461 VPWR VGND VPWR VGND sky130_ef_sc_hd__decap_12
X_7194_ clknet_leaf_75_clk net99 net815 VGND VGND VPWR VPWR u_pe_array.g_pe_row\[1\].g_pe_col\[3\].u_pe.w_reg\[0\]
+ sky130_fd_sc_hd__dfrtp_4
X_6145_ u_pe_array.g_pe_row\[0\].g_pe_col\[1\].u_pe.psum_out\[8\] u_pe_array.g_pe_row\[0\].g_pe_col\[1\].u_pe.psum_out\[7\]
+ _2873_ VGND VGND VPWR VPWR _2952_ sky130_fd_sc_hd__and3b_1
XFILLER_0_0_483 VGND VGND VPWR VPWR sky130_fd_sc_hd__fill_2
XFILLER_0_29_80 VGND VGND VPWR VPWR sky130_fd_sc_hd__decap_8
XTAP_740 VGND VPWR sky130_fd_sc_hd__tapvpwrvgnd_1
XTAP_751 VGND VPWR sky130_fd_sc_hd__tapvpwrvgnd_1
X_6076_ net715 _2387_ _2887_ _2888_ VGND VGND VPWR VPWR _0431_ sky130_fd_sc_hd__a22o_1
XTAP_795 VGND VPWR sky130_fd_sc_hd__tapvpwrvgnd_1
XTAP_784 VGND VPWR sky130_fd_sc_hd__tapvpwrvgnd_1
XTAP_773 VGND VPWR sky130_fd_sc_hd__tapvpwrvgnd_1
XTAP_762 VGND VPWR sky130_fd_sc_hd__tapvpwrvgnd_1
X_5027_ u_pe_array.g_pe_row\[0\].g_pe_col\[2\].u_pe.act_val\[5\] u_pe_array.g_pe_row\[0\].g_pe_col\[2\].u_pe.psum_out\[5\]
+ _0756_ VGND VGND VPWR VPWR _2018_ sky130_fd_sc_hd__mux2_1
XANTENNA__3635__A2 _0834_ VGND VGND VPWR VPWR sky130_fd_sc_hd__diode_2
XANTENNA__6585__A1 _1808_ VGND VGND VPWR VPWR sky130_fd_sc_hd__diode_2
XANTENNA__4596__B1 _1655_ VGND VGND VPWR VPWR sky130_fd_sc_hd__diode_2
X_6978_ clknet_leaf_9_clk _0057_ net819 VGND VGND VPWR VPWR u_pe_array.g_pe_row\[3\].g_pe_col\[2\].u_pe.psum_out\[5\]
+ sky130_fd_sc_hd__dfrtp_1
XANTENNA__7405__RESET_B net817 VGND VGND VPWR VPWR sky130_fd_sc_hd__diode_2
XFILLER_0_63_412 VGND VGND VPWR VPWR sky130_fd_sc_hd__fill_1
XANTENNA__4822__B _0833_ VGND VGND VPWR VPWR sky130_fd_sc_hd__diode_2
X_5929_ _2761_ _2762_ _2768_ VGND VGND VPWR VPWR _2769_ sky130_fd_sc_hd__nor3_1
XANTENNA__6337__A1 _1787_ VGND VGND VPWR VPWR sky130_fd_sc_hd__diode_2
XFILLER_0_90_253 VGND VGND VPWR VPWR sky130_fd_sc_hd__decap_3
XFILLER_0_16_350 VGND VGND VPWR VPWR sky130_fd_sc_hd__fill_1
XFILLER_0_50_117 VGND VGND VPWR VPWR sky130_fd_sc_hd__fill_1
XANTENNA__5653__B _2478_ VGND VGND VPWR VPWR sky130_fd_sc_hd__diode_2
XFILLER_0_8_3 VPWR VGND VPWR VGND sky130_ef_sc_hd__decap_12
XANTENNA_input22_A v_in1[1] VGND VGND VPWR VPWR sky130_fd_sc_hd__diode_2
XANTENNA__3626__A2 _0834_ VGND VGND VPWR VPWR sky130_fd_sc_hd__diode_2
XANTENNA__4587__B1 _1258_ VGND VGND VPWR VPWR sky130_fd_sc_hd__diode_2
XFILLER_0_41_37 VGND VGND VPWR VPWR sky130_fd_sc_hd__fill_1
XANTENNA__6328__A1 _1787_ VGND VGND VPWR VPWR sky130_fd_sc_hd__diode_2
XFILLER_0_94_592 VGND VGND VPWR VPWR sky130_fd_sc_hd__fill_1
XFILLER_0_54_445 VPWR VGND VPWR VGND sky130_ef_sc_hd__decap_12
XFILLER_0_14_309 VGND VGND VPWR VPWR sky130_fd_sc_hd__decap_3
XFILLER_0_42_618 VGND VGND VPWR VPWR sky130_fd_sc_hd__fill_2
XANTENNA__5844__A _2611_ VGND VGND VPWR VPWR sky130_fd_sc_hd__diode_2
XFILLER_0_1_225 VPWR VGND VPWR VGND sky130_ef_sc_hd__decap_12
XFILLER_0_105_591 VGND VGND VPWR VPWR sky130_fd_sc_hd__fill_2
XFILLER_0_50_673 VGND VGND VPWR VPWR sky130_fd_sc_hd__fill_2
XANTENNA__5839__B1 _2571_ VGND VGND VPWR VPWR sky130_fd_sc_hd__diode_2
X_4260_ u_pe_array.g_pe_row\[3\].g_pe_col\[0\].u_pe.psum_out\[9\] u_pe_array.g_pe_row\[3\].g_pe_col\[0\].u_pe.psum_out\[10\]
+ _1275_ VGND VGND VPWR VPWR _1384_ sky130_fd_sc_hd__o21a_1
XANTENNA__5303__A2 _1714_ VGND VGND VPWR VPWR sky130_fd_sc_hd__diode_2
XANTENNA__6500__A1 _1808_ VGND VGND VPWR VPWR sky130_fd_sc_hd__diode_2
XFILLER_0_5_15 VPWR VGND VPWR VGND sky130_ef_sc_hd__decap_12
X_4191_ _1320_ _1321_ VGND VGND VPWR VPWR _1322_ sky130_fd_sc_hd__nor2_1
XANTENNA__6264__B1 _2174_ VGND VGND VPWR VPWR sky130_fd_sc_hd__diode_2
X_6901_ _3434_ VGND VGND VPWR VPWR _0710_ sky130_fd_sc_hd__clkbuf_1
X_6832_ net447 _3103_ _3397_ VGND VGND VPWR VPWR _3398_ sky130_fd_sc_hd__mux2_1
XANTENNA__4290__A2 _1392_ VGND VGND VPWR VPWR sky130_fd_sc_hd__diode_2
XANTENNA__6567__A1 _1818_ VGND VGND VPWR VPWR sky130_fd_sc_hd__diode_2
X_6763_ _3360_ VGND VGND VPWR VPWR _0646_ sky130_fd_sc_hd__clkbuf_1
X_3975_ net125 _1138_ _1140_ _1004_ VGND VGND VPWR VPWR _0078_ sky130_fd_sc_hd__a22o_1
XFILLER_0_18_626 VGND VGND VPWR VPWR sky130_fd_sc_hd__fill_2
X_6694_ net388 _3103_ _3324_ VGND VGND VPWR VPWR _3325_ sky130_fd_sc_hd__mux2_1
X_5714_ net616 _2463_ _2592_ _2595_ VGND VGND VPWR VPWR _0362_ sky130_fd_sc_hd__a22o_1
XFILLER_0_72_253 VGND VGND VPWR VPWR sky130_fd_sc_hd__decap_6
X_5645_ _2533_ _2534_ _2536_ VGND VGND VPWR VPWR _2538_ sky130_fd_sc_hd__a21oi_1
XFILLER_0_31_70 VGND VGND VPWR VPWR sky130_fd_sc_hd__fill_1
XFILLER_0_33_629 VGND VGND VPWR VPWR sky130_fd_sc_hd__fill_1
XFILLER_0_86_3 VPWR VGND VPWR VGND sky130_ef_sc_hd__decap_12
XFILLER_0_5_553 VGND VGND VPWR VPWR sky130_fd_sc_hd__decap_6
XFILLER_0_103_539 VPWR VGND VPWR VGND sky130_ef_sc_hd__decap_12
XFILLER_0_103_517 VGND VGND VPWR VPWR sky130_fd_sc_hd__decap_3
XFILLER_0_5_597 VPWR VGND VPWR VGND sky130_ef_sc_hd__decap_12
XFILLER_0_13_320 VPWR VGND VPWR VGND sky130_ef_sc_hd__decap_12
Xhold210 u_pe_array.g_pe_row\[1\].g_pe_col\[3\].u_pe.psum_out\[11\] VGND VGND VPWR
+ VPWR net286 sky130_fd_sc_hd__dlygate4sd3_1
X_5576_ net330 _2463_ _2475_ _2336_ VGND VGND VPWR VPWR _0344_ sky130_fd_sc_hd__a22o_1
Xhold232 u_pe_array.u_fifo1.buffer\[8\]\[9\] VGND VGND VPWR VPWR net308 sky130_fd_sc_hd__dlygate4sd3_1
Xhold221 u_pe_array.u_fifo1.buffer\[0\]\[10\] VGND VGND VPWR VPWR net297 sky130_fd_sc_hd__dlygate4sd3_1
Xhold243 u_pe_array.u_fifo1.buffer\[0\]\[12\] VGND VGND VPWR VPWR net319 sky130_fd_sc_hd__dlygate4sd3_1
XANTENNA__7391__D u_fsm.psum_shift_en VGND VGND VPWR VPWR sky130_fd_sc_hd__diode_2
X_4527_ _1600_ VGND VGND VPWR VPWR _1601_ sky130_fd_sc_hd__inv_2
X_7315_ clknet_leaf_79_clk net104 net814 VGND VGND VPWR VPWR u_pe_array.g_pe_row\[0\].g_pe_col\[3\].u_pe.w_reg\[1\]
+ sky130_fd_sc_hd__dfrtp_1
XFILLER_0_41_673 VGND VGND VPWR VPWR sky130_fd_sc_hd__fill_2
XFILLER_0_111_561 VPWR VGND VPWR VGND sky130_ef_sc_hd__decap_12
X_7246_ clknet_leaf_40_clk _0309_ net75 VGND VGND VPWR VPWR u_pe_array.g_pe_row\[1\].g_pe_col\[0\].u_pe.act_val\[5\]
+ sky130_fd_sc_hd__dfrtp_2
Xhold287 u_pe_array.g_pe_row\[3\].g_pe_col\[2\].u_pe.psum_out\[4\] VGND VGND VPWR
+ VPWR net363 sky130_fd_sc_hd__dlygate4sd3_1
Xhold276 u_pe_array.u_fifo2.buffer\[5\]\[11\] VGND VGND VPWR VPWR net352 sky130_fd_sc_hd__dlygate4sd3_1
X_4458_ u_pe_array.g_pe_row\[2\].g_pe_col\[2\].u_pe.act_val\[0\] _1536_ VGND VGND
+ VPWR VPWR _1537_ sky130_fd_sc_hd__nand2_1
Xhold265 u_pe_array.u_fifo2.buffer\[2\]\[11\] VGND VGND VPWR VPWR net341 sky130_fd_sc_hd__dlygate4sd3_1
Xhold254 u_pe_array.g_pe_row\[0\].g_pe_col\[3\].u_pe.move_reg\[12\] VGND VGND VPWR
+ VPWR net330 sky130_fd_sc_hd__dlygate4sd3_1
Xhold298 u_pe_array.g_pe_row\[0\].g_pe_col\[1\].u_pe.psum_out\[0\] VGND VGND VPWR
+ VPWR net374 sky130_fd_sc_hd__dlygate4sd3_1
X_7177_ clknet_leaf_41_clk _0244_ net817 VGND VGND VPWR VPWR u_pe_array.g_pe_row\[2\].g_pe_col\[0\].u_pe.psum_out\[11\]
+ sky130_fd_sc_hd__dfrtp_1
X_6128_ _2934_ _2935_ _2933_ VGND VGND VPWR VPWR _2937_ sky130_fd_sc_hd__o21a_1
X_4389_ _1487_ _1488_ u_pe_array.g_pe_row\[2\].g_pe_col\[3\].u_pe.psum_out\[8\] _0916_
+ VGND VGND VPWR VPWR _0144_ sky130_fd_sc_hd__a2bb2o_1
XTAP_570 VGND VPWR sky130_fd_sc_hd__tapvpwrvgnd_1
XFILLER_0_99_117 VGND VGND VPWR VPWR sky130_fd_sc_hd__fill_2
XTAP_581 VGND VPWR sky130_fd_sc_hd__tapvpwrvgnd_1
XTAP_592 VGND VPWR sky130_fd_sc_hd__tapvpwrvgnd_1
X_6059_ u_pe_array.g_pe_row\[0\].g_pe_col\[1\].u_pe.w_reg\[1\] VGND VGND VPWR VPWR
+ _2873_ sky130_fd_sc_hd__clkbuf_8
XFILLER_0_99_139 VGND VGND VPWR VPWR sky130_fd_sc_hd__fill_1
XFILLER_0_95_334 VGND VGND VPWR VPWR sky130_fd_sc_hd__fill_2
XFILLER_0_95_312 VGND VGND VPWR VPWR sky130_fd_sc_hd__decap_6
XANTENNA__4281__A2 _1392_ VGND VGND VPWR VPWR sky130_fd_sc_hd__diode_2
XFILLER_0_48_250 VGND VGND VPWR VPWR sky130_fd_sc_hd__fill_2
XFILLER_0_48_294 VGND VGND VPWR VPWR sky130_fd_sc_hd__fill_2
XFILLER_0_102_583 VGND VGND VPWR VPWR sky130_fd_sc_hd__decap_3
XANTENNA__6797__A1 _3132_ VGND VGND VPWR VPWR sky130_fd_sc_hd__diode_2
XFILLER_0_99_673 VGND VGND VPWR VPWR sky130_fd_sc_hd__decap_4
XANTENNA__7398__RESET_B net817 VGND VGND VPWR VPWR sky130_fd_sc_hd__diode_2
XFILLER_0_98_161 VGND VGND VPWR VPWR sky130_fd_sc_hd__fill_2
XFILLER_0_59_537 VGND VGND VPWR VPWR sky130_fd_sc_hd__fill_2
XANTENNA__4272__A2 _1138_ VGND VGND VPWR VPWR sky130_fd_sc_hd__diode_2
XANTENNA__7327__RESET_B net13 VGND VGND VPWR VPWR sky130_fd_sc_hd__diode_2
XFILLER_0_74_507 VGND VGND VPWR VPWR sky130_fd_sc_hd__decap_8
XFILLER_0_52_25 VGND VGND VPWR VPWR sky130_fd_sc_hd__decap_3
XFILLER_0_67_581 VGND VGND VPWR VPWR sky130_fd_sc_hd__fill_1
XFILLER_0_6_306 VGND VGND VPWR VPWR sky130_fd_sc_hd__fill_2
X_3760_ u_pe_array.g_pe_row\[3\].g_pe_col\[3\].u_pe.psum_out\[10\] _0959_ VGND VGND
+ VPWR VPWR _0970_ sky130_fd_sc_hd__nor2_1
XFILLER_0_39_272 VGND VGND VPWR VPWR sky130_fd_sc_hd__fill_2
XFILLER_0_39_294 VGND VGND VPWR VPWR sky130_fd_sc_hd__decap_6
XFILLER_0_82_562 VGND VGND VPWR VPWR sky130_fd_sc_hd__fill_2
XFILLER_0_82_540 VGND VGND VPWR VPWR sky130_fd_sc_hd__fill_1
XFILLER_0_109_193 VGND VGND VPWR VPWR sky130_fd_sc_hd__fill_2
X_5430_ u_pe_array.g_pe_row\[1\].g_pe_col\[1\].u_pe.w_reg\[0\] u_pe_array.g_pe_row\[1\].g_pe_col\[1\].u_pe.act_val\[2\]
+ VGND VGND VPWR VPWR _2355_ sky130_fd_sc_hd__nand2_1
X_3691_ _0904_ _0905_ u_pe_array.g_pe_row\[3\].g_pe_col\[3\].u_pe.psum_out\[4\] VGND
+ VGND VPWR VPWR _0907_ sky130_fd_sc_hd__a21o_1
XFILLER_0_15_629 VGND VGND VPWR VPWR sky130_fd_sc_hd__decap_3
XANTENNA__3793__S _0745_ VGND VGND VPWR VPWR sky130_fd_sc_hd__diode_2
XFILLER_0_42_437 VGND VGND VPWR VPWR sky130_fd_sc_hd__fill_1
XANTENNA__6962__RESET_B net816 VGND VGND VPWR VPWR sky130_fd_sc_hd__diode_2
XFILLER_0_2_501 VPWR VGND VPWR VGND sky130_ef_sc_hd__decap_12
X_5361_ _1787_ _2299_ VGND VGND VPWR VPWR _2300_ sky130_fd_sc_hd__or2_1
XFILLER_0_2_545 VPWR VGND VPWR VGND sky130_ef_sc_hd__decap_12
XFILLER_0_23_673 VGND VGND VPWR VPWR sky130_fd_sc_hd__fill_2
X_5292_ _2224_ _2237_ _2238_ VGND VGND VPWR VPWR _2239_ sky130_fd_sc_hd__a21o_1
X_4312_ u_pe_array.g_pe_row\[2\].g_pe_col\[3\].u_pe.act_val\[0\] VGND VGND VPWR VPWR
+ _1418_ sky130_fd_sc_hd__inv_2
XFILLER_0_2_589 VPWR VGND VPWR VGND sky130_ef_sc_hd__decap_12
X_7100_ clknet_leaf_87_clk _0171_ net819 VGND VGND VPWR VPWR u_pe_array.g_pe_row\[2\].g_pe_col\[2\].u_pe.psum_out\[7\]
+ sky130_fd_sc_hd__dfrtp_4
X_7031_ clknet_leaf_31_clk net84 net817 VGND VGND VPWR VPWR u_pe_array.g_pe_row\[3\].g_pe_col\[0\].u_pe.w_reg\[0\]
+ sky130_fd_sc_hd__dfrtp_4
X_4243_ _1275_ u_pe_array.g_pe_row\[3\].g_pe_col\[0\].u_pe.psum_out\[10\] VGND VGND
+ VPWR VPWR _1369_ sky130_fd_sc_hd__nand2_1
XANTENNA__6609__S _3269_ VGND VGND VPWR VPWR sky130_fd_sc_hd__diode_2
X_4174_ u_pe_array.g_pe_row\[3\].g_pe_col\[0\].u_pe.act_val\[3\] VGND VGND VPWR VPWR
+ _1306_ sky130_fd_sc_hd__inv_2
XANTENNA__3541__B _0787_ VGND VGND VPWR VPWR sky130_fd_sc_hd__diode_2
XANTENNA__7068__RESET_B net74 VGND VGND VPWR VPWR sky130_fd_sc_hd__diode_2
XANTENNA__6344__S _3110_ VGND VGND VPWR VPWR sky130_fd_sc_hd__diode_2
X_6815_ _3388_ VGND VGND VPWR VPWR _0670_ sky130_fd_sc_hd__clkbuf_1
X_6746_ _3351_ VGND VGND VPWR VPWR _0638_ sky130_fd_sc_hd__clkbuf_1
XFILLER_0_92_337 VGND VGND VPWR VPWR sky130_fd_sc_hd__fill_1
XFILLER_0_42_80 VGND VGND VPWR VPWR sky130_fd_sc_hd__fill_2
X_3958_ net19 _1130_ _0819_ VGND VGND VPWR VPWR _1131_ sky130_fd_sc_hd__mux2_1
XFILLER_0_45_253 VGND VGND VPWR VPWR sky130_fd_sc_hd__fill_1
X_6677_ _3105_ _3306_ VGND VGND VPWR VPWR _3312_ sky130_fd_sc_hd__or2_1
XFILLER_0_60_223 VGND VGND VPWR VPWR sky130_fd_sc_hd__fill_2
XFILLER_0_33_437 VGND VGND VPWR VPWR sky130_fd_sc_hd__decap_8
X_3889_ _1073_ _1071_ _1068_ VGND VGND VPWR VPWR _1074_ sky130_fd_sc_hd__a21oi_1
XANTENNA__6712__A1 _3128_ VGND VGND VPWR VPWR sky130_fd_sc_hd__diode_2
XANTENNA__6299__B _2992_ VGND VGND VPWR VPWR sky130_fd_sc_hd__diode_2
X_5628_ u_pe_array.g_pe_row\[1\].g_pe_col\[0\].u_pe.act_val\[5\] u_pe_array.g_pe_row\[1\].g_pe_col\[0\].u_pe.w_reg\[0\]
+ VGND VGND VPWR VPWR _2522_ sky130_fd_sc_hd__nand2_1
XFILLER_0_60_234 VGND VGND VPWR VPWR sky130_fd_sc_hd__fill_2
XFILLER_0_13_161 VGND VGND VPWR VPWR sky130_fd_sc_hd__decap_6
X_5559_ net696 _2463_ _1655_ _2466_ VGND VGND VPWR VPWR _0336_ sky130_fd_sc_hd__a22o_1
X_7229_ clknet_leaf_58_clk _0292_ net813 VGND VGND VPWR VPWR u_pe_array.g_pe_row\[1\].g_pe_col\[2\].u_pe.psum_out\[3\]
+ sky130_fd_sc_hd__dfrtp_1
XANTENNA__6519__S _3224_ VGND VGND VPWR VPWR sky130_fd_sc_hd__diode_2
XANTENNA__6228__B1 _0866_ VGND VGND VPWR VPWR sky130_fd_sc_hd__diode_2
XANTENNA__4239__C1 _1275_ VGND VGND VPWR VPWR sky130_fd_sc_hd__diode_2
XTAP_1533 VGND VPWR sky130_fd_sc_hd__tapvpwrvgnd_1
XTAP_1511 VGND VPWR sky130_fd_sc_hd__tapvpwrvgnd_1
XTAP_1522 VGND VPWR sky130_fd_sc_hd__tapvpwrvgnd_1
XTAP_1500 VGND VPWR sky130_fd_sc_hd__tapvpwrvgnd_1
XFILLER_0_96_654 VPWR VGND VPWR VGND sky130_ef_sc_hd__decap_12
XFILLER_0_96_643 VGND VGND VPWR VPWR sky130_fd_sc_hd__fill_1
XPHY_40 VGND VGND VPWR VPWR sky130_fd_sc_hd__decap_3
XTAP_1566 VGND VPWR sky130_fd_sc_hd__tapvpwrvgnd_1
XTAP_1555 VGND VPWR sky130_fd_sc_hd__tapvpwrvgnd_1
XTAP_1544 VGND VPWR sky130_fd_sc_hd__tapvpwrvgnd_1
XPHY_51 VGND VGND VPWR VPWR sky130_fd_sc_hd__decap_3
XPHY_62 VGND VGND VPWR VPWR sky130_fd_sc_hd__decap_3
XPHY_73 VGND VGND VPWR VPWR sky130_fd_sc_hd__decap_3
XTAP_1588 VGND VPWR sky130_fd_sc_hd__tapvpwrvgnd_1
XTAP_1599 VGND VPWR sky130_fd_sc_hd__tapvpwrvgnd_1
XTAP_1577 VGND VPWR sky130_fd_sc_hd__tapvpwrvgnd_1
XPHY_95 VGND VGND VPWR VPWR sky130_fd_sc_hd__decap_3
XPHY_84 VGND VGND VPWR VPWR sky130_fd_sc_hd__decap_3
XFILLER_0_36_253 VGND VGND VPWR VPWR sky130_fd_sc_hd__decap_3
XFILLER_0_107_653 VPWR VGND VPWR VGND sky130_ef_sc_hd__decap_12
XFILLER_0_36_286 VGND VGND VPWR VPWR sky130_fd_sc_hd__fill_2
XFILLER_0_106_152 VGND VGND VPWR VPWR sky130_fd_sc_hd__fill_2
XFILLER_0_20_665 VPWR VGND VPWR VGND sky130_ef_sc_hd__decap_12
XFILLER_0_47_36 VGND VGND VPWR VPWR sky130_fd_sc_hd__fill_1
XFILLER_0_2_27 VGND VGND VPWR VPWR sky130_fd_sc_hd__fill_1
XANTENNA__3788__S _0754_ VGND VGND VPWR VPWR sky130_fd_sc_hd__diode_2
XFILLER_0_63_57 VPWR VGND VPWR VGND sky130_ef_sc_hd__decap_12
XANTENNA__7161__RESET_B net814 VGND VGND VPWR VPWR sky130_fd_sc_hd__diode_2
X_4930_ u_pe_array.g_pe_row\[2\].g_pe_col\[0\].u_pe.psum_out\[9\] _1847_ VGND VGND
+ VPWR VPWR _1932_ sky130_fd_sc_hd__or2_1
XFILLER_0_87_643 VGND VGND VPWR VPWR sky130_fd_sc_hd__fill_2
X_4861_ _1866_ _1868_ VGND VGND VPWR VPWR _1869_ sky130_fd_sc_hd__nand2_1
XFILLER_0_86_164 VGND VGND VPWR VPWR sky130_fd_sc_hd__fill_2
XANTENNA__5288__B _2158_ VGND VGND VPWR VPWR sky130_fd_sc_hd__diode_2
XFILLER_0_86_186 VGND VGND VPWR VPWR sky130_fd_sc_hd__fill_1
X_6600_ _3268_ VGND VGND VPWR VPWR _3269_ sky130_fd_sc_hd__clkbuf_8
X_3812_ net198 _0996_ _1005_ _1004_ VGND VGND VPWR VPWR _0050_ sky130_fd_sc_hd__a22o_1
XFILLER_0_7_615 VGND VGND VPWR VPWR sky130_fd_sc_hd__fill_1
X_7580_ clknet_leaf_21_clk _0629_ VGND VGND VPWR VPWR u_pe_array.u_fifo1.buffer\[1\]\[3\]
+ sky130_fd_sc_hd__dfxtp_1
X_4792_ _1819_ VGND VGND VPWR VPWR _0216_ sky130_fd_sc_hd__clkbuf_1
XFILLER_0_103_63 VGND VGND VPWR VPWR sky130_fd_sc_hd__decap_4
XANTENNA__4920__B _1847_ VGND VGND VPWR VPWR sky130_fd_sc_hd__diode_2
XANTENNA__4953__B1 _1847_ VGND VGND VPWR VPWR sky130_fd_sc_hd__diode_2
X_6531_ net262 _1810_ _3224_ VGND VGND VPWR VPWR _3232_ sky130_fd_sc_hd__mux2_1
X_3743_ _0940_ _0953_ _0954_ VGND VGND VPWR VPWR _0955_ sky130_fd_sc_hd__a21o_1
XFILLER_0_82_392 VGND VGND VPWR VPWR sky130_fd_sc_hd__fill_2
X_3674_ u_pe_array.g_pe_row\[3\].g_pe_col\[3\].u_pe.act_val\[3\] u_pe_array.g_pe_row\[3\].g_pe_col\[3\].u_pe.w_reg\[0\]
+ _0869_ _0890_ VGND VGND VPWR VPWR _0891_ sky130_fd_sc_hd__a22o_1
X_6462_ _3195_ VGND VGND VPWR VPWR _0510_ sky130_fd_sc_hd__clkbuf_1
XFILLER_0_42_234 VGND VGND VPWR VPWR sky130_fd_sc_hd__decap_6
X_5413_ net301 _2144_ _2340_ _2336_ VGND VGND VPWR VPWR _0316_ sky130_fd_sc_hd__a22o_1
XFILLER_0_70_576 VGND VGND VPWR VPWR sky130_fd_sc_hd__decap_3
XFILLER_0_70_565 VGND VGND VPWR VPWR sky130_fd_sc_hd__fill_1
X_6393_ u_pe_array.u_fifo2.count\[2\] VGND VGND VPWR VPWR _3156_ sky130_fd_sc_hd__inv_2
XFILLER_0_30_418 VGND VGND VPWR VPWR sky130_fd_sc_hd__fill_2
XFILLER_0_42_289 VGND VGND VPWR VPWR sky130_fd_sc_hd__decap_4
X_5344_ u_pe_array.u_fifo1.rd_ptr\[1\] u_pe_array.u_fifo1.rd_ptr\[0\] _2271_ u_pe_array.u_fifo1.rd_ptr\[2\]
+ VGND VGND VPWR VPWR _2284_ sky130_fd_sc_hd__and4b_2
XFILLER_0_11_665 VGND VGND VPWR VPWR sky130_fd_sc_hd__decap_6
XANTENNA__5751__B _2611_ VGND VGND VPWR VPWR sky130_fd_sc_hd__diode_2
X_5275_ _2214_ _2216_ VGND VGND VPWR VPWR _2223_ sky130_fd_sc_hd__and2b_1
X_4226_ u_pe_array.g_pe_row\[3\].g_pe_col\[0\].u_pe.psum_out\[8\] u_pe_array.g_pe_row\[3\].g_pe_col\[0\].u_pe.psum_out\[7\]
+ _1275_ VGND VGND VPWR VPWR _1354_ sky130_fd_sc_hd__and3b_1
X_7014_ clknet_leaf_12_clk _0091_ net818 VGND VGND VPWR VPWR u_pe_array.g_pe_row\[3\].g_pe_col\[1\].u_pe.psum_out\[11\]
+ sky130_fd_sc_hd__dfrtp_1
XFILLER_0_49_3 VGND VGND VPWR VPWR sky130_fd_sc_hd__decap_4
XANTENNA__7249__RESET_B net75 VGND VGND VPWR VPWR sky130_fd_sc_hd__diode_2
X_4157_ net652 _1152_ _1289_ _1290_ VGND VGND VPWR VPWR _0110_ sky130_fd_sc_hd__a22o_1
XFILLER_0_78_621 VGND VGND VPWR VPWR sky130_fd_sc_hd__fill_2
X_4088_ _1235_ _1240_ _0914_ VGND VGND VPWR VPWR _1242_ sky130_fd_sc_hd__a21o_1
XFILLER_0_78_643 VGND VGND VPWR VPWR sky130_fd_sc_hd__fill_1
XANTENNA__4383__A _1407_ VGND VGND VPWR VPWR sky130_fd_sc_hd__diode_2
XANTENNA__6630__B1 _2592_ VGND VGND VPWR VPWR sky130_fd_sc_hd__diode_2
XFILLER_0_38_518 VGND VGND VPWR VPWR sky130_fd_sc_hd__fill_2
XFILLER_0_38_529 VGND VGND VPWR VPWR sky130_fd_sc_hd__decap_3
XFILLER_0_77_197 VGND VGND VPWR VPWR sky130_fd_sc_hd__decap_4
XFILLER_0_65_337 VGND VGND VPWR VPWR sky130_fd_sc_hd__fill_2
XFILLER_0_108_417 VGND VGND VPWR VPWR sky130_fd_sc_hd__decap_3
XANTENNA__3747__A1 _0914_ VGND VGND VPWR VPWR sky130_fd_sc_hd__diode_2
X_6729_ net556 _3118_ net65 VGND VGND VPWR VPWR _3343_ sky130_fd_sc_hd__mux2_1
XANTENNA__4944__B1 _0885_ VGND VGND VPWR VPWR sky130_fd_sc_hd__diode_2
XANTENNA__4830__B _0833_ VGND VGND VPWR VPWR sky130_fd_sc_hd__diode_2
XFILLER_0_104_645 VPWR VGND VPWR VGND sky130_ef_sc_hd__decap_12
XFILLER_0_61_565 VGND VGND VPWR VPWR sky130_fd_sc_hd__decap_3
XFILLER_0_103_188 VGND VGND VPWR VPWR sky130_fd_sc_hd__decap_3
XANTENNA__3462__A _0728_ VGND VGND VPWR VPWR sky130_fd_sc_hd__diode_2
XFILLER_0_108_19 VGND VGND VPWR VPWR sky130_fd_sc_hd__decap_8
XFILLER_0_17_28 VGND VGND VPWR VPWR sky130_fd_sc_hd__decap_4
XFILLER_0_88_407 VGND VGND VPWR VPWR sky130_fd_sc_hd__fill_2
XFILLER_0_69_621 VGND VGND VPWR VPWR sky130_fd_sc_hd__fill_1
XTAP_1341 VGND VPWR sky130_fd_sc_hd__tapvpwrvgnd_1
XTAP_1330 VGND VPWR sky130_fd_sc_hd__tapvpwrvgnd_1
XFILLER_0_68_164 VGND VGND VPWR VPWR sky130_fd_sc_hd__decap_3
XTAP_1374 VGND VPWR sky130_fd_sc_hd__tapvpwrvgnd_1
XTAP_1352 VGND VPWR sky130_fd_sc_hd__tapvpwrvgnd_1
XTAP_1363 VGND VPWR sky130_fd_sc_hd__tapvpwrvgnd_1
XFILLER_0_84_635 VGND VGND VPWR VPWR sky130_fd_sc_hd__fill_2
XTAP_1396 VGND VPWR sky130_fd_sc_hd__tapvpwrvgnd_1
XTAP_1385 VGND VPWR sky130_fd_sc_hd__tapvpwrvgnd_1
XFILLER_0_37_551 VGND VGND VPWR VPWR sky130_fd_sc_hd__fill_2
XANTENNA__5727__A2 _2600_ VGND VGND VPWR VPWR sky130_fd_sc_hd__diode_2
XFILLER_0_71_329 VGND VGND VPWR VPWR sky130_fd_sc_hd__fill_1
XFILLER_0_71_318 VGND VGND VPWR VPWR sky130_fd_sc_hd__decap_3
XFILLER_0_64_370 VGND VGND VPWR VPWR sky130_fd_sc_hd__fill_1
XFILLER_0_24_201 VGND VGND VPWR VPWR sky130_fd_sc_hd__fill_2
XFILLER_0_64_392 VGND VGND VPWR VPWR sky130_fd_sc_hd__decap_6
Xinput25 v_in1[4] VGND VGND VPWR VPWR net25 sky130_fd_sc_hd__buf_1
Xinput14 start VGND VGND VPWR VPWR net14 sky130_fd_sc_hd__buf_2
XFILLER_0_24_223 VGND VGND VPWR VPWR sky130_fd_sc_hd__decap_6
XFILLER_0_110_637 VGND VGND VPWR VPWR sky130_fd_sc_hd__decap_6
XFILLER_0_20_451 VGND VGND VPWR VPWR sky130_fd_sc_hd__fill_2
X_5060_ _2040_ u_pe_array.g_pe_row\[1\].g_pe_col\[3\].u_pe.psum_out\[1\] _2029_ VGND
+ VGND VPWR VPWR _2041_ sky130_fd_sc_hd__o21a_1
XANTENNA__4187__B _1275_ VGND VGND VPWR VPWR sky130_fd_sc_hd__diode_2
XFILLER_0_74_23 VGND VGND VPWR VPWR sky130_fd_sc_hd__fill_2
XANTENNA__7342__RESET_B net812 VGND VGND VPWR VPWR sky130_fd_sc_hd__diode_2
X_4011_ _1171_ VGND VGND VPWR VPWR _1172_ sky130_fd_sc_hd__inv_2
XANTENNA__3674__B1 _0869_ VGND VGND VPWR VPWR sky130_fd_sc_hd__diode_2
X_5962_ _2797_ _2743_ u_pe_array.g_pe_row\[0\].g_pe_col\[2\].u_pe.psum_out\[6\] VGND
+ VGND VPWR VPWR _2799_ sky130_fd_sc_hd__a21o_1
X_4913_ _1911_ _1909_ _1915_ VGND VGND VPWR VPWR _1917_ sky130_fd_sc_hd__or3_1
XFILLER_0_75_613 VGND VGND VPWR VPWR sky130_fd_sc_hd__decap_3
XFILLER_0_90_77 VGND VGND VPWR VPWR sky130_fd_sc_hd__decap_3
XFILLER_0_87_484 VGND VGND VPWR VPWR sky130_fd_sc_hd__fill_1
XANTENNA__3977__B2 _1004_ VGND VGND VPWR VPWR sky130_fd_sc_hd__diode_2
XFILLER_0_74_123 VGND VGND VPWR VPWR sky130_fd_sc_hd__decap_3
X_5893_ net168 _2600_ _2737_ _0722_ VGND VGND VPWR VPWR _0399_ sky130_fd_sc_hd__a22o_1
XFILLER_0_59_175 VGND VGND VPWR VPWR sky130_fd_sc_hd__fill_2
XFILLER_0_47_337 VGND VGND VPWR VPWR sky130_fd_sc_hd__fill_2
XFILLER_0_114_62 VGND VGND VPWR VPWR sky130_fd_sc_hd__fill_2
X_4844_ _1844_ _1849_ VGND VGND VPWR VPWR _1853_ sky130_fd_sc_hd__and2_1
X_7632_ clknet_leaf_19_clk _0681_ VGND VGND VPWR VPWR u_pe_array.u_fifo1.buffer\[5\]\[3\]
+ sky130_fd_sc_hd__dfxtp_1
XANTENNA__5179__B1 _1655_ VGND VGND VPWR VPWR sky130_fd_sc_hd__diode_2
XFILLER_0_7_423 VGND VGND VPWR VPWR sky130_fd_sc_hd__fill_2
XANTENNA__5718__A2 _2463_ VGND VGND VPWR VPWR sky130_fd_sc_hd__diode_2
XFILLER_0_99_31 VGND VGND VPWR VPWR sky130_fd_sc_hd__decap_6
XFILLER_0_90_638 VGND VGND VPWR VPWR sky130_fd_sc_hd__decap_4
X_7563_ clknet_leaf_17_clk _0612_ net816 VGND VGND VPWR VPWR u_pe_array.u_fifo1.count\[3\]
+ sky130_fd_sc_hd__dfrtp_1
XFILLER_0_7_445 VGND VGND VPWR VPWR sky130_fd_sc_hd__decap_3
XFILLER_0_23_93 VGND VGND VPWR VPWR sky130_fd_sc_hd__fill_1
XFILLER_0_28_562 VGND VGND VPWR VPWR sky130_fd_sc_hd__fill_2
X_4775_ _1787_ _0850_ _0999_ _0747_ VGND VGND VPWR VPWR _1808_ sky130_fd_sc_hd__a22o_2
X_6514_ u_pe_array.u_fifo2.wr_ptr\[3\] net74 _3136_ u_pe_array.u_fifo2.wr_ptr\[2\]
+ VGND VGND VPWR VPWR _3222_ sky130_fd_sc_hd__and4b_1
XFILLER_0_43_521 VGND VGND VPWR VPWR sky130_fd_sc_hd__fill_2
XFILLER_0_7_489 VPWR VGND VPWR VGND sky130_ef_sc_hd__decap_12
X_3726_ _0930_ _0932_ VGND VGND VPWR VPWR _0939_ sky130_fd_sc_hd__and2b_1
X_7494_ clknet_leaf_7_clk _0543_ VGND VGND VPWR VPWR u_pe_array.u_fifo2.buffer\[4\]\[7\]
+ sky130_fd_sc_hd__dfxtp_1
XFILLER_0_43_576 VGND VGND VPWR VPWR sky130_fd_sc_hd__fill_1
XFILLER_0_101_615 VGND VGND VPWR VPWR sky130_fd_sc_hd__fill_1
X_3657_ _0866_ VGND VGND VPWR VPWR _0875_ sky130_fd_sc_hd__buf_8
XFILLER_0_3_673 VGND VGND VPWR VPWR sky130_fd_sc_hd__decap_4
X_6445_ _3186_ VGND VGND VPWR VPWR _0502_ sky130_fd_sc_hd__clkbuf_1
XFILLER_0_113_497 VGND VGND VPWR VPWR sky130_fd_sc_hd__decap_6
X_6376_ net200 _3142_ _1794_ VGND VGND VPWR VPWR _3145_ sky130_fd_sc_hd__o21ai_1
X_3588_ u_fsm.v_cnt\[1\] u_fsm.v_cnt\[2\] _0821_ VGND VGND VPWR VPWR _0824_ sky130_fd_sc_hd__nand3_1
X_5327_ u_pe_array.g_pe_row\[0\].g_pe_col\[1\].u_pe.w_buffer\[0\] u_pe_array.g_pe_row\[1\].g_pe_col\[1\].u_pe.w_buffer\[0\]
+ _0828_ VGND VGND VPWR VPWR _2269_ sky130_fd_sc_hd__mux2_1
XANTENNA__7083__RESET_B net818 VGND VGND VPWR VPWR sky130_fd_sc_hd__diode_2
X_5258_ _2206_ _2207_ VGND VGND VPWR VPWR _2208_ sky130_fd_sc_hd__and2b_1
X_4209_ _1336_ _1337_ _1335_ VGND VGND VPWR VPWR _1339_ sky130_fd_sc_hd__o21a_1
X_5189_ u_pe_array.g_pe_row\[1\].g_pe_col\[2\].u_pe.psum_out\[8\] u_pe_array.g_pe_row\[1\].g_pe_col\[2\].u_pe.move_reg\[8\]
+ _1661_ VGND VGND VPWR VPWR _2149_ sky130_fd_sc_hd__mux2_1
XANTENNA__7012__RESET_B net818 VGND VGND VPWR VPWR sky130_fd_sc_hd__diode_2
XFILLER_0_97_215 VGND VGND VPWR VPWR sky130_fd_sc_hd__decap_3
XFILLER_0_3_81 VPWR VGND VPWR VGND sky130_ef_sc_hd__decap_12
XFILLER_0_78_440 VGND VGND VPWR VPWR sky130_fd_sc_hd__fill_2
XANTENNA__3968__B2 _1004_ VGND VGND VPWR VPWR sky130_fd_sc_hd__diode_2
XFILLER_0_93_410 VGND VGND VPWR VPWR sky130_fd_sc_hd__decap_3
XFILLER_0_78_495 VGND VGND VPWR VPWR sky130_fd_sc_hd__fill_2
XFILLER_0_38_337 VGND VGND VPWR VPWR sky130_fd_sc_hd__fill_1
XANTENNA__6906__A1 _3128_ VGND VGND VPWR VPWR sky130_fd_sc_hd__diode_2
XFILLER_0_19_540 VPWR VGND VPWR VGND sky130_ef_sc_hd__decap_12
XFILLER_0_38_359 VGND VGND VPWR VPWR sky130_fd_sc_hd__decap_4
XFILLER_0_108_258 VPWR VGND VPWR VGND sky130_ef_sc_hd__decap_12
XFILLER_0_93_487 VGND VGND VPWR VPWR sky130_fd_sc_hd__decap_3
XFILLER_0_19_584 VGND VGND VPWR VPWR sky130_fd_sc_hd__decap_3
XFILLER_0_34_510 VGND VGND VPWR VPWR sky130_fd_sc_hd__fill_2
XANTENNA__3457__A _0728_ VGND VGND VPWR VPWR sky130_fd_sc_hd__diode_2
XFILLER_0_61_362 VGND VGND VPWR VPWR sky130_fd_sc_hd__decap_4
XFILLER_0_34_554 VGND VGND VPWR VPWR sky130_fd_sc_hd__fill_1
XFILLER_0_0_109 VGND VGND VPWR VPWR sky130_fd_sc_hd__decap_3
XFILLER_0_21_237 VGND VGND VPWR VPWR sky130_fd_sc_hd__fill_2
XFILLER_0_104_486 VGND VGND VPWR VPWR sky130_fd_sc_hd__fill_2
XANTENNA__5893__B2 _0722_ VGND VGND VPWR VPWR sky130_fd_sc_hd__diode_2
XANTENNA__3904__B _1009_ VGND VGND VPWR VPWR sky130_fd_sc_hd__diode_2
XANTENNA__4448__A2 _1524_ VGND VGND VPWR VPWR sky130_fd_sc_hd__diode_2
XANTENNA__3656__B1 _0867_ VGND VGND VPWR VPWR sky130_fd_sc_hd__diode_2
XANTENNA__4735__B _1672_ VGND VGND VPWR VPWR sky130_fd_sc_hd__diode_2
XFILLER_0_69_440 VGND VGND VPWR VPWR sky130_fd_sc_hd__fill_2
XFILLER_0_84_421 VGND VGND VPWR VPWR sky130_fd_sc_hd__fill_1
XFILLER_0_57_635 VGND VGND VPWR VPWR sky130_fd_sc_hd__fill_2
XFILLER_0_29_326 VGND VGND VPWR VPWR sky130_fd_sc_hd__decap_4
XTAP_1182 VGND VPWR sky130_fd_sc_hd__tapvpwrvgnd_1
XTAP_1171 VGND VPWR sky130_fd_sc_hd__tapvpwrvgnd_1
XTAP_1160 VGND VPWR sky130_fd_sc_hd__tapvpwrvgnd_1
XFILLER_0_60_25 VGND VGND VPWR VPWR sky130_fd_sc_hd__decap_3
XFILLER_0_57_668 VGND VGND VPWR VPWR sky130_fd_sc_hd__fill_2
XTAP_1193 VGND VPWR sky130_fd_sc_hd__tapvpwrvgnd_1
XANTENNA__4384__A1 _1407_ VGND VGND VPWR VPWR sky130_fd_sc_hd__diode_2
X_4560_ _1536_ u_pe_array.g_pe_row\[2\].g_pe_col\[2\].u_pe.psum_out\[10\] VGND VGND
+ VPWR VPWR _1630_ sky130_fd_sc_hd__nand2_1
XFILLER_0_107_3 VPWR VGND VPWR VGND sky130_ef_sc_hd__decap_12
XFILLER_0_8_15 VGND VGND VPWR VPWR sky130_fd_sc_hd__decap_4
XFILLER_0_69_34 VPWR VGND VPWR VGND sky130_ef_sc_hd__decap_12
X_3511_ _0754_ _0767_ VGND VGND VPWR VPWR _0768_ sky130_fd_sc_hd__and2_1
X_4491_ u_pe_array.g_pe_row\[2\].g_pe_col\[2\].u_pe.act_val\[3\] VGND VGND VPWR VPWR
+ _1567_ sky130_fd_sc_hd__inv_2
Xhold617 u_pe_array.g_pe_row\[2\].g_pe_col\[2\].u_pe.psum_out\[3\] VGND VGND VPWR
+ VPWR net693 sky130_fd_sc_hd__dlygate4sd3_1
Xhold606 u_pe_array.g_pe_row\[3\].g_pe_col\[2\].u_pe.psum_out\[5\] VGND VGND VPWR
+ VPWR net682 sky130_fd_sc_hd__dlygate4sd3_1
Xhold639 u_pe_array.g_pe_row\[0\].g_pe_col\[1\].u_pe.psum_out\[2\] VGND VGND VPWR
+ VPWR net715 sky130_fd_sc_hd__dlygate4sd3_1
X_6230_ _3023_ _2992_ u_pe_array.g_pe_row\[0\].g_pe_col\[0\].u_pe.psum_out\[4\] VGND
+ VGND VPWR VPWR _3024_ sky130_fd_sc_hd__a21oi_1
X_3442_ u_fsm.state\[0\] VGND VGND VPWR VPWR _0718_ sky130_fd_sc_hd__buf_2
Xhold628 u_pe_array.g_pe_row\[3\].g_pe_col\[3\].u_pe.psum_out\[5\] VGND VGND VPWR
+ VPWR net704 sky130_fd_sc_hd__dlygate4sd3_1
X_6161_ _2945_ _2948_ _2953_ _2965_ VGND VGND VPWR VPWR _2966_ sky130_fd_sc_hd__a211o_1
XTAP_900 VGND VPWR sky130_fd_sc_hd__tapvpwrvgnd_1
XFILLER_0_0_643 VGND VGND VPWR VPWR sky130_fd_sc_hd__fill_1
XTAP_944 VGND VPWR sky130_fd_sc_hd__tapvpwrvgnd_1
XTAP_933 VGND VPWR sky130_fd_sc_hd__tapvpwrvgnd_1
XTAP_922 VGND VPWR sky130_fd_sc_hd__tapvpwrvgnd_1
XTAP_911 VGND VPWR sky130_fd_sc_hd__tapvpwrvgnd_1
X_5112_ _2072_ _2074_ _2088_ VGND VGND VPWR VPWR _2089_ sky130_fd_sc_hd__o21ai_2
X_6092_ _2890_ _2900_ _2899_ VGND VGND VPWR VPWR _2903_ sky130_fd_sc_hd__a21oi_1
XFILLER_0_85_77 VGND VGND VPWR VPWR sky130_fd_sc_hd__fill_2
XFILLER_0_85_55 VGND VGND VPWR VPWR sky130_fd_sc_hd__fill_1
XTAP_977 VGND VPWR sky130_fd_sc_hd__tapvpwrvgnd_1
XTAP_955 VGND VPWR sky130_fd_sc_hd__tapvpwrvgnd_1
XTAP_966 VGND VPWR sky130_fd_sc_hd__tapvpwrvgnd_1
XFILLER_0_109_73 VGND VGND VPWR VPWR sky130_fd_sc_hd__fill_2
XFILLER_0_85_88 VGND VGND VPWR VPWR sky130_fd_sc_hd__fill_2
XTAP_999 VGND VPWR sky130_fd_sc_hd__tapvpwrvgnd_1
XTAP_988 VGND VPWR sky130_fd_sc_hd__tapvpwrvgnd_1
X_5043_ net123 _1666_ _2026_ _1665_ VGND VGND VPWR VPWR _0260_ sky130_fd_sc_hd__a22o_1
XANTENNA__6617__S _3269_ VGND VGND VPWR VPWR sky130_fd_sc_hd__diode_2
XFILLER_0_18_93 VGND VGND VPWR VPWR sky130_fd_sc_hd__fill_1
X_6994_ clknet_leaf_29_clk _0073_ net817 VGND VGND VPWR VPWR u_pe_array.g_pe_row\[3\].g_pe_col\[0\].u_pe.move_reg\[6\]
+ sky130_fd_sc_hd__dfrtp_1
XFILLER_0_48_602 VGND VGND VPWR VPWR sky130_fd_sc_hd__fill_2
XFILLER_0_87_281 VGND VGND VPWR VPWR sky130_fd_sc_hd__fill_2
XANTENNA__3976__S _0755_ VGND VGND VPWR VPWR sky130_fd_sc_hd__diode_2
X_5945_ _2760_ _2770_ _2769_ VGND VGND VPWR VPWR _2784_ sky130_fd_sc_hd__a21o_1
X_5876_ u_pe_array.g_pe_row\[1\].g_pe_col\[1\].u_pe.act_val\[3\] u_pe_array.g_pe_row\[1\].g_pe_col\[1\].u_pe.psum_out\[3\]
+ _0770_ VGND VGND VPWR VPWR _2729_ sky130_fd_sc_hd__mux2_1
X_7615_ clknet_leaf_25_clk _0664_ VGND VGND VPWR VPWR u_pe_array.u_fifo1.buffer\[3\]\[12\]
+ sky130_fd_sc_hd__dfxtp_1
XFILLER_0_90_402 VGND VGND VPWR VPWR sky130_fd_sc_hd__fill_1
XFILLER_0_63_638 VGND VGND VPWR VPWR sky130_fd_sc_hd__fill_1
X_4827_ _1840_ VGND VGND VPWR VPWR _0230_ sky130_fd_sc_hd__clkbuf_1
XANTENNA__4375__A1 _1273_ VGND VGND VPWR VPWR sky130_fd_sc_hd__diode_2
XFILLER_0_28_392 VGND VGND VPWR VPWR sky130_fd_sc_hd__fill_2
XFILLER_0_105_239 VGND VGND VPWR VPWR sky130_fd_sc_hd__decap_4
XFILLER_0_90_468 VGND VGND VPWR VPWR sky130_fd_sc_hd__fill_2
X_7546_ clknet_leaf_78_clk _0595_ net815 VGND VGND VPWR VPWR u_pe_array.g_pe_row\[3\].g_pe_col\[3\].u_pe.move_reg\[7\]
+ sky130_fd_sc_hd__dfrtp_1
X_4758_ _1788_ net526 _1796_ VGND VGND VPWR VPWR _1797_ sky130_fd_sc_hd__mux2_1
XANTENNA__5492__A _2345_ VGND VGND VPWR VPWR sky130_fd_sc_hd__diode_2
X_4689_ _1709_ _1720_ _1721_ VGND VGND VPWR VPWR _1735_ sky130_fd_sc_hd__o21a_1
X_3709_ _0922_ _0923_ VGND VGND VPWR VPWR _0924_ sky130_fd_sc_hd__and2b_1
X_7477_ clknet_leaf_4_clk _0526_ VGND VGND VPWR VPWR u_pe_array.u_fifo2.buffer\[3\]\[3\]
+ sky130_fd_sc_hd__dfxtp_1
XFILLER_0_113_261 VPWR VGND VPWR VGND sky130_ef_sc_hd__decap_12
X_6428_ _3177_ VGND VGND VPWR VPWR _0494_ sky130_fd_sc_hd__clkbuf_1
XANTENNA__4127__B2 _1004_ VGND VGND VPWR VPWR sky130_fd_sc_hd__diode_2
XANTENNA__7264__RESET_B net812 VGND VGND VPWR VPWR sky130_fd_sc_hd__diode_2
XANTENNA__4678__A2 _1714_ VGND VGND VPWR VPWR sky130_fd_sc_hd__diode_2
XFILLER_0_101_478 VGND VGND VPWR VPWR sky130_fd_sc_hd__fill_2
X_6359_ _3132_ net339 _3110_ VGND VGND VPWR VPWR _3133_ sky130_fd_sc_hd__mux2_1
XFILLER_0_11_281 VGND VGND VPWR VPWR sky130_fd_sc_hd__decap_4
XANTENNA__5627__A1 _2258_ VGND VGND VPWR VPWR sky130_fd_sc_hd__diode_2
XANTENNA__6527__S _3224_ VGND VGND VPWR VPWR sky130_fd_sc_hd__diode_2
XFILLER_0_98_502 VGND VGND VPWR VPWR sky130_fd_sc_hd__fill_2
XFILLER_0_98_568 VGND VGND VPWR VPWR sky130_fd_sc_hd__fill_1
XPHY_210 VGND VGND VPWR VPWR sky130_fd_sc_hd__decap_3
XFILLER_0_85_229 VGND VGND VPWR VPWR sky130_fd_sc_hd__decap_4
XFILLER_0_66_421 VGND VGND VPWR VPWR sky130_fd_sc_hd__decap_3
XFILLER_0_14_29 VGND VGND VPWR VPWR sky130_fd_sc_hd__fill_1
XFILLER_0_39_613 VGND VGND VPWR VPWR sky130_fd_sc_hd__decap_3
XPHY_221 VGND VGND VPWR VPWR sky130_fd_sc_hd__decap_3
XANTENNA__4602__A2 _1524_ VGND VGND VPWR VPWR sky130_fd_sc_hd__diode_2
XFILLER_0_54_605 VGND VGND VPWR VPWR sky130_fd_sc_hd__fill_1
XFILLER_0_38_145 VGND VGND VPWR VPWR sky130_fd_sc_hd__fill_1
XFILLER_0_66_498 VGND VGND VPWR VPWR sky130_fd_sc_hd__fill_1
XFILLER_0_26_318 VGND VGND VPWR VPWR sky130_fd_sc_hd__fill_2
XFILLER_0_26_329 VGND VGND VPWR VPWR sky130_fd_sc_hd__fill_2
XFILLER_0_93_284 VGND VGND VPWR VPWR sky130_fd_sc_hd__decap_3
XFILLER_0_53_159 VGND VGND VPWR VPWR sky130_fd_sc_hd__decap_8
XANTENNA_clkbuf_leaf_73_clk_A clknet_3_5__leaf_clk VGND VGND VPWR VPWR sky130_fd_sc_hd__diode_2
XFILLER_0_34_373 VGND VGND VPWR VPWR sky130_fd_sc_hd__fill_2
XFILLER_0_1_429 VPWR VGND VPWR VGND sky130_ef_sc_hd__decap_12
XANTENNA__4118__A1 u_pe_array.g_pe_row\[3\].g_pe_col\[3\].u_pe.act_val\[5\] VGND VGND
+ VPWR VPWR sky130_fd_sc_hd__diode_2
XFILLER_0_39_15 VGND VGND VPWR VPWR sky130_fd_sc_hd__decap_3
XANTENNA_clkbuf_leaf_88_clk_A clknet_3_1__leaf_clk VGND VGND VPWR VPWR sky130_fd_sc_hd__diode_2
Xhold3 u_pe_array.g_pe_row\[3\].g_pe_col\[1\].u_pe.w_buffer\[0\] VGND VGND VPWR VPWR
+ net79 sky130_fd_sc_hd__dlygate4sd3_1
XANTENNA__6987__RESET_B net76 VGND VGND VPWR VPWR sky130_fd_sc_hd__diode_2
XFILLER_0_89_502 VGND VGND VPWR VPWR sky130_fd_sc_hd__fill_2
XANTENNA__6916__RESET_B net813 VGND VGND VPWR VPWR sky130_fd_sc_hd__diode_2
XANTENNA_clkbuf_leaf_11_clk_A clknet_3_1__leaf_clk VGND VGND VPWR VPWR sky130_fd_sc_hd__diode_2
XFILLER_0_89_568 VGND VGND VPWR VPWR sky130_fd_sc_hd__fill_1
XANTENNA__6043__B2 _0722_ VGND VGND VPWR VPWR sky130_fd_sc_hd__diode_2
XFILLER_0_71_35 VGND VGND VPWR VPWR sky130_fd_sc_hd__fill_1
XFILLER_0_69_281 VGND VGND VPWR VPWR sky130_fd_sc_hd__fill_2
X_3991_ u_pe_array.g_pe_row\[3\].g_pe_col\[1\].u_pe.w_reg\[0\] u_pe_array.g_pe_row\[3\].g_pe_col\[1\].u_pe.act_val\[2\]
+ VGND VGND VPWR VPWR _1153_ sky130_fd_sc_hd__nand2_1
XANTENNA_clkbuf_leaf_26_clk_A clknet_3_2__leaf_clk VGND VGND VPWR VPWR sky130_fd_sc_hd__diode_2
XFILLER_0_71_57 VGND VGND VPWR VPWR sky130_fd_sc_hd__fill_1
XFILLER_0_9_529 VPWR VGND VPWR VGND sky130_ef_sc_hd__decap_12
XFILLER_0_29_123 VGND VGND VPWR VPWR sky130_fd_sc_hd__fill_2
XFILLER_0_29_134 VGND VGND VPWR VPWR sky130_fd_sc_hd__decap_4
X_5730_ u_pe_array.g_pe_row\[0\].g_pe_col\[3\].u_pe.psum_out\[10\] u_pe_array.g_pe_row\[0\].g_pe_col\[3\].u_pe.move_reg\[10\]
+ _2469_ VGND VGND VPWR VPWR _2604_ sky130_fd_sc_hd__mux2_1
XFILLER_0_84_251 VGND VGND VPWR VPWR sky130_fd_sc_hd__fill_1
X_7400_ clknet_leaf_43_clk _0450_ net817 VGND VGND VPWR VPWR u_pe_array.g_pe_row\[0\].g_pe_col\[0\].u_pe.psum_out\[4\]
+ sky130_fd_sc_hd__dfrtp_1
X_5661_ _2526_ _2527_ _2539_ _2549_ VGND VGND VPWR VPWR _2552_ sky130_fd_sc_hd__or4_1
XANTENNA__6900__S _3427_ VGND VGND VPWR VPWR sky130_fd_sc_hd__diode_2
X_4612_ net143 _1524_ _1664_ _1665_ VGND VGND VPWR VPWR _0190_ sky130_fd_sc_hd__a22o_1
X_5592_ u_pe_array.g_pe_row\[1\].g_pe_col\[0\].u_pe.act_val\[0\] VGND VGND VPWR VPWR
+ _2489_ sky130_fd_sc_hd__inv_2
XFILLER_0_4_201 VGND VGND VPWR VPWR sky130_fd_sc_hd__fill_1
X_7331_ clknet_leaf_45_clk _0388_ net812 VGND VGND VPWR VPWR u_pe_array.g_pe_row\[0\].g_pe_col\[1\].u_pe.act_val\[0\]
+ sky130_fd_sc_hd__dfrtp_2
XFILLER_0_4_267 VGND VGND VPWR VPWR sky130_fd_sc_hd__fill_2
XFILLER_0_13_513 VGND VGND VPWR VPWR sky130_fd_sc_hd__decap_4
X_4543_ u_pe_array.g_pe_row\[2\].g_pe_col\[2\].u_pe.psum_out\[8\] u_pe_array.g_pe_row\[2\].g_pe_col\[2\].u_pe.psum_out\[7\]
+ _1536_ VGND VGND VPWR VPWR _1615_ sky130_fd_sc_hd__and3b_1
Xhold436 u_pe_array.g_pe_row\[1\].g_pe_col\[0\].u_pe.psum_out\[12\] VGND VGND VPWR
+ VPWR net512 sky130_fd_sc_hd__dlygate4sd3_1
X_7262_ clknet_leaf_48_clk _0323_ net812 VGND VGND VPWR VPWR u_pe_array.g_pe_row\[1\].g_pe_col\[1\].u_pe.psum_out\[6\]
+ sky130_fd_sc_hd__dfrtp_1
Xhold425 u_pe_array.u_fifo1.buffer\[7\]\[2\] VGND VGND VPWR VPWR net501 sky130_fd_sc_hd__dlygate4sd3_1
XFILLER_0_52_192 VGND VGND VPWR VPWR sky130_fd_sc_hd__fill_2
XFILLER_0_20_83 VGND VGND VPWR VPWR sky130_fd_sc_hd__fill_1
Xhold414 u_pe_array.u_fifo2.buffer\[3\]\[2\] VGND VGND VPWR VPWR net490 sky130_fd_sc_hd__dlygate4sd3_1
XANTENNA__4420__S _0828_ VGND VGND VPWR VPWR sky130_fd_sc_hd__diode_2
Xhold403 u_pe_array.u_fifo2.buffer\[3\]\[3\] VGND VGND VPWR VPWR net479 sky130_fd_sc_hd__dlygate4sd3_1
X_6213_ _3002_ _3004_ VGND VGND VPWR VPWR _3008_ sky130_fd_sc_hd__nand2_1
Xhold447 u_pe_array.u_fifo1.buffer\[8\]\[2\] VGND VGND VPWR VPWR net523 sky130_fd_sc_hd__dlygate4sd3_1
X_4474_ net756 _1152_ _1550_ _1551_ VGND VGND VPWR VPWR _0166_ sky130_fd_sc_hd__a22o_1
XFILLER_0_0_440 VGND VGND VPWR VPWR sky130_fd_sc_hd__decap_8
Xhold458 u_pe_array.u_fifo2.buffer\[4\]\[2\] VGND VGND VPWR VPWR net534 sky130_fd_sc_hd__dlygate4sd3_1
Xhold469 u_pe_array.u_fifo2.buffer\[8\]\[5\] VGND VGND VPWR VPWR net545 sky130_fd_sc_hd__dlygate4sd3_1
XFILLER_0_40_365 VGND VGND VPWR VPWR sky130_fd_sc_hd__decap_3
XFILLER_0_110_253 VGND VGND VPWR VPWR sky130_fd_sc_hd__decap_6
XFILLER_0_96_54 VGND VGND VPWR VPWR sky130_fd_sc_hd__decap_6
X_7193_ clknet_leaf_52_clk net124 net812 VGND VGND VPWR VPWR u_pe_array.g_pe_row\[1\].g_pe_col\[2\].u_pe.move_reg\[12\]
+ sky130_fd_sc_hd__dfrtp_1
XFILLER_0_0_473 VGND VGND VPWR VPWR sky130_fd_sc_hd__decap_3
XFILLER_0_21_590 VGND VGND VPWR VPWR sky130_fd_sc_hd__fill_2
X_6144_ _2873_ u_pe_array.g_pe_row\[0\].g_pe_col\[1\].u_pe.psum_out\[7\] _2949_ _2950_
+ VGND VGND VPWR VPWR _2951_ sky130_fd_sc_hd__a22oi_1
XTAP_730 VGND VPWR sky130_fd_sc_hd__tapvpwrvgnd_1
XTAP_741 VGND VPWR sky130_fd_sc_hd__tapvpwrvgnd_1
XTAP_752 VGND VPWR sky130_fd_sc_hd__tapvpwrvgnd_1
XANTENNA__6347__S _3110_ VGND VGND VPWR VPWR sky130_fd_sc_hd__diode_2
X_6075_ _2880_ _2886_ _0885_ VGND VGND VPWR VPWR _2888_ sky130_fd_sc_hd__o21a_1
XTAP_785 VGND VPWR sky130_fd_sc_hd__tapvpwrvgnd_1
XTAP_774 VGND VPWR sky130_fd_sc_hd__tapvpwrvgnd_1
XTAP_763 VGND VPWR sky130_fd_sc_hd__tapvpwrvgnd_1
XTAP_796 VGND VPWR sky130_fd_sc_hd__tapvpwrvgnd_1
X_5026_ u_pe_array.u_fifo2.buffer\[8\]\[5\] _1960_ _2012_ _2016_ _0819_ VGND VGND
+ VPWR VPWR _2017_ sky130_fd_sc_hd__a221o_2
XFILLER_0_95_505 VGND VGND VPWR VPWR sky130_fd_sc_hd__fill_1
Xclkbuf_leaf_92_clk clknet_3_0__leaf_clk VGND VGND VPWR VPWR clknet_leaf_92_clk sky130_fd_sc_hd__clkbuf_16
XFILLER_0_48_421 VGND VGND VPWR VPWR sky130_fd_sc_hd__decap_3
X_6977_ clknet_leaf_10_clk _0056_ net819 VGND VGND VPWR VPWR u_pe_array.g_pe_row\[3\].g_pe_col\[2\].u_pe.psum_out\[4\]
+ sky130_fd_sc_hd__dfrtp_1
XANTENNA__4391__A _1407_ VGND VGND VPWR VPWR sky130_fd_sc_hd__diode_2
X_5928_ _2763_ _2767_ VGND VGND VPWR VPWR _2768_ sky130_fd_sc_hd__xnor2_1
XFILLER_0_36_605 VGND VGND VPWR VPWR sky130_fd_sc_hd__decap_4
XANTENNA__6337__A2 _1130_ VGND VGND VPWR VPWR sky130_fd_sc_hd__diode_2
XFILLER_0_35_126 VGND VGND VPWR VPWR sky130_fd_sc_hd__fill_2
X_5859_ _2709_ _2712_ _2717_ VGND VGND VPWR VPWR _2719_ sky130_fd_sc_hd__or3_1
XANTENNA__6810__S _3382_ VGND VGND VPWR VPWR sky130_fd_sc_hd__diode_2
XFILLER_0_63_479 VGND VGND VPWR VPWR sky130_fd_sc_hd__fill_2
XFILLER_0_63_457 VGND VGND VPWR VPWR sky130_fd_sc_hd__fill_2
XFILLER_0_9_80 VGND VGND VPWR VPWR sky130_fd_sc_hd__fill_1
X_7529_ clknet_leaf_5_clk _0578_ VGND VGND VPWR VPWR u_pe_array.u_fifo2.buffer\[7\]\[3\]
+ sky130_fd_sc_hd__dfxtp_1
XFILLER_0_43_181 VGND VGND VPWR VPWR sky130_fd_sc_hd__decap_3
XFILLER_0_16_395 VGND VGND VPWR VPWR sky130_fd_sc_hd__fill_2
XFILLER_0_31_332 VGND VGND VPWR VPWR sky130_fd_sc_hd__fill_2
XFILLER_0_31_387 VGND VGND VPWR VPWR sky130_fd_sc_hd__fill_2
XANTENNA_input15_A v_in0[0] VGND VGND VPWR VPWR sky130_fd_sc_hd__diode_2
Xclkbuf_leaf_83_clk clknet_3_1__leaf_clk VGND VGND VPWR VPWR clknet_leaf_83_clk sky130_fd_sc_hd__clkbuf_16
XANTENNA__5397__A _1787_ VGND VGND VPWR VPWR sky130_fd_sc_hd__diode_2
XFILLER_0_39_465 VGND VGND VPWR VPWR sky130_fd_sc_hd__fill_2
XFILLER_0_39_476 VGND VGND VPWR VPWR sky130_fd_sc_hd__fill_2
XANTENNA__6005__B _2743_ VGND VGND VPWR VPWR sky130_fd_sc_hd__diode_2
XFILLER_0_109_397 VGND VGND VPWR VPWR sky130_fd_sc_hd__fill_2
XFILLER_0_109_375 VGND VGND VPWR VPWR sky130_fd_sc_hd__decap_3
XFILLER_0_81_265 VGND VGND VPWR VPWR sky130_fd_sc_hd__fill_2
XFILLER_0_81_254 VGND VGND VPWR VPWR sky130_fd_sc_hd__fill_2
XFILLER_0_81_243 VGND VGND VPWR VPWR sky130_fd_sc_hd__fill_2
XFILLER_0_54_457 VGND VGND VPWR VPWR sky130_fd_sc_hd__decap_4
XFILLER_0_26_148 VGND VGND VPWR VPWR sky130_fd_sc_hd__fill_1
XANTENNA__7186__RESET_B net73 VGND VGND VPWR VPWR sky130_fd_sc_hd__diode_2
XFILLER_0_35_671 VGND VGND VPWR VPWR sky130_fd_sc_hd__fill_1
XANTENNA__3645__A _0861_ VGND VGND VPWR VPWR sky130_fd_sc_hd__diode_2
XANTENNA__7115__RESET_B net816 VGND VGND VPWR VPWR sky130_fd_sc_hd__diode_2
XFILLER_0_50_630 VGND VGND VPWR VPWR sky130_fd_sc_hd__fill_2
XFILLER_0_22_321 VGND VGND VPWR VPWR sky130_fd_sc_hd__decap_3
XFILLER_0_1_237 VPWR VGND VPWR VGND sky130_ef_sc_hd__decap_12
XFILLER_0_22_365 VGND VGND VPWR VPWR sky130_fd_sc_hd__fill_2
XANTENNA__5839__A1 _2258_ VGND VGND VPWR VPWR sky130_fd_sc_hd__diode_2
XFILLER_0_5_27 VPWR VGND VPWR VGND sky130_ef_sc_hd__decap_12
X_4190_ u_pe_array.g_pe_row\[3\].g_pe_col\[0\].u_pe.psum_out\[4\] _1307_ _1308_ VGND
+ VGND VPWR VPWR _1321_ sky130_fd_sc_hd__a21boi_1
XANTENNA__4275__B1 _1258_ VGND VGND VPWR VPWR sky130_fd_sc_hd__diode_2
XANTENNA__4814__A2 _1666_ VGND VGND VPWR VPWR sky130_fd_sc_hd__diode_2
X_6900_ net264 _3122_ _3427_ VGND VGND VPWR VPWR _3434_ sky130_fd_sc_hd__mux2_1
XFILLER_0_77_505 VGND VGND VPWR VPWR sky130_fd_sc_hd__fill_2
Xclkbuf_leaf_74_clk clknet_3_4__leaf_clk VGND VGND VPWR VPWR clknet_leaf_74_clk sky130_fd_sc_hd__clkbuf_16
XFILLER_0_106_41 VPWR VGND VPWR VGND sky130_ef_sc_hd__decap_12
X_6831_ _3396_ VGND VGND VPWR VPWR _3397_ sky130_fd_sc_hd__clkbuf_8
XFILLER_0_92_508 VGND VGND VPWR VPWR sky130_fd_sc_hd__decap_3
X_6762_ net225 _3124_ net62 VGND VGND VPWR VPWR _3360_ sky130_fd_sc_hd__mux2_1
X_3974_ u_pe_array.g_pe_row\[2\].g_pe_col\[0\].u_pe.move_reg\[11\] u_pe_array.g_pe_row\[2\].g_pe_col\[0\].u_pe.psum_out\[11\]
+ _0755_ VGND VGND VPWR VPWR _1140_ sky130_fd_sc_hd__mux2_1
XFILLER_0_9_337 VGND VGND VPWR VPWR sky130_fd_sc_hd__fill_2
XFILLER_0_15_94 VGND VGND VPWR VPWR sky130_fd_sc_hd__decap_3
X_6693_ _3106_ u_pe_array.u_fifo1.wr_ptr\[1\] _3323_ VGND VGND VPWR VPWR _3324_ sky130_fd_sc_hd__nor3_4
X_5713_ u_pe_array.g_pe_row\[0\].g_pe_col\[3\].u_pe.act_val\[2\] u_pe_array.g_pe_row\[0\].g_pe_col\[3\].u_pe.psum_out\[2\]
+ _0770_ VGND VGND VPWR VPWR _2595_ sky130_fd_sc_hd__mux2_1
X_5644_ _2533_ _2534_ _2536_ VGND VGND VPWR VPWR _2537_ sky130_fd_sc_hd__and3_1
XFILLER_0_17_159 VGND VGND VPWR VPWR sky130_fd_sc_hd__fill_2
XFILLER_0_79_3 VPWR VGND VPWR VGND sky130_ef_sc_hd__decap_12
Xhold200 u_pe_array.g_pe_row\[3\].g_pe_col\[1\].u_pe.psum_out\[11\] VGND VGND VPWR
+ VPWR net276 sky130_fd_sc_hd__dlygate4sd3_1
Xhold211 u_pe_array.u_fifo2.buffer\[5\]\[8\] VGND VGND VPWR VPWR net287 sky130_fd_sc_hd__dlygate4sd3_1
XFILLER_0_13_332 VGND VGND VPWR VPWR sky130_fd_sc_hd__fill_1
X_5575_ u_pe_array.g_pe_row\[1\].g_pe_col\[3\].u_pe.psum_out\[12\] u_pe_array.g_pe_row\[1\].g_pe_col\[3\].u_pe.move_reg\[12\]
+ _2469_ VGND VGND VPWR VPWR _2475_ sky130_fd_sc_hd__mux2_1
X_7314_ clknet_leaf_79_clk net105 net814 VGND VGND VPWR VPWR u_pe_array.g_pe_row\[0\].g_pe_col\[3\].u_pe.w_reg\[0\]
+ sky130_fd_sc_hd__dfrtp_4
Xhold244 u_pe_array.u_fifo1.buffer\[7\]\[9\] VGND VGND VPWR VPWR net320 sky130_fd_sc_hd__dlygate4sd3_1
Xhold222 u_pe_array.u_fifo1.buffer\[1\]\[12\] VGND VGND VPWR VPWR net298 sky130_fd_sc_hd__dlygate4sd3_1
Xhold233 u_pe_array.u_fifo2.buffer\[7\]\[8\] VGND VGND VPWR VPWR net309 sky130_fd_sc_hd__dlygate4sd3_1
X_4526_ _1597_ _1598_ _1596_ VGND VGND VPWR VPWR _1600_ sky130_fd_sc_hd__o21a_1
XFILLER_0_111_573 VPWR VGND VPWR VGND sky130_ef_sc_hd__decap_12
X_7245_ clknet_leaf_40_clk _0308_ net75 VGND VGND VPWR VPWR u_pe_array.g_pe_row\[1\].g_pe_col\[0\].u_pe.act_val\[4\]
+ sky130_fd_sc_hd__dfrtp_2
Xhold255 u_pe_array.g_pe_row\[2\].g_pe_col\[1\].u_pe.psum_out\[11\] VGND VGND VPWR
+ VPWR net331 sky130_fd_sc_hd__dlygate4sd3_1
Xhold277 u_pe_array.u_fifo2.buffer\[2\]\[9\] VGND VGND VPWR VPWR net353 sky130_fd_sc_hd__dlygate4sd3_1
Xhold266 u_pe_array.g_pe_row\[2\].g_pe_col\[2\].u_pe.move_reg\[11\] VGND VGND VPWR
+ VPWR net342 sky130_fd_sc_hd__dlygate4sd3_1
X_4457_ u_pe_array.g_pe_row\[2\].g_pe_col\[2\].u_pe.w_reg\[1\] VGND VGND VPWR VPWR
+ _1536_ sky130_fd_sc_hd__clkbuf_8
XFILLER_0_40_173 VGND VGND VPWR VPWR sky130_fd_sc_hd__fill_2
XFILLER_0_40_195 VGND VGND VPWR VPWR sky130_fd_sc_hd__fill_1
Xhold299 u_pe_array.u_fifo1.buffer\[0\]\[5\] VGND VGND VPWR VPWR net375 sky130_fd_sc_hd__dlygate4sd3_1
X_7176_ clknet_leaf_41_clk _0243_ net813 VGND VGND VPWR VPWR u_pe_array.g_pe_row\[2\].g_pe_col\[0\].u_pe.psum_out\[10\]
+ sky130_fd_sc_hd__dfrtp_2
XFILLER_0_0_281 VPWR VGND VPWR VGND sky130_ef_sc_hd__decap_12
Xhold288 u_pe_array.u_fifo2.buffer\[8\]\[9\] VGND VGND VPWR VPWR net364 sky130_fd_sc_hd__dlygate4sd3_1
XANTENNA__4502__B2 _0916_ VGND VGND VPWR VPWR sky130_fd_sc_hd__diode_2
X_6127_ _2933_ _2934_ _2935_ VGND VGND VPWR VPWR _2936_ sky130_fd_sc_hd__or3_1
X_4388_ _1477_ _1481_ _1486_ net72 VGND VGND VPWR VPWR _1488_ sky130_fd_sc_hd__a31o_1
XANTENNA_input7_A h_in1[0] VGND VGND VPWR VPWR sky130_fd_sc_hd__diode_2
XTAP_560 VGND VPWR sky130_fd_sc_hd__tapvpwrvgnd_1
XTAP_571 VGND VPWR sky130_fd_sc_hd__tapvpwrvgnd_1
XTAP_582 VGND VPWR sky130_fd_sc_hd__tapvpwrvgnd_1
XTAP_593 VGND VPWR sky130_fd_sc_hd__tapvpwrvgnd_1
X_6058_ u_pe_array.g_pe_row\[0\].g_pe_col\[1\].u_pe.w_reg\[0\] u_pe_array.g_pe_row\[0\].g_pe_col\[1\].u_pe.act_val\[1\]
+ VGND VGND VPWR VPWR _2872_ sky130_fd_sc_hd__nand2_1
Xclkbuf_leaf_65_clk clknet_3_5__leaf_clk VGND VGND VPWR VPWR clknet_leaf_65_clk sky130_fd_sc_hd__clkbuf_16
X_5009_ u_pe_array.g_pe_row\[0\].g_pe_col\[2\].u_pe.act_val\[3\] u_pe_array.g_pe_row\[0\].g_pe_col\[2\].u_pe.psum_out\[3\]
+ _0756_ VGND VGND VPWR VPWR _2002_ sky130_fd_sc_hd__mux2_1
XANTENNA__4805__A2 _1666_ VGND VGND VPWR VPWR sky130_fd_sc_hd__diode_2
XANTENNA__5010__A _1787_ VGND VGND VPWR VPWR sky130_fd_sc_hd__diode_2
XFILLER_0_36_413 VGND VGND VPWR VPWR sky130_fd_sc_hd__fill_2
XFILLER_0_106_301 VGND VGND VPWR VPWR sky130_fd_sc_hd__decap_4
XANTENNA__5518__B1 _2071_ VGND VGND VPWR VPWR sky130_fd_sc_hd__diode_2
XANTENNA__3792__A2 _0834_ VGND VGND VPWR VPWR sky130_fd_sc_hd__diode_2
XFILLER_0_17_671 VGND VGND VPWR VPWR sky130_fd_sc_hd__fill_1
XANTENNA__3465__A _0728_ VGND VGND VPWR VPWR sky130_fd_sc_hd__diode_2
XFILLER_0_51_449 VGND VGND VPWR VPWR sky130_fd_sc_hd__fill_2
XFILLER_0_16_192 VGND VGND VPWR VPWR sky130_fd_sc_hd__fill_2
XFILLER_0_36_49 VGND VGND VPWR VPWR sky130_fd_sc_hd__fill_1
Xclkbuf_leaf_56_clk clknet_3_6__leaf_clk VGND VGND VPWR VPWR clknet_leaf_56_clk sky130_fd_sc_hd__clkbuf_16
XFILLER_0_86_324 VGND VGND VPWR VPWR sky130_fd_sc_hd__decap_4
XFILLER_0_86_346 VGND VGND VPWR VPWR sky130_fd_sc_hd__fill_2
XANTENNA__5221__A2 _1714_ VGND VGND VPWR VPWR sky130_fd_sc_hd__diode_2
XANTENNA__5757__B1 _0885_ VGND VGND VPWR VPWR sky130_fd_sc_hd__diode_2
XFILLER_0_39_240 VGND VGND VPWR VPWR sky130_fd_sc_hd__fill_2
XFILLER_0_39_251 VGND VGND VPWR VPWR sky130_fd_sc_hd__decap_4
XANTENNA__7367__RESET_B net812 VGND VGND VPWR VPWR sky130_fd_sc_hd__diode_2
XANTENNA__3783__A2 _0834_ VGND VGND VPWR VPWR sky130_fd_sc_hd__diode_2
XFILLER_0_6_329 VGND VGND VPWR VPWR sky130_fd_sc_hd__fill_1
XFILLER_0_27_457 VGND VGND VPWR VPWR sky130_fd_sc_hd__fill_2
XFILLER_0_82_585 VGND VGND VPWR VPWR sky130_fd_sc_hd__decap_3
X_3690_ u_pe_array.g_pe_row\[3\].g_pe_col\[3\].u_pe.psum_out\[4\] _0904_ _0905_ VGND
+ VGND VPWR VPWR _0906_ sky130_fd_sc_hd__nand3_1
XFILLER_0_2_513 VPWR VGND VPWR VGND sky130_ef_sc_hd__decap_12
X_5360_ u_pe_array.g_pe_row\[0\].g_pe_col\[0\].u_pe.act_val\[1\] u_pe_array.g_pe_row\[0\].g_pe_col\[0\].u_pe.psum_out\[1\]
+ _0756_ VGND VGND VPWR VPWR _2299_ sky130_fd_sc_hd__mux2_1
XFILLER_0_2_557 VPWR VGND VPWR VGND sky130_ef_sc_hd__decap_12
X_5291_ u_pe_array.g_pe_row\[1\].g_pe_col\[2\].u_pe.psum_out\[8\] _2224_ VGND VGND
+ VPWR VPWR _2238_ sky130_fd_sc_hd__nor2_1
X_4311_ _1414_ _1416_ VGND VGND VPWR VPWR _1417_ sky130_fd_sc_hd__xnor2_2
X_4242_ _1347_ _1350_ _1355_ _1367_ VGND VGND VPWR VPWR _1368_ sky130_fd_sc_hd__a211o_1
XANTENNA__6931__RESET_B net819 VGND VGND VPWR VPWR sky130_fd_sc_hd__diode_2
XANTENNA__6485__A1 _1820_ VGND VGND VPWR VPWR sky130_fd_sc_hd__diode_2
XFILLER_0_10_368 VPWR VGND VPWR VGND sky130_ef_sc_hd__decap_12
X_7030_ clknet_leaf_80_clk _0107_ net815 VGND VGND VPWR VPWR u_pe_array.g_pe_row\[2\].g_pe_col\[3\].u_pe.move_reg\[12\]
+ sky130_fd_sc_hd__dfrtp_1
X_4173_ _1292_ _1302_ _1301_ VGND VGND VPWR VPWR _1305_ sky130_fd_sc_hd__a21oi_1
XFILLER_0_93_77 VGND VGND VPWR VPWR sky130_fd_sc_hd__fill_1
XANTENNA__6625__S _3269_ VGND VGND VPWR VPWR sky130_fd_sc_hd__diode_2
Xclkbuf_leaf_47_clk clknet_3_7__leaf_clk VGND VGND VPWR VPWR clknet_leaf_47_clk sky130_fd_sc_hd__clkbuf_16
XFILLER_0_77_302 VGND VGND VPWR VPWR sky130_fd_sc_hd__fill_2
XFILLER_0_89_184 VGND VGND VPWR VPWR sky130_fd_sc_hd__decap_3
X_6814_ net529 _3120_ _3382_ VGND VGND VPWR VPWR _3388_ sky130_fd_sc_hd__mux2_1
X_6745_ net298 _3134_ net64 VGND VGND VPWR VPWR _3351_ sky130_fd_sc_hd__mux2_1
X_3957_ u_pe_array.g_pe_row\[2\].g_pe_col\[0\].u_pe.act_val\[4\] u_pe_array.g_pe_row\[2\].g_pe_col\[0\].u_pe.psum_out\[4\]
+ _0755_ VGND VGND VPWR VPWR _1130_ sky130_fd_sc_hd__mux2_1
XFILLER_0_58_582 VGND VGND VPWR VPWR sky130_fd_sc_hd__decap_3
XFILLER_0_18_424 VGND VGND VPWR VPWR sky130_fd_sc_hd__fill_2
XANTENNA__7037__RESET_B net817 VGND VGND VPWR VPWR sky130_fd_sc_hd__diode_2
XFILLER_0_18_457 VGND VGND VPWR VPWR sky130_fd_sc_hd__decap_4
X_6676_ net210 _3310_ _3311_ VGND VGND VPWR VPWR _0608_ sky130_fd_sc_hd__a21oi_1
XFILLER_0_5_340 VGND VGND VPWR VPWR sky130_fd_sc_hd__fill_2
X_3888_ _1070_ VGND VGND VPWR VPWR _1073_ sky130_fd_sc_hd__inv_2
X_5627_ _2258_ _2520_ _2521_ _2071_ net421 VGND VGND VPWR VPWR _0349_ sky130_fd_sc_hd__a32o_1
XFILLER_0_33_449 VGND VGND VPWR VPWR sky130_fd_sc_hd__fill_2
XFILLER_0_103_337 VGND VGND VPWR VPWR sky130_fd_sc_hd__fill_1
XANTENNA__3526__A2 _0769_ VGND VGND VPWR VPWR sky130_fd_sc_hd__diode_2
X_5558_ u_pe_array.g_pe_row\[1\].g_pe_col\[3\].u_pe.psum_out\[4\] u_pe_array.g_pe_row\[1\].g_pe_col\[3\].u_pe.act_val\[4\]
+ _0745_ VGND VGND VPWR VPWR _2466_ sky130_fd_sc_hd__mux2_1
X_4509_ _1581_ _1582_ VGND VGND VPWR VPWR _1584_ sky130_fd_sc_hd__nand2_1
XFILLER_0_111_381 VGND VGND VPWR VPWR sky130_fd_sc_hd__fill_2
XANTENNA__5704__S _0828_ VGND VGND VPWR VPWR sky130_fd_sc_hd__diode_2
X_5489_ _2407_ _2408_ _2406_ VGND VGND VPWR VPWR _2410_ sky130_fd_sc_hd__o21a_1
X_7228_ clknet_leaf_58_clk _0291_ net813 VGND VGND VPWR VPWR u_pe_array.g_pe_row\[1\].g_pe_col\[2\].u_pe.psum_out\[2\]
+ sky130_fd_sc_hd__dfrtp_1
XANTENNA__4828__B _0833_ VGND VGND VPWR VPWR sky130_fd_sc_hd__diode_2
XANTENNA__6228__A1 _2740_ VGND VGND VPWR VPWR sky130_fd_sc_hd__diode_2
X_7159_ clknet_leaf_69_clk _0228_ net814 VGND VGND VPWR VPWR u_pe_array.g_pe_row\[1\].g_pe_col\[3\].u_pe.move_reg\[8\]
+ sky130_fd_sc_hd__dfrtp_1
XTAP_390 VGND VPWR sky130_fd_sc_hd__tapvpwrvgnd_1
XANTENNA__6535__S _3224_ VGND VGND VPWR VPWR sky130_fd_sc_hd__diode_2
XANTENNA__5451__A2 _1714_ VGND VGND VPWR VPWR sky130_fd_sc_hd__diode_2
Xclkbuf_leaf_38_clk clknet_3_6__leaf_clk VGND VGND VPWR VPWR clknet_leaf_38_clk sky130_fd_sc_hd__clkbuf_16
XTAP_1512 VGND VPWR sky130_fd_sc_hd__tapvpwrvgnd_1
XTAP_1523 VGND VPWR sky130_fd_sc_hd__tapvpwrvgnd_1
XTAP_1501 VGND VPWR sky130_fd_sc_hd__tapvpwrvgnd_1
XFILLER_0_96_666 VGND VGND VPWR VPWR sky130_fd_sc_hd__decap_8
XPHY_30 VGND VGND VPWR VPWR sky130_fd_sc_hd__decap_3
XTAP_1567 VGND VPWR sky130_fd_sc_hd__tapvpwrvgnd_1
XTAP_1556 VGND VPWR sky130_fd_sc_hd__tapvpwrvgnd_1
XTAP_1545 VGND VPWR sky130_fd_sc_hd__tapvpwrvgnd_1
XTAP_1534 VGND VPWR sky130_fd_sc_hd__tapvpwrvgnd_1
XFILLER_0_68_379 VGND VGND VPWR VPWR sky130_fd_sc_hd__decap_4
XPHY_41 VGND VGND VPWR VPWR sky130_fd_sc_hd__decap_3
XPHY_52 VGND VGND VPWR VPWR sky130_fd_sc_hd__decap_3
XANTENNA__5739__B1 _2571_ VGND VGND VPWR VPWR sky130_fd_sc_hd__diode_2
XPHY_63 VGND VGND VPWR VPWR sky130_fd_sc_hd__decap_3
XPHY_74 VGND VGND VPWR VPWR sky130_fd_sc_hd__decap_3
XTAP_1589 VGND VPWR sky130_fd_sc_hd__tapvpwrvgnd_1
XTAP_1578 VGND VPWR sky130_fd_sc_hd__tapvpwrvgnd_1
XFILLER_0_83_349 VGND VGND VPWR VPWR sky130_fd_sc_hd__fill_2
XPHY_96 VGND VGND VPWR VPWR sky130_fd_sc_hd__decap_3
XPHY_85 VGND VGND VPWR VPWR sky130_fd_sc_hd__decap_3
XFILLER_0_64_541 VGND VGND VPWR VPWR sky130_fd_sc_hd__fill_2
XFILLER_0_107_665 VGND VGND VPWR VPWR sky130_fd_sc_hd__decap_6
XFILLER_0_91_393 VGND VGND VPWR VPWR sky130_fd_sc_hd__decap_4
XANTENNA__4714__B2 _0916_ VGND VGND VPWR VPWR sky130_fd_sc_hd__diode_2
Xclkbuf_leaf_29_clk clknet_3_3__leaf_clk VGND VGND VPWR VPWR clknet_leaf_29_clk sky130_fd_sc_hd__clkbuf_16
XANTENNA__7548__RESET_B net815 VGND VGND VPWR VPWR sky130_fd_sc_hd__diode_2
XFILLER_0_63_69 VGND VGND VPWR VPWR sky130_fd_sc_hd__decap_8
XFILLER_0_59_335 VGND VGND VPWR VPWR sky130_fd_sc_hd__fill_1
X_4860_ _1867_ VGND VGND VPWR VPWR _1868_ sky130_fd_sc_hd__inv_2
XFILLER_0_87_666 VGND VGND VPWR VPWR sky130_fd_sc_hd__fill_2
XFILLER_0_74_305 VGND VGND VPWR VPWR sky130_fd_sc_hd__fill_1
XFILLER_0_27_210 VGND VGND VPWR VPWR sky130_fd_sc_hd__fill_2
X_3811_ u_pe_array.g_pe_row\[3\].g_pe_col\[2\].u_pe.psum_out\[11\] u_pe_array.g_pe_row\[3\].g_pe_col\[2\].u_pe.move_reg\[11\]
+ _0734_ VGND VGND VPWR VPWR _1005_ sky130_fd_sc_hd__mux2_1
XANTENNA__7130__RESET_B net816 VGND VGND VPWR VPWR sky130_fd_sc_hd__diode_2
X_4791_ _1818_ net357 _1796_ VGND VGND VPWR VPWR _1819_ sky130_fd_sc_hd__mux2_1
X_6530_ _3231_ VGND VGND VPWR VPWR _0542_ sky130_fd_sc_hd__clkbuf_1
XFILLER_0_27_221 VGND VGND VPWR VPWR sky130_fd_sc_hd__decap_3
XFILLER_0_27_254 VGND VGND VPWR VPWR sky130_fd_sc_hd__decap_4
XFILLER_0_82_371 VGND VGND VPWR VPWR sky130_fd_sc_hd__fill_2
XFILLER_0_82_360 VGND VGND VPWR VPWR sky130_fd_sc_hd__fill_2
XFILLER_0_12_62 VGND VGND VPWR VPWR sky130_fd_sc_hd__fill_2
X_3742_ u_pe_array.g_pe_row\[3\].g_pe_col\[3\].u_pe.psum_out\[8\] _0940_ VGND VGND
+ VPWR VPWR _0954_ sky130_fd_sc_hd__nor2_1
XFILLER_0_27_276 VGND VGND VPWR VPWR sky130_fd_sc_hd__fill_2
X_3673_ u_pe_array.g_pe_row\[3\].g_pe_col\[3\].u_pe.act_val\[2\] VGND VGND VPWR VPWR
+ _0890_ sky130_fd_sc_hd__inv_2
XFILLER_0_15_449 VGND VGND VPWR VPWR sky130_fd_sc_hd__decap_3
X_6461_ net472 _1788_ _3194_ VGND VGND VPWR VPWR _3195_ sky130_fd_sc_hd__mux2_1
X_5412_ u_pe_array.g_pe_row\[0\].g_pe_col\[0\].u_pe.psum_out\[12\] u_pe_array.g_pe_row\[0\].g_pe_col\[0\].u_pe.move_reg\[12\]
+ _1661_ VGND VGND VPWR VPWR _2340_ sky130_fd_sc_hd__mux2_1
X_6392_ net731 _3152_ _3155_ VGND VGND VPWR VPWR _0480_ sky130_fd_sc_hd__o21a_1
XFILLER_0_100_307 VGND VGND VPWR VPWR sky130_fd_sc_hd__fill_1
XFILLER_0_88_88 VGND VGND VPWR VPWR sky130_fd_sc_hd__fill_2
X_5343_ u_pe_array.u_fifo1.rd_ptr\[0\] _2277_ u_pe_array.u_fifo1.rd_ptr\[1\] VGND
+ VGND VPWR VPWR _2283_ sky130_fd_sc_hd__and3b_2
XFILLER_0_2_365 VGND VGND VPWR VPWR sky130_fd_sc_hd__decap_6
XANTENNA__6458__A1 _1820_ VGND VGND VPWR VPWR sky130_fd_sc_hd__diode_2
X_5274_ _1725_ _2220_ _2222_ _2071_ net411 VGND VGND VPWR VPWR _0295_ sky130_fd_sc_hd__a32o_1
X_4225_ _1275_ u_pe_array.g_pe_row\[3\].g_pe_col\[0\].u_pe.psum_out\[7\] _1351_ _1352_
+ VGND VGND VPWR VPWR _1353_ sky130_fd_sc_hd__a22oi_1
X_7013_ clknet_leaf_12_clk _0090_ net818 VGND VGND VPWR VPWR u_pe_array.g_pe_row\[3\].g_pe_col\[1\].u_pe.psum_out\[10\]
+ sky130_fd_sc_hd__dfrtp_1
X_4156_ _1282_ _1288_ _0885_ VGND VGND VPWR VPWR _1290_ sky130_fd_sc_hd__o21a_1
XANTENNA__7289__RESET_B net813 VGND VGND VPWR VPWR sky130_fd_sc_hd__diode_2
X_4087_ _1235_ _1240_ VGND VGND VPWR VPWR _1241_ sky130_fd_sc_hd__nor2_1
XFILLER_0_78_633 VGND VGND VPWR VPWR sky130_fd_sc_hd__decap_4
XANTENNA__6630__B2 _3284_ VGND VGND VPWR VPWR sky130_fd_sc_hd__diode_2
XANTENNA__7218__RESET_B net812 VGND VGND VPWR VPWR sky130_fd_sc_hd__diode_2
XFILLER_0_108_429 VGND VGND VPWR VPWR sky130_fd_sc_hd__decap_4
XFILLER_0_93_669 VGND VGND VPWR VPWR sky130_fd_sc_hd__decap_3
XFILLER_0_46_541 VGND VGND VPWR VPWR sky130_fd_sc_hd__fill_2
XFILLER_0_46_530 VGND VGND VPWR VPWR sky130_fd_sc_hd__fill_2
X_4989_ u_pe_array.u_fifo2.buffer\[6\]\[1\] _1964_ _1981_ _1983_ VGND VGND VPWR VPWR
+ _1984_ sky130_fd_sc_hd__a211o_1
X_6728_ _3342_ VGND VGND VPWR VPWR _0629_ sky130_fd_sc_hd__clkbuf_1
XANTENNA__4603__S _0855_ VGND VGND VPWR VPWR sky130_fd_sc_hd__diode_2
XFILLER_0_46_563 VGND VGND VPWR VPWR sky130_fd_sc_hd__decap_8
XFILLER_0_18_276 VGND VGND VPWR VPWR sky130_fd_sc_hd__decap_3
XANTENNA__5926__C _2743_ VGND VGND VPWR VPWR sky130_fd_sc_hd__diode_2
X_6659_ _3106_ u_pe_array.u_fifo1.wr_ptr\[1\] VGND VGND VPWR VPWR _3301_ sky130_fd_sc_hd__nand2_2
XANTENNA__3727__B _0869_ VGND VGND VPWR VPWR sky130_fd_sc_hd__diode_2
XFILLER_0_103_101 VGND VGND VPWR VPWR sky130_fd_sc_hd__fill_2
XFILLER_0_61_577 VGND VGND VPWR VPWR sky130_fd_sc_hd__fill_2
XFILLER_0_5_181 VPWR VGND VPWR VGND sky130_ef_sc_hd__decap_12
XFILLER_0_104_657 VPWR VGND VPWR VGND sky130_ef_sc_hd__decap_12
XFILLER_0_103_167 VGND VGND VPWR VPWR sky130_fd_sc_hd__fill_1
XANTENNA__4172__A2 _1152_ VGND VGND VPWR VPWR sky130_fd_sc_hd__diode_2
XANTENNA__6621__A1 _1816_ VGND VGND VPWR VPWR sky130_fd_sc_hd__diode_2
XFILLER_0_96_452 VGND VGND VPWR VPWR sky130_fd_sc_hd__fill_2
XFILLER_0_96_441 VGND VGND VPWR VPWR sky130_fd_sc_hd__fill_2
XTAP_1331 VGND VPWR sky130_fd_sc_hd__tapvpwrvgnd_1
XTAP_1320 VGND VPWR sky130_fd_sc_hd__tapvpwrvgnd_1
XFILLER_0_29_508 VGND VGND VPWR VPWR sky130_fd_sc_hd__fill_2
XTAP_1375 VGND VPWR sky130_fd_sc_hd__tapvpwrvgnd_1
XTAP_1353 VGND VPWR sky130_fd_sc_hd__tapvpwrvgnd_1
XTAP_1364 VGND VPWR sky130_fd_sc_hd__tapvpwrvgnd_1
XTAP_1342 VGND VPWR sky130_fd_sc_hd__tapvpwrvgnd_1
XFILLER_0_83_113 VGND VGND VPWR VPWR sky130_fd_sc_hd__fill_2
XTAP_1397 VGND VPWR sky130_fd_sc_hd__tapvpwrvgnd_1
XTAP_1386 VGND VPWR sky130_fd_sc_hd__tapvpwrvgnd_1
XANTENNA__5188__B2 _1665_ VGND VGND VPWR VPWR sky130_fd_sc_hd__diode_2
XFILLER_0_37_541 VGND VGND VPWR VPWR sky130_fd_sc_hd__fill_1
XFILLER_0_37_585 VGND VGND VPWR VPWR sky130_fd_sc_hd__fill_2
Xinput15 v_in0[0] VGND VGND VPWR VPWR net15 sky130_fd_sc_hd__buf_1
XFILLER_0_107_473 VPWR VGND VPWR VGND sky130_ef_sc_hd__decap_12
XANTENNA__6013__B _2743_ VGND VGND VPWR VPWR sky130_fd_sc_hd__diode_2
Xinput26 v_in1[5] VGND VGND VPWR VPWR net26 sky130_fd_sc_hd__buf_1
XFILLER_0_24_279 VGND VGND VPWR VPWR sky130_fd_sc_hd__fill_2
XANTENNA__4699__B1 _1534_ VGND VGND VPWR VPWR sky130_fd_sc_hd__diode_2
XFILLER_0_20_463 VGND VGND VPWR VPWR sky130_fd_sc_hd__decap_4
XFILLER_0_20_474 VGND VGND VPWR VPWR sky130_fd_sc_hd__fill_2
X_4010_ _1164_ _1165_ _1169_ VGND VGND VPWR VPWR _1171_ sky130_fd_sc_hd__o21ai_1
XFILLER_0_74_68 VGND VGND VPWR VPWR sky130_fd_sc_hd__fill_2
XANTENNA__3674__A1 u_pe_array.g_pe_row\[3\].g_pe_col\[3\].u_pe.act_val\[3\] VGND VGND
+ VPWR VPWR sky130_fd_sc_hd__diode_2
XANTENNA__7382__RESET_B net812 VGND VGND VPWR VPWR sky130_fd_sc_hd__diode_2
XFILLER_0_59_121 VGND VGND VPWR VPWR sky130_fd_sc_hd__decap_3
X_5961_ _2797_ u_pe_array.g_pe_row\[0\].g_pe_col\[2\].u_pe.psum_out\[6\] _2743_ VGND
+ VGND VPWR VPWR _2798_ sky130_fd_sc_hd__nand3_1
X_4912_ _1911_ _1909_ _1915_ VGND VGND VPWR VPWR _1916_ sky130_fd_sc_hd__o21ai_1
XANTENNA__3977__A2 _1138_ VGND VGND VPWR VPWR sky130_fd_sc_hd__diode_2
XANTENNA__7311__RESET_B net814 VGND VGND VPWR VPWR sky130_fd_sc_hd__diode_2
XFILLER_0_114_41 VPWR VGND VPWR VGND sky130_ef_sc_hd__decap_12
X_7631_ clknet_leaf_19_clk _0680_ VGND VGND VPWR VPWR u_pe_array.u_fifo1.buffer\[5\]\[2\]
+ sky130_fd_sc_hd__dfxtp_1
X_5892_ u_pe_array.g_pe_row\[1\].g_pe_col\[1\].u_pe.psum_out\[11\] u_pe_array.g_pe_row\[1\].g_pe_col\[1\].u_pe.move_reg\[11\]
+ _2469_ VGND VGND VPWR VPWR _2737_ sky130_fd_sc_hd__mux2_1
XFILLER_0_114_85 VPWR VGND VPWR VGND sky130_ef_sc_hd__decap_12
X_4843_ _1725_ _1851_ _1852_ _1534_ net517 VGND VGND VPWR VPWR _0234_ sky130_fd_sc_hd__a32o_1
X_7562_ clknet_leaf_18_clk _0611_ net816 VGND VGND VPWR VPWR u_pe_array.u_fifo1.count\[2\]
+ sky130_fd_sc_hd__dfrtp_2
XFILLER_0_28_574 VGND VGND VPWR VPWR sky130_fd_sc_hd__fill_2
X_4774_ _1807_ VGND VGND VPWR VPWR _0210_ sky130_fd_sc_hd__clkbuf_1
XFILLER_0_99_54 VGND VGND VPWR VPWR sky130_fd_sc_hd__fill_2
XFILLER_0_99_43 VGND VGND VPWR VPWR sky130_fd_sc_hd__fill_2
X_6513_ _3221_ VGND VGND VPWR VPWR _0535_ sky130_fd_sc_hd__clkbuf_1
XFILLER_0_43_544 VGND VGND VPWR VPWR sky130_fd_sc_hd__decap_4
X_7493_ clknet_leaf_93_clk _0542_ VGND VGND VPWR VPWR u_pe_array.u_fifo2.buffer\[4\]\[6\]
+ sky130_fd_sc_hd__dfxtp_1
X_3725_ _0864_ _0936_ _0938_ _0867_ net391 VGND VGND VPWR VPWR _0030_ sky130_fd_sc_hd__a32o_1
XFILLER_0_99_87 VGND VGND VPWR VPWR sky130_fd_sc_hd__decap_3
X_6444_ net492 _1806_ net69 VGND VGND VPWR VPWR _3186_ sky130_fd_sc_hd__mux2_1
Xclkbuf_leaf_9_clk clknet_3_0__leaf_clk VGND VGND VPWR VPWR clknet_leaf_9_clk sky130_fd_sc_hd__clkbuf_16
XFILLER_0_43_599 VGND VGND VPWR VPWR sky130_fd_sc_hd__fill_2
XFILLER_0_3_641 VPWR VGND VPWR VGND sky130_ef_sc_hd__decap_12
X_3656_ _0864_ _0873_ _0874_ _0867_ net502 VGND VGND VPWR VPWR _0025_ sky130_fd_sc_hd__a32o_1
XFILLER_0_61_3 VPWR VGND VPWR VGND sky130_ef_sc_hd__decap_12
X_6375_ _3144_ VGND VGND VPWR VPWR _0474_ sky130_fd_sc_hd__clkbuf_1
X_3587_ net598 _0821_ _0823_ VGND VGND VPWR VPWR _0007_ sky130_fd_sc_hd__o21a_1
X_5326_ net550 _1714_ _2174_ _2268_ VGND VGND VPWR VPWR _0301_ sky130_fd_sc_hd__a22o_1
XFILLER_0_2_195 VGND VGND VPWR VPWR sky130_fd_sc_hd__fill_1
X_5257_ _2204_ _2205_ VGND VGND VPWR VPWR _2207_ sky130_fd_sc_hd__nand2_1
X_4208_ _1335_ _1336_ _1337_ VGND VGND VPWR VPWR _1338_ sky130_fd_sc_hd__or3_1
X_5188_ net284 _2144_ _2148_ _1665_ VGND VGND VPWR VPWR _0283_ sky130_fd_sc_hd__a22o_1
X_4139_ u_pe_array.g_pe_row\[3\].g_pe_col\[0\].u_pe.w_reg\[0\] u_pe_array.g_pe_row\[3\].g_pe_col\[0\].u_pe.act_val\[1\]
+ VGND VGND VPWR VPWR _1274_ sky130_fd_sc_hd__nand2_1
XFILLER_0_3_93 VPWR VGND VPWR VGND sky130_ef_sc_hd__decap_12
XANTENNA__3968__A2 _0996_ VGND VGND VPWR VPWR sky130_fd_sc_hd__diode_2
XFILLER_0_78_452 VGND VGND VPWR VPWR sky130_fd_sc_hd__fill_2
XANTENNA__7052__RESET_B net819 VGND VGND VPWR VPWR sky130_fd_sc_hd__diode_2
XFILLER_0_65_113 VGND VGND VPWR VPWR sky130_fd_sc_hd__decap_8
XFILLER_0_38_316 VGND VGND VPWR VPWR sky130_fd_sc_hd__fill_2
XFILLER_0_19_552 VGND VGND VPWR VPWR sky130_fd_sc_hd__fill_1
XFILLER_0_108_248 VGND VGND VPWR VPWR sky130_fd_sc_hd__fill_2
XFILLER_0_19_574 VGND VGND VPWR VPWR sky130_fd_sc_hd__decap_3
XFILLER_0_34_533 VPWR VGND VPWR VGND sky130_ef_sc_hd__decap_12
XFILLER_0_104_443 VGND VGND VPWR VPWR sky130_fd_sc_hd__fill_2
XFILLER_0_104_432 VGND VGND VPWR VPWR sky130_fd_sc_hd__fill_1
XFILLER_0_21_205 VGND VGND VPWR VPWR sky130_fd_sc_hd__fill_2
XANTENNA__5893__A2 _2600_ VGND VGND VPWR VPWR sky130_fd_sc_hd__diode_2
XANTENNA__6842__A1 _3120_ VGND VGND VPWR VPWR sky130_fd_sc_hd__diode_2
XANTENNA__4853__B1 _0885_ VGND VGND VPWR VPWR sky130_fd_sc_hd__diode_2
XANTENNA__3656__A1 _0864_ VGND VGND VPWR VPWR sky130_fd_sc_hd__diode_2
XANTENNA__3959__A2 _0996_ VGND VGND VPWR VPWR sky130_fd_sc_hd__diode_2
XTAP_1150 VGND VPWR sky130_fd_sc_hd__tapvpwrvgnd_1
XANTENNA__6358__B1 net51 VGND VGND VPWR VPWR sky130_fd_sc_hd__diode_2
XTAP_1183 VGND VPWR sky130_fd_sc_hd__tapvpwrvgnd_1
XTAP_1172 VGND VPWR sky130_fd_sc_hd__tapvpwrvgnd_1
XTAP_1161 VGND VPWR sky130_fd_sc_hd__tapvpwrvgnd_1
Xclkbuf_3_4__f_clk clknet_0_clk VGND VGND VPWR VPWR clknet_3_4__leaf_clk sky130_fd_sc_hd__clkbuf_16
XFILLER_0_29_349 VGND VGND VPWR VPWR sky130_fd_sc_hd__decap_3
XFILLER_0_84_477 VGND VGND VPWR VPWR sky130_fd_sc_hd__decap_3
XTAP_1194 VGND VPWR sky130_fd_sc_hd__tapvpwrvgnd_1
XFILLER_0_56_179 VGND VGND VPWR VPWR sky130_fd_sc_hd__decap_8
XFILLER_0_71_138 VGND VGND VPWR VPWR sky130_fd_sc_hd__fill_1
XFILLER_0_37_371 VGND VGND VPWR VPWR sky130_fd_sc_hd__decap_4
XFILLER_0_107_281 VGND VGND VPWR VPWR sky130_fd_sc_hd__decap_8
XFILLER_0_80_650 VGND VGND VPWR VPWR sky130_fd_sc_hd__fill_2
X_3510_ u_pe_array.g_pe_row\[1\].g_pe_col\[0\].u_pe.act_val\[5\] u_pe_array.g_pe_row\[1\].g_pe_col\[0\].u_pe.psum_out\[5\]
+ _0756_ VGND VGND VPWR VPWR _0767_ sky130_fd_sc_hd__mux2_1
XFILLER_0_52_363 VGND VGND VPWR VPWR sky130_fd_sc_hd__fill_1
XFILLER_0_25_555 VGND VGND VPWR VPWR sky130_fd_sc_hd__fill_2
Xhold607 u_pe_array.g_pe_row\[2\].g_pe_col\[0\].u_pe.psum_out\[5\] VGND VGND VPWR
+ VPWR net683 sky130_fd_sc_hd__dlygate4sd3_1
XFILLER_0_69_57 VGND VGND VPWR VPWR sky130_fd_sc_hd__decap_3
XFILLER_0_69_46 VGND VGND VPWR VPWR sky130_fd_sc_hd__decap_8
Xhold618 u_pe_array.g_pe_row\[2\].g_pe_col\[1\].u_pe.act_val\[3\] VGND VGND VPWR VPWR
+ net694 sky130_fd_sc_hd__dlygate4sd3_1
XFILLER_0_12_227 VGND VGND VPWR VPWR sky130_fd_sc_hd__fill_1
X_4490_ _1553_ _1563_ _1562_ VGND VGND VPWR VPWR _1566_ sky130_fd_sc_hd__a21oi_1
Xhold629 u_pe_array.u_fifo1.rd_ptr\[1\] VGND VGND VPWR VPWR net705 sky130_fd_sc_hd__dlygate4sd3_1
X_3441_ u_fsm.state\[2\] VGND VGND VPWR VPWR _0717_ sky130_fd_sc_hd__buf_4
XFILLER_0_110_457 VGND VGND VPWR VPWR sky130_fd_sc_hd__decap_4
XFILLER_0_110_446 VGND VGND VPWR VPWR sky130_fd_sc_hd__decap_3
X_6160_ _2960_ VGND VGND VPWR VPWR _2965_ sky130_fd_sc_hd__inv_2
XTAP_901 VGND VPWR sky130_fd_sc_hd__tapvpwrvgnd_1
XTAP_934 VGND VPWR sky130_fd_sc_hd__tapvpwrvgnd_1
XTAP_923 VGND VPWR sky130_fd_sc_hd__tapvpwrvgnd_1
XTAP_912 VGND VPWR sky130_fd_sc_hd__tapvpwrvgnd_1
X_5111_ u_pe_array.g_pe_row\[1\].g_pe_col\[3\].u_pe.psum_out\[5\] _2073_ VGND VGND
+ VPWR VPWR _2088_ sky130_fd_sc_hd__nand2_1
X_6091_ net745 _2387_ _2174_ _2902_ VGND VGND VPWR VPWR _0432_ sky130_fd_sc_hd__a22o_1
XANTENNA__7563__RESET_B net816 VGND VGND VPWR VPWR sky130_fd_sc_hd__diode_2
XTAP_978 VGND VPWR sky130_fd_sc_hd__tapvpwrvgnd_1
XTAP_956 VGND VPWR sky130_fd_sc_hd__tapvpwrvgnd_1
XTAP_967 VGND VPWR sky130_fd_sc_hd__tapvpwrvgnd_1
XTAP_945 VGND VPWR sky130_fd_sc_hd__tapvpwrvgnd_1
XTAP_989 VGND VPWR sky130_fd_sc_hd__tapvpwrvgnd_1
X_5042_ u_pe_array.g_pe_row\[0\].g_pe_col\[2\].u_pe.psum_out\[12\] u_pe_array.g_pe_row\[0\].g_pe_col\[2\].u_pe.move_reg\[12\]
+ _1661_ VGND VGND VPWR VPWR _2026_ sky130_fd_sc_hd__mux2_1
X_6993_ clknet_leaf_34_clk _0072_ net817 VGND VGND VPWR VPWR u_pe_array.g_pe_row\[3\].g_pe_col\[0\].u_pe.act_val\[5\]
+ sky130_fd_sc_hd__dfrtp_1
XFILLER_0_94_219 VGND VGND VPWR VPWR sky130_fd_sc_hd__decap_3
XFILLER_0_75_422 VGND VGND VPWR VPWR sky130_fd_sc_hd__fill_2
XFILLER_0_75_411 VGND VGND VPWR VPWR sky130_fd_sc_hd__fill_2
XANTENNA__4072__B2 _0916_ VGND VGND VPWR VPWR sky130_fd_sc_hd__diode_2
XANTENNA__6633__S _0747_ VGND VGND VPWR VPWR sky130_fd_sc_hd__diode_2
X_5944_ _2781_ _2782_ VGND VGND VPWR VPWR _2783_ sky130_fd_sc_hd__nand2_1
XANTENNA__6349__B1 net60 VGND VGND VPWR VPWR sky130_fd_sc_hd__diode_2
X_5875_ u_pe_array.g_pe_row\[0\].g_pe_col\[1\].u_pe.act_val\[2\] _2600_ _2592_ _2728_
+ VGND VGND VPWR VPWR _0390_ sky130_fd_sc_hd__a22o_1
X_7614_ clknet_leaf_24_clk _0663_ VGND VGND VPWR VPWR u_pe_array.u_fifo1.buffer\[3\]\[11\]
+ sky130_fd_sc_hd__dfxtp_1
X_4826_ net604 _0833_ VGND VGND VPWR VPWR _1840_ sky130_fd_sc_hd__and2_1
XFILLER_0_75_499 VGND VGND VPWR VPWR sky130_fd_sc_hd__fill_2
XFILLER_0_16_533 VGND VGND VPWR VPWR sky130_fd_sc_hd__decap_8
X_7545_ clknet_leaf_78_clk _0594_ net815 VGND VGND VPWR VPWR u_pe_array.g_pe_row\[3\].g_pe_col\[3\].u_pe.move_reg\[6\]
+ sky130_fd_sc_hd__dfrtp_1
XFILLER_0_71_661 VGND VGND VPWR VPWR sky130_fd_sc_hd__fill_2
X_4757_ _1795_ VGND VGND VPWR VPWR _1796_ sky130_fd_sc_hd__buf_4
XFILLER_0_43_341 VGND VGND VPWR VPWR sky130_fd_sc_hd__decap_4
XFILLER_0_7_276 VGND VGND VPWR VPWR sky130_fd_sc_hd__decap_4
XANTENNA__5572__B2 _2336_ VGND VGND VPWR VPWR sky130_fd_sc_hd__diode_2
XFILLER_0_31_503 VGND VGND VPWR VPWR sky130_fd_sc_hd__fill_1
X_4688_ _1732_ _1733_ VGND VGND VPWR VPWR _1734_ sky130_fd_sc_hd__nor2_1
X_3708_ _0920_ _0921_ VGND VGND VPWR VPWR _0923_ sky130_fd_sc_hd__nand2_1
X_7476_ clknet_leaf_3_clk _0525_ VGND VGND VPWR VPWR u_pe_array.u_fifo2.buffer\[3\]\[2\]
+ sky130_fd_sc_hd__dfxtp_1
XFILLER_0_113_273 VGND VGND VPWR VPWR sky130_fd_sc_hd__decap_6
X_3639_ u_pe_array.g_pe_row\[3\].g_pe_col\[3\].u_pe.psum_out\[0\] u_pe_array.g_pe_row\[3\].g_pe_col\[3\].u_pe.act_val\[0\]
+ u_pe_array.g_pe_row\[3\].g_pe_col\[3\].u_pe.w_reg\[0\] VGND VGND VPWR VPWR _0859_
+ sky130_fd_sc_hd__and3_1
X_6427_ net249 _1816_ net70 VGND VGND VPWR VPWR _3177_ sky130_fd_sc_hd__mux2_1
XANTENNA__4127__A2 _1138_ VGND VGND VPWR VPWR sky130_fd_sc_hd__diode_2
XFILLER_0_101_457 VGND VGND VPWR VPWR sky130_fd_sc_hd__fill_2
XANTENNA__5875__A2 _2600_ VGND VGND VPWR VPWR sky130_fd_sc_hd__diode_2
X_6358_ _1787_ _1140_ net51 VGND VGND VPWR VPWR _3132_ sky130_fd_sc_hd__a21o_4
XFILLER_0_3_482 VPWR VGND VPWR VGND sky130_ef_sc_hd__decap_12
X_5309_ u_pe_array.g_pe_row\[1\].g_pe_col\[2\].u_pe.psum_out\[10\] _2243_ VGND VGND
+ VPWR VPWR _2254_ sky130_fd_sc_hd__nor2_1
XFILLER_0_11_293 VGND VGND VPWR VPWR sky130_fd_sc_hd__fill_2
XANTENNA__6824__A1 _3130_ VGND VGND VPWR VPWR sky130_fd_sc_hd__diode_2
X_6289_ _3077_ _3078_ net709 _0875_ VGND VGND VPWR VPWR _0454_ sky130_fd_sc_hd__a2bb2o_1
XANTENNA__6808__S _3382_ VGND VGND VPWR VPWR sky130_fd_sc_hd__diode_2
XANTENNA__4835__B1 _1534_ VGND VGND VPWR VPWR sky130_fd_sc_hd__diode_2
XANTENNA__7233__RESET_B net75 VGND VGND VPWR VPWR sky130_fd_sc_hd__diode_2
XANTENNA__3740__B _0869_ VGND VGND VPWR VPWR sky130_fd_sc_hd__diode_2
XPHY_200 VGND VGND VPWR VPWR sky130_fd_sc_hd__decap_3
XANTENNA__5260__B1 _0885_ VGND VGND VPWR VPWR sky130_fd_sc_hd__diode_2
XFILLER_0_14_19 VGND VGND VPWR VPWR sky130_fd_sc_hd__fill_2
XFILLER_0_38_102 VGND VGND VPWR VPWR sky130_fd_sc_hd__decap_3
XFILLER_0_39_625 VGND VGND VPWR VPWR sky130_fd_sc_hd__fill_2
XPHY_222 VGND VGND VPWR VPWR sky130_fd_sc_hd__decap_3
XPHY_211 VGND VGND VPWR VPWR sky130_fd_sc_hd__decap_3
XANTENNA__5667__B _2478_ VGND VGND VPWR VPWR sky130_fd_sc_hd__diode_2
XFILLER_0_66_444 VGND VGND VPWR VPWR sky130_fd_sc_hd__fill_1
XANTENNA__3468__A _0728_ VGND VGND VPWR VPWR sky130_fd_sc_hd__diode_2
XFILLER_0_66_466 VGND VGND VPWR VPWR sky130_fd_sc_hd__decap_8
XANTENNA__3810__B2 _1004_ VGND VGND VPWR VPWR sky130_fd_sc_hd__diode_2
XFILLER_0_19_360 VGND VGND VPWR VPWR sky130_fd_sc_hd__fill_2
XFILLER_0_19_393 VGND VGND VPWR VPWR sky130_fd_sc_hd__decap_3
XFILLER_0_81_458 VGND VGND VPWR VPWR sky130_fd_sc_hd__fill_2
XANTENNA__5563__B2 _2336_ VGND VGND VPWR VPWR sky130_fd_sc_hd__diode_2
XFILLER_0_34_396 VGND VGND VPWR VPWR sky130_fd_sc_hd__fill_2
XFILLER_0_100_490 VGND VGND VPWR VPWR sky130_fd_sc_hd__fill_1
XFILLER_0_55_15 VPWR VGND VPWR VGND sky130_ef_sc_hd__decap_12
Xhold4 u_pe_array.g_pe_row\[3\].g_pe_col\[2\].u_pe.w_buffer\[1\] VGND VGND VPWR VPWR
+ net80 sky130_fd_sc_hd__dlygate4sd3_1
XFILLER_0_89_514 VGND VGND VPWR VPWR sky130_fd_sc_hd__fill_2
XANTENNA__6043__A2 _2738_ VGND VGND VPWR VPWR sky130_fd_sc_hd__diode_2
X_3990_ _0866_ VGND VGND VPWR VPWR _1152_ sky130_fd_sc_hd__buf_8
XFILLER_0_57_411 VGND VGND VPWR VPWR sky130_fd_sc_hd__fill_2
XANTENNA__6956__RESET_B net819 VGND VGND VPWR VPWR sky130_fd_sc_hd__diode_2
X_5660_ _2258_ _2550_ _2551_ _2071_ net686 VGND VGND VPWR VPWR _0352_ sky130_fd_sc_hd__a32o_1
XANTENNA__3801__B2 u_fsm.psum_shift_en VGND VGND VPWR VPWR sky130_fd_sc_hd__diode_2
XFILLER_0_45_617 VGND VGND VPWR VPWR sky130_fd_sc_hd__fill_2
XFILLER_0_72_447 VGND VGND VPWR VPWR sky130_fd_sc_hd__decap_8
X_4611_ _0721_ VGND VGND VPWR VPWR _1665_ sky130_fd_sc_hd__buf_6
X_5591_ _2485_ _2487_ VGND VGND VPWR VPWR _2488_ sky130_fd_sc_hd__xnor2_1
XFILLER_0_72_458 VGND VGND VPWR VPWR sky130_fd_sc_hd__decap_6
XANTENNA__4357__A2 _1152_ VGND VGND VPWR VPWR sky130_fd_sc_hd__diode_2
XFILLER_0_52_160 VGND VGND VPWR VPWR sky130_fd_sc_hd__decap_8
XFILLER_0_4_257 VGND VGND VPWR VPWR sky130_fd_sc_hd__fill_1
XFILLER_0_4_246 VGND VGND VPWR VPWR sky130_fd_sc_hd__decap_6
XFILLER_0_4_235 VGND VGND VPWR VPWR sky130_fd_sc_hd__decap_3
XFILLER_0_13_503 VGND VGND VPWR VPWR sky130_fd_sc_hd__fill_1
XFILLER_0_13_525 VGND VGND VPWR VPWR sky130_fd_sc_hd__fill_1
XFILLER_0_25_374 VGND VGND VPWR VPWR sky130_fd_sc_hd__fill_2
X_4542_ _1536_ u_pe_array.g_pe_row\[2\].g_pe_col\[2\].u_pe.psum_out\[7\] _1612_ _1613_
+ VGND VGND VPWR VPWR _1614_ sky130_fd_sc_hd__a22oi_1
X_7330_ clknet_leaf_81_clk _0387_ net13 VGND VGND VPWR VPWR u_pe_array.g_pe_row\[0\].g_pe_col\[2\].u_pe.w_buffer\[1\]
+ sky130_fd_sc_hd__dfrtp_1
X_7261_ clknet_leaf_49_clk _0322_ net812 VGND VGND VPWR VPWR u_pe_array.g_pe_row\[1\].g_pe_col\[1\].u_pe.psum_out\[5\]
+ sky130_fd_sc_hd__dfrtp_1
X_4473_ _1543_ _1549_ _0885_ VGND VGND VPWR VPWR _1551_ sky130_fd_sc_hd__o21a_1
XFILLER_0_13_558 VGND VGND VPWR VPWR sky130_fd_sc_hd__fill_2
Xhold426 u_pe_array.g_pe_row\[3\].g_pe_col\[3\].u_pe.psum_out\[1\] VGND VGND VPWR
+ VPWR net502 sky130_fd_sc_hd__dlygate4sd3_1
Xhold404 u_pe_array.u_fifo2.buffer\[5\]\[1\] VGND VGND VPWR VPWR net480 sky130_fd_sc_hd__dlygate4sd3_1
Xhold415 u_pe_array.u_fifo2.buffer\[7\]\[2\] VGND VGND VPWR VPWR net491 sky130_fd_sc_hd__dlygate4sd3_1
X_6212_ net665 _0867_ _2174_ _3007_ VGND VGND VPWR VPWR _0448_ sky130_fd_sc_hd__a22o_1
XFILLER_0_96_33 VGND VGND VPWR VPWR sky130_fd_sc_hd__fill_1
Xhold459 u_pe_array.u_fifo1.buffer\[1\]\[1\] VGND VGND VPWR VPWR net535 sky130_fd_sc_hd__dlygate4sd3_1
Xhold448 u_pe_array.u_fifo1.buffer\[3\]\[4\] VGND VGND VPWR VPWR net524 sky130_fd_sc_hd__dlygate4sd3_1
Xhold437 u_pe_array.u_fifo2.buffer\[6\]\[0\] VGND VGND VPWR VPWR net513 sky130_fd_sc_hd__dlygate4sd3_1
X_7192_ clknet_leaf_52_clk net167 net812 VGND VGND VPWR VPWR u_pe_array.g_pe_row\[1\].g_pe_col\[2\].u_pe.move_reg\[11\]
+ sky130_fd_sc_hd__dfrtp_1
X_6143_ _2873_ u_pe_array.g_pe_row\[0\].g_pe_col\[1\].u_pe.psum_out\[8\] VGND VGND
+ VPWR VPWR _2950_ sky130_fd_sc_hd__or2_1
XTAP_731 VGND VPWR sky130_fd_sc_hd__tapvpwrvgnd_1
XTAP_720 VGND VPWR sky130_fd_sc_hd__tapvpwrvgnd_1
XTAP_742 VGND VPWR sky130_fd_sc_hd__tapvpwrvgnd_1
X_6074_ _2880_ _2886_ VGND VGND VPWR VPWR _2887_ sky130_fd_sc_hd__nand2_1
XTAP_786 VGND VPWR sky130_fd_sc_hd__tapvpwrvgnd_1
XTAP_775 VGND VPWR sky130_fd_sc_hd__tapvpwrvgnd_1
XTAP_764 VGND VPWR sky130_fd_sc_hd__tapvpwrvgnd_1
XTAP_753 VGND VPWR sky130_fd_sc_hd__tapvpwrvgnd_1
XTAP_797 VGND VPWR sky130_fd_sc_hd__tapvpwrvgnd_1
XANTENNA__4817__B1 _1655_ VGND VGND VPWR VPWR sky130_fd_sc_hd__diode_2
X_5025_ u_pe_array.u_fifo2.buffer\[6\]\[5\] _1964_ _2013_ _2015_ VGND VGND VPWR VPWR
+ _2016_ sky130_fd_sc_hd__a211o_1
XFILLER_0_24_3 VGND VGND VPWR VPWR sky130_fd_sc_hd__decap_6
XFILLER_0_45_81 VGND VGND VPWR VPWR sky130_fd_sc_hd__fill_2
XFILLER_0_67_219 VGND VGND VPWR VPWR sky130_fd_sc_hd__fill_2
XFILLER_0_48_400 VGND VGND VPWR VPWR sky130_fd_sc_hd__fill_1
X_6976_ clknet_leaf_9_clk _0055_ net819 VGND VGND VPWR VPWR u_pe_array.g_pe_row\[3\].g_pe_col\[2\].u_pe.psum_out\[3\]
+ sky130_fd_sc_hd__dfrtp_1
XANTENNA__4596__A2 _1524_ VGND VGND VPWR VPWR sky130_fd_sc_hd__diode_2
X_5927_ _2765_ _2766_ VGND VGND VPWR VPWR _2767_ sky130_fd_sc_hd__nor2_1
XFILLER_0_0_50 VGND VGND VPWR VPWR sky130_fd_sc_hd__decap_6
XFILLER_0_90_222 VGND VGND VPWR VPWR sky130_fd_sc_hd__fill_2
XFILLER_0_63_447 VGND VGND VPWR VPWR sky130_fd_sc_hd__fill_1
XFILLER_0_36_639 VGND VGND VPWR VPWR sky130_fd_sc_hd__fill_2
X_5858_ _2709_ _2712_ _2717_ VGND VGND VPWR VPWR _2718_ sky130_fd_sc_hd__o21ai_1
XFILLER_0_106_538 VGND VGND VPWR VPWR sky130_fd_sc_hd__fill_1
XFILLER_0_90_266 VGND VGND VPWR VPWR sky130_fd_sc_hd__decap_3
XFILLER_0_63_469 VGND VGND VPWR VPWR sky130_fd_sc_hd__fill_2
X_4809_ u_pe_array.g_pe_row\[1\].g_pe_col\[2\].u_pe.act_val\[3\] u_pe_array.g_pe_row\[1\].g_pe_col\[2\].u_pe.psum_out\[3\]
+ _0756_ VGND VGND VPWR VPWR _1830_ sky130_fd_sc_hd__mux2_2
XFILLER_0_44_661 VGND VGND VPWR VPWR sky130_fd_sc_hd__fill_2
X_5789_ _2653_ _2654_ VGND VGND VPWR VPWR _2655_ sky130_fd_sc_hd__xnor2_1
XFILLER_0_35_149 VGND VGND VPWR VPWR sky130_fd_sc_hd__fill_2
XFILLER_0_16_374 VGND VGND VPWR VPWR sky130_fd_sc_hd__fill_2
X_7528_ clknet_leaf_3_clk _0577_ VGND VGND VPWR VPWR u_pe_array.u_fifo2.buffer\[7\]\[2\]
+ sky130_fd_sc_hd__dfxtp_1
X_7459_ clknet_leaf_0_clk _0508_ VGND VGND VPWR VPWR u_pe_array.u_fifo2.buffer\[1\]\[11\]
+ sky130_fd_sc_hd__dfxtp_1
XFILLER_0_101_243 VGND VGND VPWR VPWR sky130_fd_sc_hd__fill_2
XFILLER_0_101_287 VGND VGND VPWR VPWR sky130_fd_sc_hd__decap_3
XANTENNA__5950__B _2743_ VGND VGND VPWR VPWR sky130_fd_sc_hd__diode_2
XANTENNA__4808__B1 _1655_ VGND VGND VPWR VPWR sky130_fd_sc_hd__diode_2
XFILLER_0_98_333 VGND VGND VPWR VPWR sky130_fd_sc_hd__fill_1
XANTENNA__4587__A2 _1524_ VGND VGND VPWR VPWR sky130_fd_sc_hd__diode_2
XANTENNA__3795__B1 _0837_ VGND VGND VPWR VPWR sky130_fd_sc_hd__diode_2
XFILLER_0_54_425 VGND VGND VPWR VPWR sky130_fd_sc_hd__decap_3
XFILLER_0_26_105 VGND VGND VPWR VPWR sky130_fd_sc_hd__fill_2
XFILLER_0_39_488 VGND VGND VPWR VPWR sky130_fd_sc_hd__fill_2
XFILLER_0_109_387 VGND VGND VPWR VPWR sky130_fd_sc_hd__fill_2
XFILLER_0_81_233 VGND VGND VPWR VPWR sky130_fd_sc_hd__fill_1
XFILLER_0_81_277 VGND VGND VPWR VPWR sky130_fd_sc_hd__decap_3
XFILLER_0_50_620 VGND VGND VPWR VPWR sky130_fd_sc_hd__fill_2
XFILLER_0_50_653 VGND VGND VPWR VPWR sky130_fd_sc_hd__decap_3
XFILLER_0_1_205 VPWR VGND VPWR VGND sky130_ef_sc_hd__decap_12
XFILLER_0_1_249 VPWR VGND VPWR VGND sky130_ef_sc_hd__decap_12
XFILLER_0_22_377 VGND VGND VPWR VPWR sky130_fd_sc_hd__fill_2
XFILLER_0_5_39 VPWR VGND VPWR VGND sky130_ef_sc_hd__decap_12
XANTENNA__7155__RESET_B net814 VGND VGND VPWR VPWR sky130_fd_sc_hd__diode_2
XANTENNA__3661__A u_pe_array.g_pe_row\[3\].g_pe_col\[3\].u_pe.act_val\[2\] VGND VGND
+ VPWR VPWR sky130_fd_sc_hd__diode_2
XANTENNA__6264__A2 _0867_ VGND VGND VPWR VPWR sky130_fd_sc_hd__diode_2
XFILLER_0_89_322 VGND VGND VPWR VPWR sky130_fd_sc_hd__fill_1
XFILLER_0_82_13 VGND VGND VPWR VPWR sky130_fd_sc_hd__decap_8
XANTENNA__3483__C1 _0747_ VGND VGND VPWR VPWR sky130_fd_sc_hd__diode_2
XFILLER_0_106_53 VGND VGND VPWR VPWR sky130_fd_sc_hd__decap_3
XFILLER_0_77_539 VGND VGND VPWR VPWR sky130_fd_sc_hd__fill_2
X_6830_ _3106_ _3300_ _3380_ VGND VGND VPWR VPWR _3396_ sky130_fd_sc_hd__and3_1
X_6761_ _3359_ VGND VGND VPWR VPWR _0645_ sky130_fd_sc_hd__clkbuf_1
XFILLER_0_15_84 VGND VGND VPWR VPWR sky130_fd_sc_hd__fill_2
XFILLER_0_85_561 VGND VGND VPWR VPWR sky130_fd_sc_hd__fill_2
X_3973_ net120 _1138_ _1139_ _1004_ VGND VGND VPWR VPWR _0077_ sky130_fd_sc_hd__a22o_1
XANTENNA__3786__B1 _0837_ VGND VGND VPWR VPWR sky130_fd_sc_hd__diode_2
X_5712_ net795 _2463_ _2592_ _2594_ VGND VGND VPWR VPWR _0361_ sky130_fd_sc_hd__a22o_1
X_6692_ _3322_ VGND VGND VPWR VPWR _3323_ sky130_fd_sc_hd__buf_2
XFILLER_0_57_285 VGND VGND VPWR VPWR sky130_fd_sc_hd__fill_1
XFILLER_0_17_127 VGND VGND VPWR VPWR sky130_fd_sc_hd__fill_2
XFILLER_0_72_233 VGND VGND VPWR VPWR sky130_fd_sc_hd__fill_2
X_5643_ u_pe_array.g_pe_row\[1\].g_pe_col\[0\].u_pe.act_val\[4\] _2535_ _2524_ _2522_
+ VGND VGND VPWR VPWR _2536_ sky130_fd_sc_hd__o22ai_1
XFILLER_0_45_447 VGND VGND VPWR VPWR sky130_fd_sc_hd__fill_1
XFILLER_0_60_406 VPWR VGND VPWR VGND sky130_ef_sc_hd__decap_12
X_5574_ net293 _2463_ _2474_ _2336_ VGND VGND VPWR VPWR _0343_ sky130_fd_sc_hd__a22o_1
X_7313_ clknet_leaf_64_clk _0372_ net73 VGND VGND VPWR VPWR u_pe_array.g_pe_row\[0\].g_pe_col\[2\].u_pe.move_reg\[12\]
+ sky130_fd_sc_hd__dfrtp_1
XFILLER_0_53_480 VGND VGND VPWR VPWR sky130_fd_sc_hd__fill_2
XFILLER_0_13_344 VGND VGND VPWR VPWR sky130_fd_sc_hd__fill_1
X_4525_ _1596_ _1597_ _1598_ VGND VGND VPWR VPWR _1599_ sky130_fd_sc_hd__or3_1
Xhold201 u_pe_array.g_pe_row\[0\].g_pe_col\[3\].u_pe.move_reg\[8\] VGND VGND VPWR
+ VPWR net277 sky130_fd_sc_hd__dlygate4sd3_1
Xhold234 u_pe_array.u_fifo2.buffer\[7\]\[9\] VGND VGND VPWR VPWR net310 sky130_fd_sc_hd__dlygate4sd3_1
Xhold223 u_pe_array.u_fifo2.buffer\[4\]\[10\] VGND VGND VPWR VPWR net299 sky130_fd_sc_hd__dlygate4sd3_1
Xhold212 u_pe_array.u_fifo2.buffer\[1\]\[8\] VGND VGND VPWR VPWR net288 sky130_fd_sc_hd__dlygate4sd3_1
XFILLER_0_40_141 VGND VGND VPWR VPWR sky130_fd_sc_hd__decap_4
XFILLER_0_111_541 VPWR VGND VPWR VGND sky130_ef_sc_hd__decap_12
X_7244_ clknet_leaf_39_clk _0307_ net813 VGND VGND VPWR VPWR u_pe_array.g_pe_row\[1\].g_pe_col\[0\].u_pe.act_val\[3\]
+ sky130_fd_sc_hd__dfrtp_2
Xhold245 u_fsm.h_cnt\[1\] VGND VGND VPWR VPWR net321 sky130_fd_sc_hd__dlygate4sd3_1
X_4456_ u_pe_array.g_pe_row\[2\].g_pe_col\[2\].u_pe.w_reg\[0\] u_pe_array.g_pe_row\[2\].g_pe_col\[2\].u_pe.act_val\[1\]
+ VGND VGND VPWR VPWR _1535_ sky130_fd_sc_hd__nand2_1
Xhold256 u_pe_array.u_fifo2.buffer\[0\]\[11\] VGND VGND VPWR VPWR net332 sky130_fd_sc_hd__dlygate4sd3_1
Xhold278 u_pe_array.u_fifo2.buffer\[2\]\[8\] VGND VGND VPWR VPWR net354 sky130_fd_sc_hd__dlygate4sd3_1
Xhold267 u_pe_array.u_fifo2.buffer\[2\]\[10\] VGND VGND VPWR VPWR net343 sky130_fd_sc_hd__dlygate4sd3_1
XFILLER_0_111_585 VPWR VGND VPWR VGND sky130_ef_sc_hd__decap_12
XANTENNA__4667__A _0866_ VGND VGND VPWR VPWR sky130_fd_sc_hd__diode_2
X_7175_ clknet_leaf_41_clk _0242_ net813 VGND VGND VPWR VPWR u_pe_array.g_pe_row\[2\].g_pe_col\[0\].u_pe.psum_out\[9\]
+ sky130_fd_sc_hd__dfrtp_2
Xhold289 u_pe_array.g_pe_row\[0\].g_pe_col\[1\].u_pe.move_reg\[9\] VGND VGND VPWR
+ VPWR net365 sky130_fd_sc_hd__dlygate4sd3_1
XFILLER_0_0_271 VGND VGND VPWR VPWR sky130_fd_sc_hd__fill_2
X_4387_ _1477_ _1481_ _1486_ VGND VGND VPWR VPWR _1487_ sky130_fd_sc_hd__a21oi_2
X_6126_ _2913_ _2922_ VGND VGND VPWR VPWR _2935_ sky130_fd_sc_hd__and2_1
XFILLER_0_0_293 VPWR VGND VPWR VGND sky130_ef_sc_hd__decap_12
XTAP_550 VGND VPWR sky130_fd_sc_hd__tapvpwrvgnd_1
XTAP_561 VGND VPWR sky130_fd_sc_hd__tapvpwrvgnd_1
XTAP_572 VGND VPWR sky130_fd_sc_hd__tapvpwrvgnd_1
XTAP_583 VGND VPWR sky130_fd_sc_hd__tapvpwrvgnd_1
XTAP_594 VGND VPWR sky130_fd_sc_hd__tapvpwrvgnd_1
X_6057_ _2740_ _2869_ _2871_ _2571_ net374 VGND VGND VPWR VPWR _0429_ sky130_fd_sc_hd__a32o_1
XANTENNA__5463__B1 net71 VGND VGND VPWR VPWR sky130_fd_sc_hd__diode_2
X_5008_ u_pe_array.u_fifo2.buffer\[8\]\[3\] _1960_ _1996_ _2000_ _0819_ VGND VGND
+ VPWR VPWR _2001_ sky130_fd_sc_hd__a221o_2
XFILLER_0_68_528 VGND VGND VPWR VPWR sky130_fd_sc_hd__fill_2
XANTENNA__4606__S _1661_ VGND VGND VPWR VPWR sky130_fd_sc_hd__diode_2
XANTENNA_clkbuf_leaf_72_clk_A clknet_3_5__leaf_clk VGND VGND VPWR VPWR sky130_fd_sc_hd__diode_2
XFILLER_0_95_358 VGND VGND VPWR VPWR sky130_fd_sc_hd__decap_4
XANTENNA__3510__S _0756_ VGND VGND VPWR VPWR sky130_fd_sc_hd__diode_2
XFILLER_0_76_550 VGND VGND VPWR VPWR sky130_fd_sc_hd__decap_3
X_6959_ clknet_leaf_17_clk _0040_ net816 VGND VGND VPWR VPWR u_pe_array.g_pe_row\[3\].g_pe_col\[1\].u_pe.act_val\[1\]
+ sky130_fd_sc_hd__dfrtp_2
XANTENNA__3777__A0 u_pe_array.g_pe_row\[2\].g_pe_col\[2\].u_pe.w_buffer\[0\] VGND
+ VGND VPWR VPWR sky130_fd_sc_hd__diode_2
XFILLER_0_76_583 VGND VGND VPWR VPWR sky130_fd_sc_hd__fill_1
XFILLER_0_63_211 VGND VGND VPWR VPWR sky130_fd_sc_hd__decap_8
XANTENNA_clkbuf_leaf_87_clk_A clknet_3_1__leaf_clk VGND VGND VPWR VPWR sky130_fd_sc_hd__diode_2
XANTENNA__5518__A1 _2258_ VGND VGND VPWR VPWR sky130_fd_sc_hd__diode_2
XFILLER_0_8_371 VGND VGND VPWR VPWR sky130_fd_sc_hd__fill_1
XFILLER_0_36_469 VGND VGND VPWR VPWR sky130_fd_sc_hd__fill_2
XFILLER_0_106_357 VGND VGND VPWR VPWR sky130_fd_sc_hd__fill_2
XFILLER_0_63_288 VGND VGND VPWR VPWR sky130_fd_sc_hd__fill_2
XFILLER_0_51_439 VGND VGND VPWR VPWR sky130_fd_sc_hd__fill_2
XANTENNA_clkbuf_leaf_10_clk_A clknet_3_1__leaf_clk VGND VGND VPWR VPWR sky130_fd_sc_hd__diode_2
XFILLER_0_32_620 VGND VGND VPWR VPWR sky130_fd_sc_hd__fill_2
XFILLER_0_32_642 VGND VGND VPWR VPWR sky130_fd_sc_hd__fill_2
XFILLER_0_31_141 VGND VGND VPWR VPWR sky130_fd_sc_hd__fill_1
XFILLER_0_32_675 VGND VGND VPWR VPWR sky130_fd_sc_hd__fill_2
XANTENNA_clkbuf_leaf_25_clk_A clknet_3_2__leaf_clk VGND VGND VPWR VPWR sky130_fd_sc_hd__diode_2
XANTENNA__5172__S _0754_ VGND VGND VPWR VPWR sky130_fd_sc_hd__diode_2
XFILLER_0_86_358 VGND VGND VPWR VPWR sky130_fd_sc_hd__decap_6
XFILLER_0_27_425 VGND VGND VPWR VPWR sky130_fd_sc_hd__fill_2
XFILLER_0_39_285 VGND VGND VPWR VPWR sky130_fd_sc_hd__fill_1
XFILLER_0_54_222 VGND VGND VPWR VPWR sky130_fd_sc_hd__fill_2
XFILLER_0_82_597 VGND VGND VPWR VPWR sky130_fd_sc_hd__fill_2
XANTENNA__7336__RESET_B net812 VGND VGND VPWR VPWR sky130_fd_sc_hd__diode_2
XFILLER_0_35_480 VGND VGND VPWR VPWR sky130_fd_sc_hd__fill_2
XFILLER_0_50_461 VGND VGND VPWR VPWR sky130_fd_sc_hd__fill_2
XFILLER_0_2_525 VGND VGND VPWR VPWR sky130_fd_sc_hd__decap_6
XFILLER_0_22_141 VGND VGND VPWR VPWR sky130_fd_sc_hd__decap_3
XFILLER_0_105_390 VGND VGND VPWR VPWR sky130_fd_sc_hd__fill_2
X_5290_ _2235_ _2236_ VGND VGND VPWR VPWR _2237_ sky130_fd_sc_hd__nand2_1
XANTENNA__3940__B1 _0887_ VGND VGND VPWR VPWR sky130_fd_sc_hd__diode_2
X_4310_ u_pe_array.g_pe_row\[2\].g_pe_col\[3\].u_pe.psum_out\[2\] _1415_ VGND VGND
+ VPWR VPWR _1416_ sky130_fd_sc_hd__xnor2_2
XFILLER_0_2_569 VPWR VGND VPWR VGND sky130_ef_sc_hd__decap_12
X_4241_ _1362_ VGND VGND VPWR VPWR _1367_ sky130_fd_sc_hd__inv_2
X_4172_ net657 _1152_ _0887_ _1304_ VGND VGND VPWR VPWR _0111_ sky130_fd_sc_hd__a22o_1
XANTENNA__6906__S _3427_ VGND VGND VPWR VPWR sky130_fd_sc_hd__diode_2
XANTENNA__6971__RESET_B net819 VGND VGND VPWR VPWR sky130_fd_sc_hd__diode_2
XANTENNA__4426__S _0770_ VGND VGND VPWR VPWR sky130_fd_sc_hd__diode_2
XFILLER_0_92_306 VGND VGND VPWR VPWR sky130_fd_sc_hd__fill_2
X_6813_ _3387_ VGND VGND VPWR VPWR _0669_ sky130_fd_sc_hd__clkbuf_1
XFILLER_0_9_113 VGND VGND VPWR VPWR sky130_fd_sc_hd__fill_2
X_6744_ _3350_ VGND VGND VPWR VPWR _0637_ sky130_fd_sc_hd__clkbuf_1
XFILLER_0_92_317 VGND VGND VPWR VPWR sky130_fd_sc_hd__fill_2
X_3956_ net615 _0996_ _0837_ _1129_ VGND VGND VPWR VPWR _0070_ sky130_fd_sc_hd__a22o_1
XANTENNA__4420__A1 u_pe_array.g_pe_row\[2\].g_pe_col\[2\].u_pe.w_buffer\[0\] VGND
+ VGND VPWR VPWR sky130_fd_sc_hd__diode_2
XFILLER_0_85_391 VGND VGND VPWR VPWR sky130_fd_sc_hd__fill_1
X_6675_ u_pe_array.u_fifo1.rd_ptr\[3\] _3310_ _3306_ _2273_ VGND VGND VPWR VPWR _3311_
+ sky130_fd_sc_hd__a2bb2o_1
XFILLER_0_91_3 VGND VGND VPWR VPWR sky130_fd_sc_hd__decap_8
XFILLER_0_73_597 VGND VGND VPWR VPWR sky130_fd_sc_hd__fill_2
X_5626_ _2518_ _2519_ VGND VGND VPWR VPWR _2521_ sky130_fd_sc_hd__or2_1
XFILLER_0_33_417 VGND VGND VPWR VPWR sky130_fd_sc_hd__fill_2
X_3887_ net503 _0875_ _0887_ _1072_ VGND VGND VPWR VPWR _0058_ sky130_fd_sc_hd__a22o_1
XFILLER_0_60_247 VGND VGND VPWR VPWR sky130_fd_sc_hd__decap_3
XFILLER_0_14_642 VGND VGND VPWR VPWR sky130_fd_sc_hd__fill_2
XANTENNA__7077__RESET_B net815 VGND VGND VPWR VPWR sky130_fd_sc_hd__diode_2
XFILLER_0_103_349 VPWR VGND VPWR VGND sky130_ef_sc_hd__decap_12
XANTENNA__4184__B1 _0914_ VGND VGND VPWR VPWR sky130_fd_sc_hd__diode_2
X_5557_ net822 _2463_ _1655_ _2465_ VGND VGND VPWR VPWR _0335_ sky130_fd_sc_hd__a22o_1
X_5488_ _2406_ _2407_ _2408_ VGND VGND VPWR VPWR _2409_ sky130_fd_sc_hd__or3_1
XANTENNA__7006__RESET_B net816 VGND VGND VPWR VPWR sky130_fd_sc_hd__diode_2
X_4508_ _1581_ _1582_ VGND VGND VPWR VPWR _1583_ sky130_fd_sc_hd__nor2_1
X_7227_ clknet_leaf_61_clk _0290_ net73 VGND VGND VPWR VPWR u_pe_array.g_pe_row\[1\].g_pe_col\[2\].u_pe.psum_out\[1\]
+ sky130_fd_sc_hd__dfrtp_1
X_4439_ u_pe_array.g_pe_row\[3\].g_pe_col\[1\].u_pe.psum_out\[7\] u_pe_array.g_pe_row\[3\].g_pe_col\[1\].u_pe.move_reg\[7\]
+ _0855_ VGND VGND VPWR VPWR _1525_ sky130_fd_sc_hd__mux2_1
XFILLER_0_111_393 VGND VGND VPWR VPWR sky130_fd_sc_hd__fill_2
X_7158_ clknet_leaf_69_clk _0227_ net814 VGND VGND VPWR VPWR u_pe_array.g_pe_row\[1\].g_pe_col\[3\].u_pe.move_reg\[7\]
+ sky130_fd_sc_hd__dfrtp_1
XANTENNA__6816__S _3382_ VGND VGND VPWR VPWR sky130_fd_sc_hd__diode_2
X_6109_ u_pe_array.g_pe_row\[0\].g_pe_col\[1\].u_pe.psum_out\[4\] _2905_ _2906_ VGND
+ VGND VPWR VPWR _2919_ sky130_fd_sc_hd__a21boi_1
X_7089_ clknet_leaf_13_clk _0162_ net818 VGND VGND VPWR VPWR u_pe_array.g_pe_row\[2\].g_pe_col\[1\].u_pe.move_reg\[11\]
+ sky130_fd_sc_hd__dfrtp_1
XTAP_391 VGND VPWR sky130_fd_sc_hd__tapvpwrvgnd_1
XTAP_380 VGND VPWR sky130_fd_sc_hd__tapvpwrvgnd_1
XFILLER_0_96_623 VGND VGND VPWR VPWR sky130_fd_sc_hd__fill_1
XFILLER_0_96_601 VPWR VGND VPWR VGND sky130_ef_sc_hd__decap_12
XTAP_1513 VGND VPWR sky130_fd_sc_hd__tapvpwrvgnd_1
XTAP_1524 VGND VPWR sky130_fd_sc_hd__tapvpwrvgnd_1
XTAP_1502 VGND VPWR sky130_fd_sc_hd__tapvpwrvgnd_1
XPHY_20 VGND VGND VPWR VPWR sky130_fd_sc_hd__decap_3
XPHY_31 VGND VGND VPWR VPWR sky130_fd_sc_hd__decap_3
XTAP_1557 VGND VPWR sky130_fd_sc_hd__tapvpwrvgnd_1
XTAP_1546 VGND VPWR sky130_fd_sc_hd__tapvpwrvgnd_1
XTAP_1535 VGND VPWR sky130_fd_sc_hd__tapvpwrvgnd_1
XPHY_42 VGND VGND VPWR VPWR sky130_fd_sc_hd__decap_3
XPHY_53 VGND VGND VPWR VPWR sky130_fd_sc_hd__decap_3
XPHY_64 VGND VGND VPWR VPWR sky130_fd_sc_hd__decap_3
XANTENNA__5739__A1 _2258_ VGND VGND VPWR VPWR sky130_fd_sc_hd__diode_2
XTAP_1579 VGND VPWR sky130_fd_sc_hd__tapvpwrvgnd_1
XTAP_1568 VGND VPWR sky130_fd_sc_hd__tapvpwrvgnd_1
XFILLER_0_95_177 VGND VGND VPWR VPWR sky130_fd_sc_hd__fill_2
XFILLER_0_83_328 VGND VGND VPWR VPWR sky130_fd_sc_hd__decap_6
XFILLER_0_49_594 VGND VGND VPWR VPWR sky130_fd_sc_hd__decap_3
XPHY_97 VGND VGND VPWR VPWR sky130_fd_sc_hd__decap_3
XPHY_86 VGND VGND VPWR VPWR sky130_fd_sc_hd__decap_3
XPHY_75 VGND VGND VPWR VPWR sky130_fd_sc_hd__decap_3
XANTENNA__6551__S _3239_ VGND VGND VPWR VPWR sky130_fd_sc_hd__diode_2
XANTENNA__5675__B _2478_ VGND VGND VPWR VPWR sky130_fd_sc_hd__diode_2
XFILLER_0_64_531 VGND VGND VPWR VPWR sky130_fd_sc_hd__fill_1
XFILLER_0_36_244 VGND VGND VPWR VPWR sky130_fd_sc_hd__fill_2
XFILLER_0_91_372 VGND VGND VPWR VPWR sky130_fd_sc_hd__decap_3
XANTENNA__3476__A _0734_ VGND VGND VPWR VPWR sky130_fd_sc_hd__diode_2
XFILLER_0_51_225 VGND VGND VPWR VPWR sky130_fd_sc_hd__decap_3
XFILLER_0_17_480 VGND VGND VPWR VPWR sky130_fd_sc_hd__fill_2
XANTENNA__3923__B _1009_ VGND VGND VPWR VPWR sky130_fd_sc_hd__diode_2
XANTENNA__4478__A1 _1536_ VGND VGND VPWR VPWR sky130_fd_sc_hd__diode_2
XANTENNA__6219__A2 _2992_ VGND VGND VPWR VPWR sky130_fd_sc_hd__diode_2
XFILLER_0_63_15 VPWR VGND VPWR VGND sky130_ef_sc_hd__decap_12
XFILLER_0_2_29 VPWR VGND VPWR VGND sky130_ef_sc_hd__decap_12
XANTENNA__3989__B1 _1144_ VGND VGND VPWR VPWR sky130_fd_sc_hd__diode_2
X_3810_ net122 _0996_ _1003_ _1004_ VGND VGND VPWR VPWR _0049_ sky130_fd_sc_hd__a22o_1
X_4790_ u_pe_array.g_pe_row\[2\].g_pe_col\[2\].u_pe.move_reg\[11\] _1005_ _0747_ VGND
+ VGND VPWR VPWR _1818_ sky130_fd_sc_hd__mux2_4
XFILLER_0_7_617 VPWR VGND VPWR VGND sky130_ef_sc_hd__decap_12
X_3741_ _0951_ _0952_ VGND VGND VPWR VPWR _0953_ sky130_fd_sc_hd__nand2_1
XFILLER_0_27_233 VGND VGND VPWR VPWR sky130_fd_sc_hd__fill_2
X_6460_ _1792_ _3140_ _3165_ VGND VGND VPWR VPWR _3194_ sky130_fd_sc_hd__nor3_4
XFILLER_0_12_96 VGND VGND VPWR VPWR sky130_fd_sc_hd__decap_3
X_3672_ _0877_ _0883_ _0888_ VGND VGND VPWR VPWR _0889_ sky130_fd_sc_hd__a21o_1
XANTENNA__7170__RESET_B net813 VGND VGND VPWR VPWR sky130_fd_sc_hd__diode_2
XFILLER_0_88_45 VGND VGND VPWR VPWR sky130_fd_sc_hd__fill_2
X_5411_ net115 _2144_ _2339_ _2336_ VGND VGND VPWR VPWR _0315_ sky130_fd_sc_hd__a22o_1
XFILLER_0_70_589 VGND VGND VPWR VPWR sky130_fd_sc_hd__fill_2
X_6391_ u_pe_array.u_fifo2.count\[0\] _3154_ VGND VGND VPWR VPWR _3155_ sky130_fd_sc_hd__nand2_1
XFILLER_0_2_300 VGND VGND VPWR VPWR sky130_fd_sc_hd__decap_4
X_5342_ u_pe_array.u_fifo1.rd_ptr\[1\] u_pe_array.u_fifo1.rd_ptr\[0\] _2277_ VGND
+ VGND VPWR VPWR _2282_ sky130_fd_sc_hd__and3_2
XFILLER_0_11_601 VPWR VGND VPWR VGND sky130_ef_sc_hd__decap_12
XFILLER_0_23_461 VGND VGND VPWR VPWR sky130_fd_sc_hd__fill_2
XANTENNA__4929__B _1847_ VGND VGND VPWR VPWR sky130_fd_sc_hd__diode_2
XFILLER_0_50_280 VGND VGND VPWR VPWR sky130_fd_sc_hd__fill_2
XFILLER_0_10_144 VGND VGND VPWR VPWR sky130_fd_sc_hd__fill_2
X_5273_ _2221_ VGND VGND VPWR VPWR _2222_ sky130_fd_sc_hd__inv_2
X_7012_ clknet_leaf_12_clk _0089_ net818 VGND VGND VPWR VPWR u_pe_array.g_pe_row\[3\].g_pe_col\[1\].u_pe.psum_out\[9\]
+ sky130_fd_sc_hd__dfrtp_1
XFILLER_0_10_177 VGND VGND VPWR VPWR sky130_fd_sc_hd__decap_6
X_4224_ _1275_ u_pe_array.g_pe_row\[3\].g_pe_col\[0\].u_pe.psum_out\[8\] VGND VGND
+ VPWR VPWR _1352_ sky130_fd_sc_hd__or2_1
X_4155_ _1282_ _1288_ VGND VGND VPWR VPWR _1289_ sky130_fd_sc_hd__nand2_1
XANTENNA__6091__B1 _2174_ VGND VGND VPWR VPWR sky130_fd_sc_hd__diode_2
XFILLER_0_78_612 VGND VGND VPWR VPWR sky130_fd_sc_hd__fill_2
XFILLER_0_78_601 VGND VGND VPWR VPWR sky130_fd_sc_hd__decap_8
X_4086_ _1238_ _1239_ VGND VGND VPWR VPWR _1240_ sky130_fd_sc_hd__or2_1
XANTENNA__6630__A2 _2738_ VGND VGND VPWR VPWR sky130_fd_sc_hd__diode_2
XFILLER_0_18_200 VGND VGND VPWR VPWR sky130_fd_sc_hd__decap_3
XFILLER_0_92_136 VGND VGND VPWR VPWR sky130_fd_sc_hd__fill_2
XANTENNA__7258__RESET_B net812 VGND VGND VPWR VPWR sky130_fd_sc_hd__diode_2
X_4988_ u_pe_array.u_fifo2.buffer\[3\]\[1\] _1969_ _1970_ u_pe_array.u_fifo2.buffer\[2\]\[1\]
+ _1982_ VGND VGND VPWR VPWR _1983_ sky130_fd_sc_hd__a221o_1
X_6727_ net471 _3116_ net65 VGND VGND VPWR VPWR _3342_ sky130_fd_sc_hd__mux2_1
X_3939_ _1117_ _1118_ VGND VGND VPWR VPWR _1119_ sky130_fd_sc_hd__xnor2_1
XFILLER_0_18_266 VGND VGND VPWR VPWR sky130_fd_sc_hd__decap_4
X_6658_ u_pe_array.u_fifo1.wr_ptr\[1\] VGND VGND VPWR VPWR _3300_ sky130_fd_sc_hd__inv_2
XFILLER_0_103_113 VGND VGND VPWR VPWR sky130_fd_sc_hd__fill_2
X_5609_ _2496_ _2497_ _2503_ VGND VGND VPWR VPWR _2505_ sky130_fd_sc_hd__o21ai_1
XFILLER_0_104_669 VGND VGND VPWR VPWR sky130_fd_sc_hd__fill_2
XFILLER_0_5_193 VGND VGND VPWR VPWR sky130_fd_sc_hd__decap_6
X_6589_ net243 _1812_ _3254_ VGND VGND VPWR VPWR _3263_ sky130_fd_sc_hd__mux2_1
XANTENNA__5715__S _0770_ VGND VGND VPWR VPWR sky130_fd_sc_hd__diode_2
XFILLER_0_96_431 VGND VGND VPWR VPWR sky130_fd_sc_hd__fill_2
XTAP_1332 VGND VPWR sky130_fd_sc_hd__tapvpwrvgnd_1
XTAP_1321 VGND VPWR sky130_fd_sc_hd__tapvpwrvgnd_1
XTAP_1310 VGND VPWR sky130_fd_sc_hd__tapvpwrvgnd_1
XTAP_1354 VGND VPWR sky130_fd_sc_hd__tapvpwrvgnd_1
XTAP_1365 VGND VPWR sky130_fd_sc_hd__tapvpwrvgnd_1
XTAP_1343 VGND VPWR sky130_fd_sc_hd__tapvpwrvgnd_1
XTAP_1398 VGND VPWR sky130_fd_sc_hd__tapvpwrvgnd_1
XTAP_1387 VGND VPWR sky130_fd_sc_hd__tapvpwrvgnd_1
XTAP_1376 VGND VPWR sky130_fd_sc_hd__tapvpwrvgnd_1
XFILLER_0_83_147 VGND VGND VPWR VPWR sky130_fd_sc_hd__fill_2
XANTENNA__5188__A2 _2144_ VGND VGND VPWR VPWR sky130_fd_sc_hd__diode_2
XANTENNA__4396__B1 _1144_ VGND VGND VPWR VPWR sky130_fd_sc_hd__diode_2
XANTENNA__4935__A2 _1714_ VGND VGND VPWR VPWR sky130_fd_sc_hd__diode_2
XFILLER_0_83_169 VGND VGND VPWR VPWR sky130_fd_sc_hd__decap_4
Xinput16 v_in0[1] VGND VGND VPWR VPWR net16 sky130_fd_sc_hd__clkbuf_2
Xinput27 w_in_flat[0] VGND VGND VPWR VPWR net27 sky130_fd_sc_hd__buf_1
XANTENNA__5854__A_N _2611_ VGND VGND VPWR VPWR sky130_fd_sc_hd__diode_2
XFILLER_0_107_485 VGND VGND VPWR VPWR sky130_fd_sc_hd__fill_2
XANTENNA__4699__A1 _1725_ VGND VGND VPWR VPWR sky130_fd_sc_hd__diode_2
XFILLER_0_58_15 VPWR VGND VPWR VGND sky130_ef_sc_hd__decap_12
XANTENNA__5360__S _0756_ VGND VGND VPWR VPWR sky130_fd_sc_hd__diode_2
XFILLER_0_79_409 VGND VGND VPWR VPWR sky130_fd_sc_hd__fill_2
XFILLER_0_59_111 VGND VGND VPWR VPWR sky130_fd_sc_hd__fill_1
X_5960_ u_pe_array.g_pe_row\[0\].g_pe_col\[2\].u_pe.act_val\[5\] VGND VGND VPWR VPWR
+ _2797_ sky130_fd_sc_hd__inv_2
X_4911_ _1914_ u_pe_array.g_pe_row\[2\].g_pe_col\[0\].u_pe.psum_out\[7\] _1900_ VGND
+ VGND VPWR VPWR _1915_ sky130_fd_sc_hd__mux2_1
XFILLER_0_90_24 VGND VGND VPWR VPWR sky130_fd_sc_hd__fill_2
X_5891_ net214 _2600_ _2736_ _0722_ VGND VGND VPWR VPWR _0398_ sky130_fd_sc_hd__a22o_1
X_7630_ clknet_leaf_23_clk _0679_ VGND VGND VPWR VPWR u_pe_array.u_fifo1.buffer\[5\]\[1\]
+ sky130_fd_sc_hd__dfxtp_1
XFILLER_0_59_188 VPWR VGND VPWR VGND sky130_ef_sc_hd__decap_12
XFILLER_0_114_53 VGND VGND VPWR VPWR sky130_fd_sc_hd__decap_3
X_4842_ u_pe_array.g_pe_row\[2\].g_pe_col\[0\].u_pe.psum_out\[1\] _1850_ VGND VGND
+ VPWR VPWR _1852_ sky130_fd_sc_hd__nand2_1
XANTENNA__5179__A2 _1666_ VGND VGND VPWR VPWR sky130_fd_sc_hd__diode_2
XANTENNA__7351__RESET_B net818 VGND VGND VPWR VPWR sky130_fd_sc_hd__diode_2
XFILLER_0_114_97 VGND VGND VPWR VPWR sky130_fd_sc_hd__decap_8
X_7561_ clknet_leaf_17_clk _0610_ net816 VGND VGND VPWR VPWR u_pe_array.u_fifo1.count\[1\]
+ sky130_fd_sc_hd__dfrtp_1
X_4773_ _1806_ net545 _1796_ VGND VGND VPWR VPWR _1807_ sky130_fd_sc_hd__mux2_1
X_6512_ net223 _1820_ _3208_ VGND VGND VPWR VPWR _3221_ sky130_fd_sc_hd__mux2_1
XFILLER_0_15_203 VGND VGND VPWR VPWR sky130_fd_sc_hd__decap_3
XFILLER_0_15_225 VGND VGND VPWR VPWR sky130_fd_sc_hd__fill_2
X_3724_ _0937_ VGND VGND VPWR VPWR _0938_ sky130_fd_sc_hd__inv_2
X_7492_ clknet_leaf_3_clk _0541_ VGND VGND VPWR VPWR u_pe_array.u_fifo2.buffer\[4\]\[5\]
+ sky130_fd_sc_hd__dfxtp_1
X_3655_ u_pe_array.g_pe_row\[3\].g_pe_col\[3\].u_pe.psum_out\[1\] _0872_ VGND VGND
+ VPWR VPWR _0874_ sky130_fd_sc_hd__nand2_1
X_6443_ _3185_ VGND VGND VPWR VPWR _0501_ sky130_fd_sc_hd__clkbuf_1
XFILLER_0_3_653 VPWR VGND VPWR VGND sky130_ef_sc_hd__decap_12
XFILLER_0_30_206 VGND VGND VPWR VPWR sky130_fd_sc_hd__fill_2
XFILLER_0_30_228 VGND VGND VPWR VPWR sky130_fd_sc_hd__fill_2
XFILLER_0_101_617 VGND VGND VPWR VPWR sky130_fd_sc_hd__decap_8
X_6374_ _3142_ _3143_ VGND VGND VPWR VPWR _3144_ sky130_fd_sc_hd__and2b_1
X_3586_ net598 _0821_ _0801_ VGND VGND VPWR VPWR _0823_ sky130_fd_sc_hd__a21boi_1
XFILLER_0_2_141 VPWR VGND VPWR VGND sky130_ef_sc_hd__decap_12
X_5325_ _2266_ _2267_ VGND VGND VPWR VPWR _2268_ sky130_fd_sc_hd__xnor2_1
XFILLER_0_11_453 VGND VGND VPWR VPWR sky130_fd_sc_hd__fill_2
X_5256_ _2204_ _2205_ VGND VGND VPWR VPWR _2206_ sky130_fd_sc_hd__nor2_1
XFILLER_0_54_3 VPWR VGND VPWR VGND sky130_ef_sc_hd__decap_12
XFILLER_0_11_497 VGND VGND VPWR VPWR sky130_fd_sc_hd__decap_3
X_4207_ _1315_ _1324_ VGND VGND VPWR VPWR _1337_ sky130_fd_sc_hd__and2_1
X_5187_ u_pe_array.g_pe_row\[1\].g_pe_col\[2\].u_pe.psum_out\[7\] u_pe_array.g_pe_row\[1\].g_pe_col\[2\].u_pe.move_reg\[7\]
+ _1661_ VGND VGND VPWR VPWR _2148_ sky130_fd_sc_hd__mux2_1
X_4138_ _0863_ VGND VGND VPWR VPWR _1273_ sky130_fd_sc_hd__buf_8
X_4069_ _1223_ _1224_ VGND VGND VPWR VPWR _1225_ sky130_fd_sc_hd__or2_1
Xwire62 net63 VGND VGND VPWR VPWR net62 sky130_fd_sc_hd__buf_2
XFILLER_0_78_475 VGND VGND VPWR VPWR sky130_fd_sc_hd__fill_1
XANTENNA__4614__S _1661_ VGND VGND VPWR VPWR sky130_fd_sc_hd__diode_2
XFILLER_0_65_103 VGND VGND VPWR VPWR sky130_fd_sc_hd__decap_8
XFILLER_0_93_445 VGND VGND VPWR VPWR sky130_fd_sc_hd__decap_3
XANTENNA__5937__C _2743_ VGND VGND VPWR VPWR sky130_fd_sc_hd__diode_2
XFILLER_0_65_169 VGND VGND VPWR VPWR sky130_fd_sc_hd__fill_2
XANTENNA__7092__RESET_B net815 VGND VGND VPWR VPWR sky130_fd_sc_hd__diode_2
XANTENNA__7021__RESET_B net819 VGND VGND VPWR VPWR sky130_fd_sc_hd__diode_2
XFILLER_0_104_411 VGND VGND VPWR VPWR sky130_fd_sc_hd__fill_2
XFILLER_0_34_545 VGND VGND VPWR VPWR sky130_fd_sc_hd__decap_6
XFILLER_0_61_397 VGND VGND VPWR VPWR sky130_fd_sc_hd__decap_4
XFILLER_0_21_228 VGND VGND VPWR VPWR sky130_fd_sc_hd__decap_3
XFILLER_0_104_477 VGND VGND VPWR VPWR sky130_fd_sc_hd__decap_3
XANTENNA__4569__B _1536_ VGND VGND VPWR VPWR sky130_fd_sc_hd__diode_2
XFILLER_0_88_206 VGND VGND VPWR VPWR sky130_fd_sc_hd__fill_2
XANTENNA__7109__RESET_B net76 VGND VGND VPWR VPWR sky130_fd_sc_hd__diode_2
XTAP_1140 VGND VPWR sky130_fd_sc_hd__tapvpwrvgnd_1
XFILLER_0_69_475 VGND VGND VPWR VPWR sky130_fd_sc_hd__decap_8
XFILLER_0_57_626 VGND VGND VPWR VPWR sky130_fd_sc_hd__decap_3
XANTENNA__6358__A1 _1787_ VGND VGND VPWR VPWR sky130_fd_sc_hd__diode_2
XTAP_1173 VGND VPWR sky130_fd_sc_hd__tapvpwrvgnd_1
XTAP_1162 VGND VPWR sky130_fd_sc_hd__tapvpwrvgnd_1
XTAP_1151 VGND VPWR sky130_fd_sc_hd__tapvpwrvgnd_1
XFILLER_0_56_125 VGND VGND VPWR VPWR sky130_fd_sc_hd__fill_2
XTAP_1195 VGND VPWR sky130_fd_sc_hd__tapvpwrvgnd_1
XTAP_1184 VGND VPWR sky130_fd_sc_hd__tapvpwrvgnd_1
XFILLER_0_56_169 VGND VGND VPWR VPWR sky130_fd_sc_hd__decap_4
XFILLER_0_52_320 VGND VGND VPWR VPWR sky130_fd_sc_hd__decap_4
XFILLER_0_25_534 VGND VGND VPWR VPWR sky130_fd_sc_hd__fill_2
XANTENNA__5581__A2 _2478_ VGND VGND VPWR VPWR sky130_fd_sc_hd__diode_2
Xhold608 u_pe_array.g_pe_row\[2\].g_pe_col\[2\].u_pe.psum_out\[5\] VGND VGND VPWR
+ VPWR net684 sky130_fd_sc_hd__dlygate4sd3_1
XFILLER_0_110_414 VGND VGND VPWR VPWR sky130_fd_sc_hd__fill_2
XANTENNA__5582__C _2478_ VGND VGND VPWR VPWR sky130_fd_sc_hd__diode_2
XFILLER_0_0_601 VPWR VGND VPWR VGND sky130_ef_sc_hd__decap_12
Xhold619 u_pe_array.g_pe_row\[3\].g_pe_col\[3\].u_pe.act_val\[1\] VGND VGND VPWR VPWR
+ net695 sky130_fd_sc_hd__dlygate4sd3_1
XFILLER_0_0_645 VPWR VGND VPWR VGND sky130_ef_sc_hd__decap_12
X_6090_ _2890_ _2901_ VGND VGND VPWR VPWR _2902_ sky130_fd_sc_hd__xor2_1
XFILLER_0_85_35 VGND VGND VPWR VPWR sky130_fd_sc_hd__fill_2
XTAP_935 VGND VPWR sky130_fd_sc_hd__tapvpwrvgnd_1
XTAP_924 VGND VPWR sky130_fd_sc_hd__tapvpwrvgnd_1
XTAP_913 VGND VPWR sky130_fd_sc_hd__tapvpwrvgnd_1
XTAP_902 VGND VPWR sky130_fd_sc_hd__tapvpwrvgnd_1
XFILLER_0_0_667 VGND VGND VPWR VPWR sky130_fd_sc_hd__decap_4
X_5110_ _2085_ _2086_ VGND VGND VPWR VPWR _2087_ sky130_fd_sc_hd__nand2_1
XFILLER_0_85_57 VGND VGND VPWR VPWR sky130_fd_sc_hd__fill_1
XTAP_957 VGND VPWR sky130_fd_sc_hd__tapvpwrvgnd_1
XTAP_968 VGND VPWR sky130_fd_sc_hd__tapvpwrvgnd_1
XTAP_946 VGND VPWR sky130_fd_sc_hd__tapvpwrvgnd_1
X_5041_ net166 _1666_ _2025_ _1665_ VGND VGND VPWR VPWR _0259_ sky130_fd_sc_hd__a22o_1
XANTENNA__6186__S _0827_ VGND VGND VPWR VPWR sky130_fd_sc_hd__diode_2
XTAP_979 VGND VPWR sky130_fd_sc_hd__tapvpwrvgnd_1
XANTENNA__6597__A1 _1820_ VGND VGND VPWR VPWR sky130_fd_sc_hd__diode_2
X_6992_ clknet_leaf_33_clk _0071_ net76 VGND VGND VPWR VPWR u_pe_array.g_pe_row\[3\].g_pe_col\[0\].u_pe.act_val\[4\]
+ sky130_fd_sc_hd__dfrtp_1
XFILLER_0_19_6 VGND VGND VPWR VPWR sky130_fd_sc_hd__fill_2
X_5943_ _2779_ _2780_ VGND VGND VPWR VPWR _2782_ sky130_fd_sc_hd__or2_1
XANTENNA__6349__A1 _1787_ VGND VGND VPWR VPWR sky130_fd_sc_hd__diode_2
XFILLER_0_87_294 VGND VGND VPWR VPWR sky130_fd_sc_hd__decap_4
X_5874_ u_pe_array.g_pe_row\[1\].g_pe_col\[1\].u_pe.act_val\[2\] net418 _0770_ VGND
+ VGND VPWR VPWR _2728_ sky130_fd_sc_hd__mux2_1
XANTENNA__4434__S _0769_ VGND VGND VPWR VPWR sky130_fd_sc_hd__diode_2
XFILLER_0_47_136 VGND VGND VPWR VPWR sky130_fd_sc_hd__fill_2
X_7613_ clknet_leaf_25_clk _0662_ VGND VGND VPWR VPWR u_pe_array.u_fifo1.buffer\[3\]\[10\]
+ sky130_fd_sc_hd__dfxtp_1
XFILLER_0_90_415 VGND VGND VPWR VPWR sky130_fd_sc_hd__fill_2
XFILLER_0_75_489 VGND VGND VPWR VPWR sky130_fd_sc_hd__fill_1
XFILLER_0_7_222 VGND VGND VPWR VPWR sky130_fd_sc_hd__fill_2
X_4825_ _1839_ VGND VGND VPWR VPWR _0229_ sky130_fd_sc_hd__clkbuf_1
XFILLER_0_56_670 VGND VGND VPWR VPWR sky130_fd_sc_hd__fill_2
X_7544_ clknet_leaf_82_clk _0593_ net818 VGND VGND VPWR VPWR u_pe_array.g_pe_row\[3\].g_pe_col\[3\].u_pe.act_val\[5\]
+ sky130_fd_sc_hd__dfrtp_4
X_4756_ _1789_ _1794_ VGND VGND VPWR VPWR _1795_ sky130_fd_sc_hd__or2_1
XFILLER_0_50_93 VGND VGND VPWR VPWR sky130_fd_sc_hd__fill_2
XFILLER_0_50_71 VGND VGND VPWR VPWR sky130_fd_sc_hd__decap_8
XFILLER_0_16_567 VGND VGND VPWR VPWR sky130_fd_sc_hd__decap_3
XANTENNA__5572__A2 _2463_ VGND VGND VPWR VPWR sky130_fd_sc_hd__diode_2
XFILLER_0_70_172 VGND VGND VPWR VPWR sky130_fd_sc_hd__fill_2
X_4687_ _1731_ _1727_ VGND VGND VPWR VPWR _1733_ sky130_fd_sc_hd__and2b_1
X_3707_ _0920_ _0921_ VGND VGND VPWR VPWR _0922_ sky130_fd_sc_hd__nor2_1
XFILLER_0_16_589 VGND VGND VPWR VPWR sky130_fd_sc_hd__decap_4
X_7475_ clknet_leaf_2_clk _0524_ VGND VGND VPWR VPWR u_pe_array.u_fifo2.buffer\[3\]\[1\]
+ sky130_fd_sc_hd__dfxtp_1
XFILLER_0_31_515 VGND VGND VPWR VPWR sky130_fd_sc_hd__fill_2
X_3638_ u_pe_array.g_pe_row\[3\].g_pe_col\[3\].u_pe.act_val\[0\] u_pe_array.g_pe_row\[3\].g_pe_col\[3\].u_pe.w_reg\[0\]
+ u_pe_array.g_pe_row\[3\].g_pe_col\[3\].u_pe.psum_out\[0\] VGND VGND VPWR VPWR _0858_
+ sky130_fd_sc_hd__a21o_1
X_6426_ _3176_ VGND VGND VPWR VPWR _0493_ sky130_fd_sc_hd__clkbuf_1
X_6357_ _3131_ VGND VGND VPWR VPWR _0469_ sky130_fd_sc_hd__clkbuf_1
X_3569_ u_fsm.cnt\[1\] u_fsm.cnt\[0\] u_fsm.cnt\[2\] VGND VGND VPWR VPWR _0811_ sky130_fd_sc_hd__a21o_1
XFILLER_0_3_494 VGND VGND VPWR VPWR sky130_fd_sc_hd__decap_8
X_5308_ _2251_ _2252_ VGND VGND VPWR VPWR _2253_ sky130_fd_sc_hd__nand2_1
X_6288_ _3067_ _3069_ _3070_ _3076_ net71 VGND VGND VPWR VPWR _3078_ sky130_fd_sc_hd__a41o_1
XANTENNA__4835__A1 _1725_ VGND VGND VPWR VPWR sky130_fd_sc_hd__diode_2
X_5239_ u_pe_array.g_pe_row\[1\].g_pe_col\[2\].u_pe.act_val\[3\] VGND VGND VPWR VPWR
+ _2190_ sky130_fd_sc_hd__inv_2
XANTENNA__6824__S _3382_ VGND VGND VPWR VPWR sky130_fd_sc_hd__diode_2
XANTENNA__6037__B1 _2592_ VGND VGND VPWR VPWR sky130_fd_sc_hd__diode_2
XFILLER_0_98_526 VGND VGND VPWR VPWR sky130_fd_sc_hd__fill_2
XANTENNA__7273__RESET_B net814 VGND VGND VPWR VPWR sky130_fd_sc_hd__diode_2
XPHY_201 VGND VGND VPWR VPWR sky130_fd_sc_hd__decap_3
XFILLER_0_78_250 VGND VGND VPWR VPWR sky130_fd_sc_hd__fill_2
XPHY_223 VGND VGND VPWR VPWR sky130_fd_sc_hd__decap_3
XFILLER_0_109_503 VGND VGND VPWR VPWR sky130_fd_sc_hd__fill_1
XPHY_212 VGND VGND VPWR VPWR sky130_fd_sc_hd__decap_3
XANTENNA__7202__RESET_B net814 VGND VGND VPWR VPWR sky130_fd_sc_hd__diode_2
XFILLER_0_81_404 VGND VGND VPWR VPWR sky130_fd_sc_hd__decap_3
XANTENNA__3810__A2 _0996_ VGND VGND VPWR VPWR sky130_fd_sc_hd__diode_2
XFILLER_0_19_372 VGND VGND VPWR VPWR sky130_fd_sc_hd__fill_2
XANTENNA__5563__A2 _2463_ VGND VGND VPWR VPWR sky130_fd_sc_hd__diode_2
XFILLER_0_104_230 VGND VGND VPWR VPWR sky130_fd_sc_hd__fill_2
XFILLER_0_62_673 VGND VGND VPWR VPWR sky130_fd_sc_hd__fill_2
XANTENNA__6512__A1 _1820_ VGND VGND VPWR VPWR sky130_fd_sc_hd__diode_2
XFILLER_0_22_537 VGND VGND VPWR VPWR sky130_fd_sc_hd__fill_1
XFILLER_0_22_548 VGND VGND VPWR VPWR sky130_fd_sc_hd__fill_2
XANTENNA__3915__C _1009_ VGND VGND VPWR VPWR sky130_fd_sc_hd__diode_2
XFILLER_0_39_39 VGND VGND VPWR VPWR sky130_fd_sc_hd__decap_8
Xhold5 u_pe_array.g_pe_row\[3\].g_pe_col\[1\].u_pe.w_buffer\[1\] VGND VGND VPWR VPWR
+ net81 sky130_fd_sc_hd__dlygate4sd3_1
XFILLER_0_55_27 VPWR VGND VPWR VGND sky130_ef_sc_hd__decap_12
XFILLER_0_71_15 VPWR VGND VPWR VGND sky130_ef_sc_hd__decap_12
XFILLER_0_84_253 VGND VGND VPWR VPWR sky130_fd_sc_hd__fill_2
XFILLER_0_57_456 VGND VGND VPWR VPWR sky130_fd_sc_hd__fill_2
XANTENNA__3801__A2 _0996_ VGND VGND VPWR VPWR sky130_fd_sc_hd__diode_2
XANTENNA__6996__RESET_B net817 VGND VGND VPWR VPWR sky130_fd_sc_hd__diode_2
XFILLER_0_84_275 VGND VGND VPWR VPWR sky130_fd_sc_hd__fill_2
XFILLER_0_72_415 VGND VGND VPWR VPWR sky130_fd_sc_hd__decap_3
X_4610_ u_pe_array.g_pe_row\[2\].g_pe_col\[1\].u_pe.psum_out\[11\] u_pe_array.g_pe_row\[2\].g_pe_col\[1\].u_pe.move_reg\[11\]
+ _1661_ VGND VGND VPWR VPWR _1664_ sky130_fd_sc_hd__mux2_1
XFILLER_0_112_3 VPWR VGND VPWR VGND sky130_ef_sc_hd__decap_12
X_5590_ u_pe_array.g_pe_row\[1\].g_pe_col\[0\].u_pe.psum_out\[2\] _2486_ VGND VGND
+ VPWR VPWR _2487_ sky130_fd_sc_hd__xnor2_1
XANTENNA__6925__RESET_B net816 VGND VGND VPWR VPWR sky130_fd_sc_hd__diode_2
XFILLER_0_53_673 VGND VGND VPWR VPWR sky130_fd_sc_hd__fill_2
X_4541_ _1536_ u_pe_array.g_pe_row\[2\].g_pe_col\[2\].u_pe.psum_out\[8\] VGND VGND
+ VPWR VPWR _1613_ sky130_fd_sc_hd__or2_1
X_7260_ clknet_leaf_48_clk _0321_ net812 VGND VGND VPWR VPWR u_pe_array.g_pe_row\[1\].g_pe_col\[1\].u_pe.psum_out\[4\]
+ sky130_fd_sc_hd__dfrtp_1
XFILLER_0_80_481 VGND VGND VPWR VPWR sky130_fd_sc_hd__decap_4
X_4472_ _1543_ _1549_ VGND VGND VPWR VPWR _1550_ sky130_fd_sc_hd__nand2_1
XFILLER_0_20_85 VGND VGND VPWR VPWR sky130_fd_sc_hd__fill_2
Xhold405 u_pe_array.u_fifo2.buffer\[7\]\[4\] VGND VGND VPWR VPWR net481 sky130_fd_sc_hd__dlygate4sd3_1
Xhold416 u_pe_array.u_fifo2.buffer\[1\]\[5\] VGND VGND VPWR VPWR net492 sky130_fd_sc_hd__dlygate4sd3_1
Xhold427 u_pe_array.g_pe_row\[3\].g_pe_col\[2\].u_pe.psum_out\[6\] VGND VGND VPWR
+ VPWR net503 sky130_fd_sc_hd__dlygate4sd3_1
X_6211_ _3005_ _3006_ VGND VGND VPWR VPWR _3007_ sky130_fd_sc_hd__xor2_1
Xhold438 u_pe_array.g_pe_row\[0\].g_pe_col\[1\].u_pe.psum_out\[11\] VGND VGND VPWR
+ VPWR net514 sky130_fd_sc_hd__dlygate4sd3_1
Xhold449 u_pe_array.u_fifo1.buffer\[3\]\[2\] VGND VGND VPWR VPWR net525 sky130_fd_sc_hd__dlygate4sd3_1
X_7191_ clknet_leaf_65_clk _0258_ net73 VGND VGND VPWR VPWR u_pe_array.g_pe_row\[1\].g_pe_col\[2\].u_pe.move_reg\[10\]
+ sky130_fd_sc_hd__dfrtp_1
XANTENNA__5910__B_N _2743_ VGND VGND VPWR VPWR sky130_fd_sc_hd__diode_2
XFILLER_0_96_45 VGND VGND VPWR VPWR sky130_fd_sc_hd__fill_1
X_6142_ _2873_ u_pe_array.g_pe_row\[0\].g_pe_col\[1\].u_pe.psum_out\[8\] VGND VGND
+ VPWR VPWR _2949_ sky130_fd_sc_hd__nand2_1
XTAP_710 VGND VPWR sky130_fd_sc_hd__tapvpwrvgnd_1
XFILLER_0_96_89 VGND VGND VPWR VPWR sky130_fd_sc_hd__decap_4
XTAP_732 VGND VPWR sky130_fd_sc_hd__tapvpwrvgnd_1
XTAP_721 VGND VPWR sky130_fd_sc_hd__tapvpwrvgnd_1
XTAP_743 VGND VPWR sky130_fd_sc_hd__tapvpwrvgnd_1
X_6073_ _2881_ _2885_ VGND VGND VPWR VPWR _2886_ sky130_fd_sc_hd__xor2_1
XTAP_776 VGND VPWR sky130_fd_sc_hd__tapvpwrvgnd_1
XTAP_765 VGND VPWR sky130_fd_sc_hd__tapvpwrvgnd_1
XTAP_754 VGND VPWR sky130_fd_sc_hd__tapvpwrvgnd_1
XTAP_798 VGND VPWR sky130_fd_sc_hd__tapvpwrvgnd_1
XTAP_787 VGND VPWR sky130_fd_sc_hd__tapvpwrvgnd_1
X_5024_ u_pe_array.u_fifo2.buffer\[3\]\[5\] _1969_ _1970_ u_pe_array.u_fifo2.buffer\[2\]\[5\]
+ _2014_ VGND VGND VPWR VPWR _2015_ sky130_fd_sc_hd__a221o_1
XANTENNA__6019__B1 _2743_ VGND VGND VPWR VPWR sky130_fd_sc_hd__diode_2
XFILLER_0_67_209 VGND VGND VPWR VPWR sky130_fd_sc_hd__fill_1
X_6975_ clknet_leaf_86_clk _0054_ net819 VGND VGND VPWR VPWR u_pe_array.g_pe_row\[3\].g_pe_col\[2\].u_pe.psum_out\[2\]
+ sky130_fd_sc_hd__dfrtp_1
X_5926_ _2764_ u_pe_array.g_pe_row\[0\].g_pe_col\[2\].u_pe.psum_out\[3\] _2743_ VGND
+ VGND VPWR VPWR _2766_ sky130_fd_sc_hd__and3_1
XFILLER_0_63_404 VGND VGND VPWR VPWR sky130_fd_sc_hd__decap_8
XFILLER_0_8_531 VGND VGND VPWR VPWR sky130_fd_sc_hd__fill_1
XFILLER_0_90_212 VGND VGND VPWR VPWR sky130_fd_sc_hd__fill_1
XFILLER_0_61_81 VPWR VGND VPWR VGND sky130_ef_sc_hd__decap_12
XFILLER_0_48_489 VGND VGND VPWR VPWR sky130_fd_sc_hd__fill_1
X_5857_ u_pe_array.g_pe_row\[0\].g_pe_col\[3\].u_pe.psum_out\[10\] _2713_ _2716_ VGND
+ VGND VPWR VPWR _2717_ sky130_fd_sc_hd__a21oi_1
XFILLER_0_44_640 VGND VGND VPWR VPWR sky130_fd_sc_hd__fill_2
X_4808_ net775 _1666_ _1655_ _1829_ VGND VGND VPWR VPWR _0222_ sky130_fd_sc_hd__a22o_1
X_5788_ u_pe_array.g_pe_row\[0\].g_pe_col\[3\].u_pe.w_reg\[0\] u_pe_array.g_pe_row\[0\].g_pe_col\[3\].u_pe.act_val\[5\]
+ VGND VGND VPWR VPWR _2654_ sky130_fd_sc_hd__nand2_1
X_4739_ u_pe_array.g_pe_row\[2\].g_pe_col\[1\].u_pe.psum_out\[10\] _1776_ _1779_ VGND
+ VGND VPWR VPWR _1780_ sky130_fd_sc_hd__a21oi_1
XFILLER_0_44_673 VGND VGND VPWR VPWR sky130_fd_sc_hd__fill_2
X_7527_ clknet_leaf_2_clk _0576_ VGND VGND VPWR VPWR u_pe_array.u_fifo2.buffer\[7\]\[1\]
+ sky130_fd_sc_hd__dfxtp_1
X_7458_ clknet_leaf_1_clk _0507_ VGND VGND VPWR VPWR u_pe_array.u_fifo2.buffer\[1\]\[10\]
+ sky130_fd_sc_hd__dfxtp_1
X_6409_ net478 _1798_ net70 VGND VGND VPWR VPWR _3168_ sky130_fd_sc_hd__mux2_1
X_7389_ clknet_leaf_42_clk _0442_ net817 VGND VGND VPWR VPWR u_pe_array.g_pe_row\[0\].g_pe_col\[0\].u_pe.w_buffer\[0\]
+ sky130_fd_sc_hd__dfrtp_1
XFILLER_0_101_255 VGND VGND VPWR VPWR sky130_fd_sc_hd__fill_2
XFILLER_0_101_233 VGND VGND VPWR VPWR sky130_fd_sc_hd__fill_1
XANTENNA__4847__B _1847_ VGND VGND VPWR VPWR sky130_fd_sc_hd__diode_2
XANTENNA__4808__B2 _1829_ VGND VGND VPWR VPWR sky130_fd_sc_hd__diode_2
XANTENNA__5481__A1 _2345_ VGND VGND VPWR VPWR sky130_fd_sc_hd__diode_2
XFILLER_0_98_389 VPWR VGND VPWR VGND sky130_ef_sc_hd__decap_12
XFILLER_0_94_562 VGND VGND VPWR VPWR sky130_fd_sc_hd__decap_4
XFILLER_0_66_253 VGND VGND VPWR VPWR sky130_fd_sc_hd__fill_2
XFILLER_0_27_607 VGND VGND VPWR VPWR sky130_fd_sc_hd__fill_2
XFILLER_0_81_201 VGND VGND VPWR VPWR sky130_fd_sc_hd__fill_2
XFILLER_0_34_150 VGND VGND VPWR VPWR sky130_fd_sc_hd__decap_3
XFILLER_0_105_561 VGND VGND VPWR VPWR sky130_fd_sc_hd__decap_4
XFILLER_0_62_481 VGND VGND VPWR VPWR sky130_fd_sc_hd__decap_3
XFILLER_0_50_643 VGND VGND VPWR VPWR sky130_fd_sc_hd__fill_1
XFILLER_0_34_183 VGND VGND VPWR VPWR sky130_fd_sc_hd__fill_1
XFILLER_0_34_194 VGND VGND VPWR VPWR sky130_fd_sc_hd__fill_2
XFILLER_0_1_217 VGND VGND VPWR VPWR sky130_fd_sc_hd__decap_6
XFILLER_0_22_345 VGND VGND VPWR VPWR sky130_fd_sc_hd__fill_2
XFILLER_0_66_15 VPWR VGND VPWR VGND sky130_ef_sc_hd__decap_12
XANTENNA__7195__RESET_B net815 VGND VGND VPWR VPWR sky130_fd_sc_hd__diode_2
XANTENNA__7124__RESET_B net76 VGND VGND VPWR VPWR sky130_fd_sc_hd__diode_2
XANTENNA__4275__A2 _1392_ VGND VGND VPWR VPWR sky130_fd_sc_hd__diode_2
XANTENNA__5588__B u_pe_array.g_pe_row\[1\].g_pe_col\[0\].u_pe.w_reg\[0\] VGND VGND
+ VPWR VPWR sky130_fd_sc_hd__diode_2
X_6760_ net275 _3122_ net62 VGND VGND VPWR VPWR _3359_ sky130_fd_sc_hd__mux2_1
XFILLER_0_15_74 VGND VGND VPWR VPWR sky130_fd_sc_hd__decap_4
XFILLER_0_85_551 VGND VGND VPWR VPWR sky130_fd_sc_hd__fill_2
X_3972_ u_pe_array.g_pe_row\[2\].g_pe_col\[0\].u_pe.move_reg\[10\] u_pe_array.g_pe_row\[2\].g_pe_col\[0\].u_pe.psum_out\[10\]
+ _0755_ VGND VGND VPWR VPWR _1139_ sky130_fd_sc_hd__mux2_1
XFILLER_0_45_404 VGND VGND VPWR VPWR sky130_fd_sc_hd__fill_2
X_5711_ u_pe_array.g_pe_row\[0\].g_pe_col\[3\].u_pe.psum_out\[1\] u_pe_array.g_pe_row\[0\].g_pe_col\[3\].u_pe.act_val\[1\]
+ _0745_ VGND VGND VPWR VPWR _2594_ sky130_fd_sc_hd__mux2_1
XFILLER_0_85_595 VGND VGND VPWR VPWR sky130_fd_sc_hd__fill_2
X_6691_ u_pe_array.u_fifo1.wr_ptr\[2\] u_pe_array.u_fifo1.wr_ptr\[3\] _1789_ _3105_
+ VGND VGND VPWR VPWR _3322_ sky130_fd_sc_hd__or4_1
XFILLER_0_45_426 VGND VGND VPWR VPWR sky130_fd_sc_hd__decap_3
X_5642_ u_pe_array.g_pe_row\[1\].g_pe_col\[0\].u_pe.psum_out\[5\] _2478_ VGND VGND
+ VPWR VPWR _2535_ sky130_fd_sc_hd__nand2_1
XFILLER_0_13_301 VGND VGND VPWR VPWR sky130_fd_sc_hd__fill_2
X_5573_ u_pe_array.g_pe_row\[1\].g_pe_col\[3\].u_pe.psum_out\[11\] u_pe_array.g_pe_row\[1\].g_pe_col\[3\].u_pe.move_reg\[11\]
+ _2469_ VGND VGND VPWR VPWR _2474_ sky130_fd_sc_hd__mux2_1
XFILLER_0_41_610 VGND VGND VPWR VPWR sky130_fd_sc_hd__fill_2
X_7312_ clknet_leaf_66_clk _0371_ net814 VGND VGND VPWR VPWR u_pe_array.g_pe_row\[0\].g_pe_col\[2\].u_pe.move_reg\[11\]
+ sky130_fd_sc_hd__dfrtp_1
X_4524_ _1576_ _1585_ VGND VGND VPWR VPWR _1598_ sky130_fd_sc_hd__and2_1
Xhold202 _0340_ VGND VGND VPWR VPWR net278 sky130_fd_sc_hd__dlygate4sd3_1
XFILLER_0_40_120 VGND VGND VPWR VPWR sky130_fd_sc_hd__fill_2
Xhold213 u_pe_array.u_fifo1.buffer\[3\]\[9\] VGND VGND VPWR VPWR net289 sky130_fd_sc_hd__dlygate4sd3_1
Xhold235 u_pe_array.u_fifo2.buffer\[5\]\[9\] VGND VGND VPWR VPWR net311 sky130_fd_sc_hd__dlygate4sd3_1
Xhold224 u_pe_array.u_fifo2.buffer\[0\]\[8\] VGND VGND VPWR VPWR net300 sky130_fd_sc_hd__dlygate4sd3_1
XFILLER_0_111_553 VGND VGND VPWR VPWR sky130_fd_sc_hd__decap_6
X_7243_ clknet_leaf_39_clk _0306_ net813 VGND VGND VPWR VPWR u_pe_array.g_pe_row\[1\].g_pe_col\[0\].u_pe.act_val\[2\]
+ sky130_fd_sc_hd__dfrtp_1
Xhold246 u_pe_array.g_pe_row\[1\].g_pe_col\[1\].u_pe.psum_out\[11\] VGND VGND VPWR
+ VPWR net322 sky130_fd_sc_hd__dlygate4sd3_1
XFILLER_0_13_389 VGND VGND VPWR VPWR sky130_fd_sc_hd__decap_3
Xhold268 u_pe_array.u_fifo2.buffer\[3\]\[10\] VGND VGND VPWR VPWR net344 sky130_fd_sc_hd__dlygate4sd3_1
X_4455_ _1273_ _1531_ _1533_ _1534_ net403 VGND VGND VPWR VPWR _0164_ sky130_fd_sc_hd__a32o_1
Xhold257 u_pe_array.g_pe_row\[2\].g_pe_col\[3\].u_pe.psum_out\[11\] VGND VGND VPWR
+ VPWR net333 sky130_fd_sc_hd__dlygate4sd3_1
XFILLER_0_111_597 VPWR VGND VPWR VGND sky130_ef_sc_hd__decap_12
X_7174_ clknet_leaf_41_clk _0241_ net813 VGND VGND VPWR VPWR u_pe_array.g_pe_row\[2\].g_pe_col\[0\].u_pe.psum_out\[8\]
+ sky130_fd_sc_hd__dfrtp_2
Xhold279 u_pe_array.u_fifo2.buffer\[6\]\[6\] VGND VGND VPWR VPWR net355 sky130_fd_sc_hd__dlygate4sd3_1
X_4386_ _1484_ _1485_ VGND VGND VPWR VPWR _1486_ sky130_fd_sc_hd__or2_1
XFILLER_0_40_197 VGND VGND VPWR VPWR sky130_fd_sc_hd__fill_2
X_6125_ _2910_ _2920_ _2921_ VGND VGND VPWR VPWR _2934_ sky130_fd_sc_hd__o21a_1
XTAP_540 VGND VPWR sky130_fd_sc_hd__tapvpwrvgnd_1
XTAP_551 VGND VPWR sky130_fd_sc_hd__tapvpwrvgnd_1
XFILLER_0_99_109 VGND VGND VPWR VPWR sky130_fd_sc_hd__decap_3
XTAP_573 VGND VPWR sky130_fd_sc_hd__tapvpwrvgnd_1
XTAP_562 VGND VPWR sky130_fd_sc_hd__tapvpwrvgnd_1
XTAP_584 VGND VPWR sky130_fd_sc_hd__tapvpwrvgnd_1
X_6056_ _2870_ VGND VGND VPWR VPWR _2871_ sky130_fd_sc_hd__inv_2
XTAP_595 VGND VPWR sky130_fd_sc_hd__tapvpwrvgnd_1
XANTENNA__4683__A _1672_ VGND VGND VPWR VPWR sky130_fd_sc_hd__diode_2
X_5007_ u_pe_array.u_fifo2.buffer\[6\]\[3\] _1964_ _1997_ _1999_ VGND VGND VPWR VPWR
+ _2000_ sky130_fd_sc_hd__a211o_1
XFILLER_0_68_507 VGND VGND VPWR VPWR sky130_fd_sc_hd__fill_2
XFILLER_0_95_337 VGND VGND VPWR VPWR sky130_fd_sc_hd__decap_8
XFILLER_0_72_80 VGND VGND VPWR VPWR sky130_fd_sc_hd__fill_1
X_6958_ clknet_leaf_17_clk _0039_ net816 VGND VGND VPWR VPWR u_pe_array.g_pe_row\[3\].g_pe_col\[1\].u_pe.act_val\[0\]
+ sky130_fd_sc_hd__dfrtp_2
X_6889_ _3428_ VGND VGND VPWR VPWR _0704_ sky130_fd_sc_hd__clkbuf_1
XFILLER_0_48_286 VGND VGND VPWR VPWR sky130_fd_sc_hd__fill_2
X_5909_ u_pe_array.g_pe_row\[0\].g_pe_col\[2\].u_pe.act_val\[2\] u_pe_array.g_pe_row\[0\].g_pe_col\[2\].u_pe.w_reg\[0\]
+ VGND VGND VPWR VPWR _2750_ sky130_fd_sc_hd__nand2_1
XFILLER_0_63_245 VPWR VGND VPWR VGND sky130_ef_sc_hd__decap_12
XFILLER_0_63_234 VGND VGND VPWR VPWR sky130_fd_sc_hd__decap_3
XFILLER_0_17_673 VGND VGND VPWR VPWR sky130_fd_sc_hd__decap_4
XANTENNA__5019__A _1787_ VGND VGND VPWR VPWR sky130_fd_sc_hd__diode_2
XFILLER_0_114_380 VPWR VGND VPWR VGND sky130_ef_sc_hd__decap_12
XFILLER_0_31_164 VGND VGND VPWR VPWR sky130_fd_sc_hd__fill_2
XANTENNA__6549__S _3239_ VGND VGND VPWR VPWR sky130_fd_sc_hd__diode_2
XFILLER_0_102_575 VGND VGND VPWR VPWR sky130_fd_sc_hd__decap_8
XANTENNA_hold671_A u_pe_array.g_pe_row\[3\].g_pe_col\[3\].u_pe.act_val\[5\] VGND VGND
+ VPWR VPWR sky130_fd_sc_hd__diode_2
XFILLER_0_6_3 VPWR VGND VPWR VGND sky130_ef_sc_hd__decap_12
XFILLER_0_31_197 VGND VGND VPWR VPWR sky130_fd_sc_hd__fill_1
XANTENNA__3701__B2 _0916_ VGND VGND VPWR VPWR sky130_fd_sc_hd__diode_2
XANTENNA_input20_A v_in0[5] VGND VGND VPWR VPWR sky130_fd_sc_hd__diode_2
XANTENNA__5454__A1 _2345_ VGND VGND VPWR VPWR sky130_fd_sc_hd__diode_2
XANTENNA__5454__B2 u_pe_array.g_pe_row\[1\].g_pe_col\[1\].u_pe.w_reg\[0\] VGND VGND
+ VPWR VPWR sky130_fd_sc_hd__diode_2
XFILLER_0_109_130 VGND VGND VPWR VPWR sky130_fd_sc_hd__decap_4
XFILLER_0_6_309 VGND VGND VPWR VPWR sky130_fd_sc_hd__decap_4
XFILLER_0_42_429 VGND VGND VPWR VPWR sky130_fd_sc_hd__fill_2
XFILLER_0_35_470 VGND VGND VPWR VPWR sky130_fd_sc_hd__fill_2
XFILLER_0_50_473 VGND VGND VPWR VPWR sky130_fd_sc_hd__decap_3
XANTENNA__7376__RESET_B net812 VGND VGND VPWR VPWR sky130_fd_sc_hd__diode_2
X_4240_ _1365_ VGND VGND VPWR VPWR _1366_ sky130_fd_sc_hd__inv_2
XFILLER_0_22_197 VGND VGND VPWR VPWR sky130_fd_sc_hd__fill_2
X_4171_ _1292_ _1303_ VGND VGND VPWR VPWR _1304_ sky130_fd_sc_hd__xnor2_1
XANTENNA__7305__RESET_B net814 VGND VGND VPWR VPWR sky130_fd_sc_hd__diode_2
XFILLER_0_93_57 VGND VGND VPWR VPWR sky130_fd_sc_hd__decap_8
XANTENNA__3611__S _0755_ VGND VGND VPWR VPWR sky130_fd_sc_hd__diode_2
XFILLER_0_26_51 VGND VGND VPWR VPWR sky130_fd_sc_hd__fill_1
X_6812_ net557 _3118_ _3382_ VGND VGND VPWR VPWR _3387_ sky130_fd_sc_hd__mux2_1
XFILLER_0_77_337 VGND VGND VPWR VPWR sky130_fd_sc_hd__decap_3
XANTENNA__6940__RESET_B net74 VGND VGND VPWR VPWR sky130_fd_sc_hd__diode_2
X_6743_ net327 _3132_ net64 VGND VGND VPWR VPWR _3350_ sky130_fd_sc_hd__mux2_1
XFILLER_0_85_381 VGND VGND VPWR VPWR sky130_fd_sc_hd__decap_4
X_3955_ net18 _1128_ _0819_ VGND VGND VPWR VPWR _1129_ sky130_fd_sc_hd__mux2_1
XANTENNA__6158__C1 _2873_ VGND VGND VPWR VPWR sky130_fd_sc_hd__diode_2
XFILLER_0_73_554 VGND VGND VPWR VPWR sky130_fd_sc_hd__fill_2
XFILLER_0_73_532 VGND VGND VPWR VPWR sky130_fd_sc_hd__fill_2
X_6674_ u_pe_array.u_fifo1.rd_ptr\[2\] _3308_ VGND VGND VPWR VPWR _3310_ sky130_fd_sc_hd__and2_1
XFILLER_0_9_169 VGND VGND VPWR VPWR sky130_fd_sc_hd__fill_2
XFILLER_0_73_587 VGND VGND VPWR VPWR sky130_fd_sc_hd__decap_4
X_5625_ _2518_ _2519_ VGND VGND VPWR VPWR _2520_ sky130_fd_sc_hd__nand2_1
X_3886_ _1070_ _1071_ VGND VGND VPWR VPWR _1072_ sky130_fd_sc_hd__xnor2_1
XFILLER_0_60_215 VGND VGND VPWR VPWR sky130_fd_sc_hd__fill_2
XFILLER_0_33_429 VGND VGND VPWR VPWR sky130_fd_sc_hd__fill_2
XFILLER_0_5_397 VGND VGND VPWR VPWR sky130_fd_sc_hd__fill_2
X_5556_ u_pe_array.g_pe_row\[1\].g_pe_col\[3\].u_pe.psum_out\[3\] u_pe_array.g_pe_row\[1\].g_pe_col\[3\].u_pe.act_val\[3\]
+ _0769_ VGND VGND VPWR VPWR _2465_ sky130_fd_sc_hd__mux2_1
X_5487_ _2385_ _2395_ VGND VGND VPWR VPWR _2408_ sky130_fd_sc_hd__and2_1
X_4507_ u_pe_array.g_pe_row\[2\].g_pe_col\[2\].u_pe.psum_out\[4\] _1568_ _1569_ VGND
+ VGND VPWR VPWR _1582_ sky130_fd_sc_hd__a21boi_1
XFILLER_0_13_186 VGND VGND VPWR VPWR sky130_fd_sc_hd__decap_4
XFILLER_0_111_361 VGND VGND VPWR VPWR sky130_fd_sc_hd__decap_3
X_4438_ _0832_ VGND VGND VPWR VPWR _1524_ sky130_fd_sc_hd__clkbuf_8
X_7226_ clknet_leaf_61_clk _0289_ net73 VGND VGND VPWR VPWR u_pe_array.g_pe_row\[1\].g_pe_col\[2\].u_pe.psum_out\[0\]
+ sky130_fd_sc_hd__dfrtp_1
XFILLER_0_6_83 VGND VGND VPWR VPWR sky130_fd_sc_hd__fill_1
XANTENNA__7046__RESET_B net815 VGND VGND VPWR VPWR sky130_fd_sc_hd__diode_2
XFILLER_0_1_581 VPWR VGND VPWR VGND sky130_ef_sc_hd__decap_12
X_4369_ net544 _1152_ _1468_ _1470_ VGND VGND VPWR VPWR _0142_ sky130_fd_sc_hd__a22o_1
X_7157_ clknet_leaf_68_clk _0226_ net814 VGND VGND VPWR VPWR u_pe_array.g_pe_row\[1\].g_pe_col\[3\].u_pe.move_reg\[6\]
+ sky130_fd_sc_hd__dfrtp_1
X_6108_ u_pe_array.g_pe_row\[0\].g_pe_col\[1\].u_pe.psum_out\[5\] _2917_ VGND VGND
+ VPWR VPWR _2918_ sky130_fd_sc_hd__xnor2_1
X_7088_ clknet_leaf_13_clk net194 net816 VGND VGND VPWR VPWR u_pe_array.g_pe_row\[2\].g_pe_col\[1\].u_pe.move_reg\[10\]
+ sky130_fd_sc_hd__dfrtp_1
XANTENNA__6633__A0 _0992_ VGND VGND VPWR VPWR sky130_fd_sc_hd__diode_2
XTAP_392 VGND VPWR sky130_fd_sc_hd__tapvpwrvgnd_1
XTAP_381 VGND VPWR sky130_fd_sc_hd__tapvpwrvgnd_1
XTAP_370 VGND VPWR sky130_fd_sc_hd__tapvpwrvgnd_1
X_6039_ net588 _2738_ _2592_ _2861_ VGND VGND VPWR VPWR _0421_ sky130_fd_sc_hd__a22o_1
XFILLER_0_96_613 VGND VGND VPWR VPWR sky130_fd_sc_hd__decap_8
XTAP_1503 VGND VPWR sky130_fd_sc_hd__tapvpwrvgnd_1
XTAP_1514 VGND VPWR sky130_fd_sc_hd__tapvpwrvgnd_1
XPHY_21 VGND VGND VPWR VPWR sky130_fd_sc_hd__decap_3
XPHY_10 VGND VGND VPWR VPWR sky130_fd_sc_hd__decap_3
XTAP_1547 VGND VPWR sky130_fd_sc_hd__tapvpwrvgnd_1
XTAP_1536 VGND VPWR sky130_fd_sc_hd__tapvpwrvgnd_1
XTAP_1525 VGND VPWR sky130_fd_sc_hd__tapvpwrvgnd_1
XANTENNA__6832__S _3397_ VGND VGND VPWR VPWR sky130_fd_sc_hd__diode_2
XFILLER_0_68_359 VGND VGND VPWR VPWR sky130_fd_sc_hd__decap_4
XPHY_32 VGND VGND VPWR VPWR sky130_fd_sc_hd__decap_3
XPHY_43 VGND VGND VPWR VPWR sky130_fd_sc_hd__decap_3
XPHY_54 VGND VGND VPWR VPWR sky130_fd_sc_hd__decap_3
XPHY_65 VGND VGND VPWR VPWR sky130_fd_sc_hd__decap_3
XTAP_1569 VGND VPWR sky130_fd_sc_hd__tapvpwrvgnd_1
XTAP_1558 VGND VPWR sky130_fd_sc_hd__tapvpwrvgnd_1
XFILLER_0_83_318 VGND VGND VPWR VPWR sky130_fd_sc_hd__fill_2
XPHY_98 VGND VGND VPWR VPWR sky130_fd_sc_hd__decap_3
XPHY_87 VGND VGND VPWR VPWR sky130_fd_sc_hd__decap_3
XPHY_76 VGND VGND VPWR VPWR sky130_fd_sc_hd__decap_3
XFILLER_0_64_587 VGND VGND VPWR VPWR sky130_fd_sc_hd__fill_1
XFILLER_0_24_418 VGND VGND VPWR VPWR sky130_fd_sc_hd__fill_2
XFILLER_0_36_278 VGND VGND VPWR VPWR sky130_fd_sc_hd__fill_2
XANTENNA__4175__A1 _1275_ VGND VGND VPWR VPWR sky130_fd_sc_hd__diode_2
XFILLER_0_17_492 VGND VGND VPWR VPWR sky130_fd_sc_hd__fill_1
XFILLER_0_24_429 VGND VGND VPWR VPWR sky130_fd_sc_hd__fill_2
XFILLER_0_106_166 VGND VGND VPWR VPWR sky130_fd_sc_hd__fill_1
XANTENNA__4175__B2 u_pe_array.g_pe_row\[3\].g_pe_col\[0\].u_pe.w_reg\[0\] VGND VGND
+ VPWR VPWR sky130_fd_sc_hd__diode_2
XANTENNA__5183__S _0747_ VGND VGND VPWR VPWR sky130_fd_sc_hd__diode_2
XFILLER_0_32_473 VGND VGND VPWR VPWR sky130_fd_sc_hd__decap_3
XANTENNA__3492__A _0747_ VGND VGND VPWR VPWR sky130_fd_sc_hd__diode_2
XFILLER_0_99_462 VGND VGND VPWR VPWR sky130_fd_sc_hd__fill_2
XANTENNA__3989__A1 _0864_ VGND VGND VPWR VPWR sky130_fd_sc_hd__diode_2
XFILLER_0_63_27 VPWR VGND VPWR VGND sky130_ef_sc_hd__decap_12
XFILLER_0_87_635 VGND VGND VPWR VPWR sky130_fd_sc_hd__fill_2
XFILLER_0_59_337 VGND VGND VPWR VPWR sky130_fd_sc_hd__decap_4
XFILLER_0_74_318 VGND VGND VPWR VPWR sky130_fd_sc_hd__decap_4
XFILLER_0_27_201 VGND VGND VPWR VPWR sky130_fd_sc_hd__fill_2
XFILLER_0_7_629 VPWR VGND VPWR VGND sky130_ef_sc_hd__decap_12
X_3740_ u_pe_array.g_pe_row\[3\].g_pe_col\[3\].u_pe.psum_out\[8\] _0869_ VGND VGND
+ VPWR VPWR _0952_ sky130_fd_sc_hd__or2_1
XFILLER_0_103_55 VGND VGND VPWR VPWR sky130_fd_sc_hd__fill_1
XFILLER_0_12_53 VGND VGND VPWR VPWR sky130_fd_sc_hd__fill_1
XFILLER_0_6_139 VGND VGND VPWR VPWR sky130_fd_sc_hd__fill_1
XANTENNA__3610__B1 _0837_ VGND VGND VPWR VPWR sky130_fd_sc_hd__diode_2
XFILLER_0_42_204 VGND VGND VPWR VPWR sky130_fd_sc_hd__fill_2
X_3671_ _0878_ _0882_ VGND VGND VPWR VPWR _0888_ sky130_fd_sc_hd__nor2_1
XFILLER_0_113_615 VGND VGND VPWR VPWR sky130_fd_sc_hd__fill_1
X_5410_ u_pe_array.g_pe_row\[0\].g_pe_col\[0\].u_pe.psum_out\[11\] u_pe_array.g_pe_row\[0\].g_pe_col\[0\].u_pe.move_reg\[11\]
+ _1661_ VGND VGND VPWR VPWR _2339_ sky130_fd_sc_hd__mux2_1
XFILLER_0_70_568 VGND VGND VPWR VPWR sky130_fd_sc_hd__fill_2
XFILLER_0_70_557 VGND VGND VPWR VPWR sky130_fd_sc_hd__fill_2
XANTENNA__7557__RESET_B net816 VGND VGND VPWR VPWR sky130_fd_sc_hd__diode_2
X_6390_ _3152_ _3153_ VGND VGND VPWR VPWR _3154_ sky130_fd_sc_hd__or2_1
XFILLER_0_2_323 VGND VGND VPWR VPWR sky130_fd_sc_hd__decap_4
XANTENNA__5902__A2 _2743_ VGND VGND VPWR VPWR sky130_fd_sc_hd__diode_2
XFILLER_0_112_125 VGND VGND VPWR VPWR sky130_fd_sc_hd__fill_2
XFILLER_0_88_57 VGND VGND VPWR VPWR sky130_fd_sc_hd__fill_2
X_5341_ u_pe_array.u_fifo1.buffer\[4\]\[0\] _2279_ _2280_ u_pe_array.u_fifo1.buffer\[7\]\[0\]
+ VGND VGND VPWR VPWR _2281_ sky130_fd_sc_hd__a22o_1
XFILLER_0_11_613 VGND VGND VPWR VPWR sky130_fd_sc_hd__decap_3
XANTENNA_clkbuf_leaf_71_clk_A clknet_3_5__leaf_clk VGND VGND VPWR VPWR sky130_fd_sc_hd__diode_2
XFILLER_0_23_473 VGND VGND VPWR VPWR sky130_fd_sc_hd__fill_2
XFILLER_0_100_309 VGND VGND VPWR VPWR sky130_fd_sc_hd__decap_3
XANTENNA__3606__S _0819_ VGND VGND VPWR VPWR sky130_fd_sc_hd__diode_2
X_5272_ _2218_ _2219_ _2217_ VGND VGND VPWR VPWR _2221_ sky130_fd_sc_hd__o21a_1
X_7011_ clknet_leaf_12_clk _0088_ net818 VGND VGND VPWR VPWR u_pe_array.g_pe_row\[3\].g_pe_col\[1\].u_pe.psum_out\[8\]
+ sky130_fd_sc_hd__dfrtp_2
X_4223_ _1275_ u_pe_array.g_pe_row\[3\].g_pe_col\[0\].u_pe.psum_out\[8\] VGND VGND
+ VPWR VPWR _1351_ sky130_fd_sc_hd__nand2_1
X_4154_ _1283_ _1287_ VGND VGND VPWR VPWR _1288_ sky130_fd_sc_hd__xor2_1
XANTENNA_clkbuf_leaf_86_clk_A clknet_3_1__leaf_clk VGND VGND VPWR VPWR sky130_fd_sc_hd__diode_2
X_4085_ _1228_ _1236_ _1237_ VGND VGND VPWR VPWR _1239_ sky130_fd_sc_hd__and3_1
XFILLER_0_53_71 VGND VGND VPWR VPWR sky130_fd_sc_hd__fill_2
XFILLER_0_77_178 VGND VGND VPWR VPWR sky130_fd_sc_hd__fill_2
XFILLER_0_77_167 VGND VGND VPWR VPWR sky130_fd_sc_hd__fill_1
XFILLER_0_108_409 VGND VGND VPWR VPWR sky130_fd_sc_hd__fill_2
XANTENNA_clkbuf_leaf_24_clk_A clknet_3_2__leaf_clk VGND VGND VPWR VPWR sky130_fd_sc_hd__diode_2
X_6726_ _3341_ VGND VGND VPWR VPWR _0628_ sky130_fd_sc_hd__clkbuf_1
X_4987_ u_pe_array.u_fifo2.buffer\[5\]\[1\] _1971_ _1972_ u_pe_array.u_fifo2.buffer\[1\]\[1\]
+ _1973_ VGND VGND VPWR VPWR _1982_ sky130_fd_sc_hd__a221o_1
XFILLER_0_61_502 VGND VGND VPWR VPWR sky130_fd_sc_hd__fill_2
XFILLER_0_46_587 VGND VGND VPWR VPWR sky130_fd_sc_hd__fill_1
X_3938_ u_pe_array.g_pe_row\[3\].g_pe_col\[2\].u_pe.psum_out\[12\] _1111_ VGND VGND
+ VPWR VPWR _1118_ sky130_fd_sc_hd__xnor2_1
XFILLER_0_73_384 VGND VGND VPWR VPWR sky130_fd_sc_hd__fill_2
X_6657_ _3299_ VGND VGND VPWR VPWR _0601_ sky130_fd_sc_hd__clkbuf_1
XFILLER_0_46_598 VGND VGND VPWR VPWR sky130_fd_sc_hd__fill_2
X_3869_ _1053_ _1055_ VGND VGND VPWR VPWR _1056_ sky130_fd_sc_hd__xor2_1
XANTENNA__7298__RESET_B net813 VGND VGND VPWR VPWR sky130_fd_sc_hd__diode_2
X_5608_ _2496_ _2497_ _2503_ VGND VGND VPWR VPWR _2504_ sky130_fd_sc_hd__nor3_1
XFILLER_0_61_557 VGND VGND VPWR VPWR sky130_fd_sc_hd__decap_3
X_6588_ _3262_ VGND VGND VPWR VPWR _0569_ sky130_fd_sc_hd__clkbuf_1
XFILLER_0_5_161 VGND VGND VPWR VPWR sky130_fd_sc_hd__decap_6
XFILLER_0_103_136 VGND VGND VPWR VPWR sky130_fd_sc_hd__fill_2
XANTENNA_clkbuf_leaf_39_clk_A clknet_3_6__leaf_clk VGND VGND VPWR VPWR sky130_fd_sc_hd__diode_2
X_5539_ _2258_ _2453_ _2454_ _2071_ net322 VGND VGND VPWR VPWR _0328_ sky130_fd_sc_hd__a32o_1
XANTENNA__7227__RESET_B net73 VGND VGND VPWR VPWR sky130_fd_sc_hd__diode_2
XANTENNA__3668__B1 _0885_ VGND VGND VPWR VPWR sky130_fd_sc_hd__diode_2
X_7209_ clknet_leaf_80_clk _0274_ net815 VGND VGND VPWR VPWR u_pe_array.g_pe_row\[1\].g_pe_col\[2\].u_pe.w_buffer\[0\]
+ sky130_fd_sc_hd__dfrtp_1
XANTENNA__5409__B2 _2336_ VGND VGND VPWR VPWR sky130_fd_sc_hd__diode_2
XFILLER_0_96_421 VGND VGND VPWR VPWR sky130_fd_sc_hd__fill_2
XFILLER_0_96_410 VGND VGND VPWR VPWR sky130_fd_sc_hd__fill_1
XTAP_1322 VGND VPWR sky130_fd_sc_hd__tapvpwrvgnd_1
XTAP_1311 VGND VPWR sky130_fd_sc_hd__tapvpwrvgnd_1
XTAP_1300 VGND VPWR sky130_fd_sc_hd__tapvpwrvgnd_1
XFILLER_0_68_123 VGND VGND VPWR VPWR sky130_fd_sc_hd__fill_1
XTAP_1355 VGND VPWR sky130_fd_sc_hd__tapvpwrvgnd_1
XTAP_1366 VGND VPWR sky130_fd_sc_hd__tapvpwrvgnd_1
XTAP_1344 VGND VPWR sky130_fd_sc_hd__tapvpwrvgnd_1
XTAP_1333 VGND VPWR sky130_fd_sc_hd__tapvpwrvgnd_1
XANTENNA__5686__B _2478_ VGND VGND VPWR VPWR sky130_fd_sc_hd__diode_2
XTAP_1399 VGND VPWR sky130_fd_sc_hd__tapvpwrvgnd_1
XTAP_1388 VGND VPWR sky130_fd_sc_hd__tapvpwrvgnd_1
XTAP_1377 VGND VPWR sky130_fd_sc_hd__tapvpwrvgnd_1
XANTENNA__5178__S _0747_ VGND VGND VPWR VPWR sky130_fd_sc_hd__diode_2
XANTENNA__4396__A1 _1273_ VGND VGND VPWR VPWR sky130_fd_sc_hd__diode_2
XANTENNA__5593__B1 _2478_ VGND VGND VPWR VPWR sky130_fd_sc_hd__diode_2
XFILLER_0_52_502 VGND VGND VPWR VPWR sky130_fd_sc_hd__fill_2
Xinput28 w_in_flat[1] VGND VGND VPWR VPWR net28 sky130_fd_sc_hd__buf_1
Xinput17 v_in0[2] VGND VGND VPWR VPWR net17 sky130_fd_sc_hd__clkbuf_2
XFILLER_0_52_579 VGND VGND VPWR VPWR sky130_fd_sc_hd__fill_2
XFILLER_0_24_248 VGND VGND VPWR VPWR sky130_fd_sc_hd__fill_2
XANTENNA__4810__S _0754_ VGND VGND VPWR VPWR sky130_fd_sc_hd__diode_2
XANTENNA__5896__B2 _0722_ VGND VGND VPWR VPWR sky130_fd_sc_hd__diode_2
XFILLER_0_58_27 VGND VGND VPWR VPWR sky130_fd_sc_hd__fill_1
XFILLER_0_20_421 VGND VGND VPWR VPWR sky130_fd_sc_hd__fill_2
XFILLER_0_20_443 VGND VGND VPWR VPWR sky130_fd_sc_hd__fill_2
XFILLER_0_102_180 VGND VGND VPWR VPWR sky130_fd_sc_hd__decap_3
XANTENNA__4111__A _0836_ VGND VGND VPWR VPWR sky130_fd_sc_hd__diode_2
XFILLER_0_74_15 VGND VGND VPWR VPWR sky130_fd_sc_hd__decap_8
XANTENNA_output51_A net51 VGND VGND VPWR VPWR sky130_fd_sc_hd__diode_2
XFILLER_0_99_281 VGND VGND VPWR VPWR sky130_fd_sc_hd__fill_2
X_4910_ _1912_ _1913_ VGND VGND VPWR VPWR _1914_ sky130_fd_sc_hd__and2_1
X_5890_ u_pe_array.g_pe_row\[1\].g_pe_col\[1\].u_pe.psum_out\[10\] u_pe_array.g_pe_row\[1\].g_pe_col\[1\].u_pe.move_reg\[10\]
+ _2469_ VGND VGND VPWR VPWR _2736_ sky130_fd_sc_hd__mux2_1
XFILLER_0_59_145 VGND VGND VPWR VPWR sky130_fd_sc_hd__fill_2
XANTENNA__3831__B1 _1009_ VGND VGND VPWR VPWR sky130_fd_sc_hd__diode_2
X_4841_ u_pe_array.g_pe_row\[2\].g_pe_col\[0\].u_pe.psum_out\[1\] _1850_ VGND VGND
+ VPWR VPWR _1851_ sky130_fd_sc_hd__or2_1
XFILLER_0_90_47 VGND VGND VPWR VPWR sky130_fd_sc_hd__fill_1
XFILLER_0_23_52 VGND VGND VPWR VPWR sky130_fd_sc_hd__decap_4
X_7560_ clknet_leaf_18_clk _0609_ net816 VGND VGND VPWR VPWR u_pe_array.u_fifo1.count\[0\]
+ sky130_fd_sc_hd__dfrtp_2
X_4772_ _1787_ _0848_ _0997_ _0747_ VGND VGND VPWR VPWR _1806_ sky130_fd_sc_hd__a22o_2
XFILLER_0_82_170 VGND VGND VPWR VPWR sky130_fd_sc_hd__fill_1
XFILLER_0_43_513 VGND VGND VPWR VPWR sky130_fd_sc_hd__fill_2
X_6511_ _3220_ VGND VGND VPWR VPWR _0534_ sky130_fd_sc_hd__clkbuf_1
XFILLER_0_15_215 VGND VGND VPWR VPWR sky130_fd_sc_hd__fill_1
X_3723_ _0934_ _0935_ _0933_ VGND VGND VPWR VPWR _0937_ sky130_fd_sc_hd__o21a_1
X_7491_ clknet_leaf_2_clk _0540_ VGND VGND VPWR VPWR u_pe_array.u_fifo2.buffer\[4\]\[4\]
+ sky130_fd_sc_hd__dfxtp_1
XFILLER_0_28_587 VGND VGND VPWR VPWR sky130_fd_sc_hd__fill_1
XANTENNA__7391__RESET_B net818 VGND VGND VPWR VPWR sky130_fd_sc_hd__diode_2
XFILLER_0_43_568 VGND VGND VPWR VPWR sky130_fd_sc_hd__decap_8
X_3654_ u_pe_array.g_pe_row\[3\].g_pe_col\[3\].u_pe.psum_out\[1\] _0872_ VGND VGND
+ VPWR VPWR _0873_ sky130_fd_sc_hd__or2_1
X_6442_ net452 _1804_ net68 VGND VGND VPWR VPWR _3185_ sky130_fd_sc_hd__mux2_1
XANTENNA__5887__B2 _0722_ VGND VGND VPWR VPWR sky130_fd_sc_hd__diode_2
XFILLER_0_43_579 VGND VGND VPWR VPWR sky130_fd_sc_hd__decap_6
XANTENNA__7320__RESET_B net814 VGND VGND VPWR VPWR sky130_fd_sc_hd__diode_2
X_6373_ _1792_ u_pe_array.u_fifo2.wr_ptr\[1\] _3136_ u_pe_array.u_fifo2.wr_ptr\[2\]
+ VGND VGND VPWR VPWR _3143_ sky130_fd_sc_hd__a31o_1
X_3585_ _0821_ _0822_ VGND VGND VPWR VPWR _0006_ sky130_fd_sc_hd__nor2_1
XFILLER_0_3_665 VGND VGND VPWR VPWR sky130_fd_sc_hd__decap_6
XFILLER_0_2_153 VPWR VGND VPWR VGND sky130_ef_sc_hd__decap_12
XFILLER_0_23_281 VGND VGND VPWR VPWR sky130_fd_sc_hd__decap_3
XFILLER_0_23_292 VGND VGND VPWR VPWR sky130_fd_sc_hd__fill_2
XANTENNA__3898__B1 _0867_ VGND VGND VPWR VPWR sky130_fd_sc_hd__diode_2
XFILLER_0_100_139 VGND VGND VPWR VPWR sky130_fd_sc_hd__fill_1
X_5324_ u_pe_array.g_pe_row\[1\].g_pe_col\[2\].u_pe.psum_out\[12\] _2259_ VGND VGND
+ VPWR VPWR _2267_ sky130_fd_sc_hd__xnor2_1
XFILLER_0_2_197 VPWR VGND VPWR VGND sky130_ef_sc_hd__decap_12
X_5255_ u_pe_array.g_pe_row\[1\].g_pe_col\[2\].u_pe.psum_out\[4\] _2191_ _2192_ VGND
+ VGND VPWR VPWR _2205_ sky130_fd_sc_hd__a21boi_1
XANTENNA__5551__S _0770_ VGND VGND VPWR VPWR sky130_fd_sc_hd__diode_2
X_4206_ _1312_ _1322_ _1323_ VGND VGND VPWR VPWR _1336_ sky130_fd_sc_hd__o21a_1
XFILLER_0_47_3 VGND VGND VPWR VPWR sky130_fd_sc_hd__decap_3
X_5186_ net381 _2144_ _2147_ _1665_ VGND VGND VPWR VPWR _0282_ sky130_fd_sc_hd__a22o_1
XFILLER_0_97_207 VGND VGND VPWR VPWR sky130_fd_sc_hd__fill_2
X_4137_ _0864_ _1270_ _1272_ _1144_ net378 VGND VGND VPWR VPWR _0108_ sky130_fd_sc_hd__a32o_1
XFILLER_0_3_51 VGND VGND VPWR VPWR sky130_fd_sc_hd__decap_4
XANTENNA__4149__B1_N _1275_ VGND VGND VPWR VPWR sky130_fd_sc_hd__diode_2
X_4068_ u_pe_array.g_pe_row\[3\].g_pe_col\[1\].u_pe.psum_out\[8\] u_pe_array.g_pe_row\[3\].g_pe_col\[1\].u_pe.psum_out\[7\]
+ _1145_ VGND VGND VPWR VPWR _1224_ sky130_fd_sc_hd__and3b_1
XFILLER_0_78_432 VGND VGND VPWR VPWR sky130_fd_sc_hd__fill_2
Xwire63 _3352_ VGND VGND VPWR VPWR net63 sky130_fd_sc_hd__buf_2
XFILLER_0_93_402 VGND VGND VPWR VPWR sky130_fd_sc_hd__fill_2
XFILLER_0_38_307 VGND VGND VPWR VPWR sky130_fd_sc_hd__fill_1
XFILLER_0_38_329 VGND VGND VPWR VPWR sky130_fd_sc_hd__fill_2
XFILLER_0_93_479 VGND VGND VPWR VPWR sky130_fd_sc_hd__fill_2
XFILLER_0_80_107 VGND VGND VPWR VPWR sky130_fd_sc_hd__fill_1
XFILLER_0_65_159 VGND VGND VPWR VPWR sky130_fd_sc_hd__fill_1
XFILLER_0_46_351 VGND VGND VPWR VPWR sky130_fd_sc_hd__fill_2
XFILLER_0_34_502 VGND VGND VPWR VPWR sky130_fd_sc_hd__decap_8
X_6709_ _3332_ VGND VGND VPWR VPWR _0620_ sky130_fd_sc_hd__clkbuf_1
XANTENNA__7408__RESET_B net817 VGND VGND VPWR VPWR sky130_fd_sc_hd__diode_2
XFILLER_0_46_362 VGND VGND VPWR VPWR sky130_fd_sc_hd__fill_2
XANTENNA__5726__S _2469_ VGND VGND VPWR VPWR sky130_fd_sc_hd__diode_2
XANTENNA__7061__RESET_B net815 VGND VGND VPWR VPWR sky130_fd_sc_hd__diode_2
XFILLER_0_104_467 VGND VGND VPWR VPWR sky130_fd_sc_hd__decap_4
XANTENNA__6557__S _3239_ VGND VGND VPWR VPWR sky130_fd_sc_hd__diode_2
XFILLER_0_69_432 VGND VGND VPWR VPWR sky130_fd_sc_hd__decap_6
XANTENNA__5802__A1 _2611_ VGND VGND VPWR VPWR sky130_fd_sc_hd__diode_2
XTAP_1141 VGND VPWR sky130_fd_sc_hd__tapvpwrvgnd_1
XTAP_1130 VGND VPWR sky130_fd_sc_hd__tapvpwrvgnd_1
XTAP_1174 VGND VPWR sky130_fd_sc_hd__tapvpwrvgnd_1
XTAP_1163 VGND VPWR sky130_fd_sc_hd__tapvpwrvgnd_1
XTAP_1152 VGND VPWR sky130_fd_sc_hd__tapvpwrvgnd_1
XFILLER_0_56_137 VGND VGND VPWR VPWR sky130_fd_sc_hd__decap_3
XTAP_1196 VGND VPWR sky130_fd_sc_hd__tapvpwrvgnd_1
XTAP_1185 VGND VPWR sky130_fd_sc_hd__tapvpwrvgnd_1
XFILLER_0_71_107 VGND VGND VPWR VPWR sky130_fd_sc_hd__decap_4
XFILLER_0_65_660 VGND VGND VPWR VPWR sky130_fd_sc_hd__fill_2
XANTENNA__7149__RESET_B net817 VGND VGND VPWR VPWR sky130_fd_sc_hd__diode_2
XFILLER_0_4_407 VGND VGND VPWR VPWR sky130_fd_sc_hd__fill_2
XFILLER_0_114_209 VPWR VGND VPWR VGND sky130_ef_sc_hd__decap_12
XFILLER_0_64_192 VGND VGND VPWR VPWR sky130_fd_sc_hd__fill_2
XFILLER_0_8_29 VGND VGND VPWR VPWR sky130_fd_sc_hd__decap_4
XFILLER_0_52_365 VGND VGND VPWR VPWR sky130_fd_sc_hd__decap_4
Xhold609 u_pe_array.g_pe_row\[3\].g_pe_col\[2\].u_pe.psum_out\[10\] VGND VGND VPWR
+ VPWR net685 sky130_fd_sc_hd__dlygate4sd3_1
XFILLER_0_40_505 VGND VGND VPWR VPWR sky130_fd_sc_hd__fill_2
XFILLER_0_100_23 VGND VGND VPWR VPWR sky130_fd_sc_hd__decap_4
XFILLER_0_0_613 VGND VGND VPWR VPWR sky130_fd_sc_hd__fill_1
XTAP_925 VGND VPWR sky130_fd_sc_hd__tapvpwrvgnd_1
XTAP_914 VGND VPWR sky130_fd_sc_hd__tapvpwrvgnd_1
XTAP_903 VGND VPWR sky130_fd_sc_hd__tapvpwrvgnd_1
XFILLER_0_0_657 VGND VGND VPWR VPWR sky130_fd_sc_hd__fill_2
XTAP_958 VGND VPWR sky130_fd_sc_hd__tapvpwrvgnd_1
XTAP_947 VGND VPWR sky130_fd_sc_hd__tapvpwrvgnd_1
XTAP_936 VGND VPWR sky130_fd_sc_hd__tapvpwrvgnd_1
X_5040_ u_pe_array.g_pe_row\[0\].g_pe_col\[2\].u_pe.psum_out\[11\] u_pe_array.g_pe_row\[0\].g_pe_col\[2\].u_pe.move_reg\[11\]
+ _1661_ VGND VGND VPWR VPWR _2025_ sky130_fd_sc_hd__mux2_1
XTAP_969 VGND VPWR sky130_fd_sc_hd__tapvpwrvgnd_1
XFILLER_0_18_85 VGND VGND VPWR VPWR sky130_fd_sc_hd__fill_1
X_6991_ clknet_leaf_36_clk _0070_ net76 VGND VGND VPWR VPWR u_pe_array.g_pe_row\[3\].g_pe_col\[0\].u_pe.act_val\[3\]
+ sky130_fd_sc_hd__dfrtp_2
X_5942_ _2779_ _2780_ VGND VGND VPWR VPWR _2781_ sky130_fd_sc_hd__nand2_1
XFILLER_0_87_262 VGND VGND VPWR VPWR sky130_fd_sc_hd__decap_4
XFILLER_0_47_104 VGND VGND VPWR VPWR sky130_fd_sc_hd__fill_2
XFILLER_0_34_51 VGND VGND VPWR VPWR sky130_fd_sc_hd__fill_2
X_5873_ net555 _2600_ _2592_ _2727_ VGND VGND VPWR VPWR _0389_ sky130_fd_sc_hd__a22o_1
XFILLER_0_75_446 VGND VGND VPWR VPWR sky130_fd_sc_hd__fill_2
X_7612_ clknet_leaf_25_clk _0661_ VGND VGND VPWR VPWR u_pe_array.u_fifo1.buffer\[3\]\[9\]
+ sky130_fd_sc_hd__dfxtp_1
XFILLER_0_75_479 VGND VGND VPWR VPWR sky130_fd_sc_hd__decap_3
XFILLER_0_63_608 VGND VGND VPWR VPWR sky130_fd_sc_hd__decap_3
X_4824_ net619 _0833_ VGND VGND VPWR VPWR _1839_ sky130_fd_sc_hd__and2_1
XFILLER_0_28_340 VGND VGND VPWR VPWR sky130_fd_sc_hd__decap_3
XANTENNA__5557__B1 _1655_ VGND VGND VPWR VPWR sky130_fd_sc_hd__diode_2
X_4755_ _1791_ u_pe_array.u_fifo2.wr_ptr\[2\] u_pe_array.u_fifo2.wr_ptr\[3\] _1793_
+ VGND VGND VPWR VPWR _1794_ sky130_fd_sc_hd__or4bb_1
XFILLER_0_16_513 VGND VGND VPWR VPWR sky130_fd_sc_hd__fill_1
X_7543_ clknet_leaf_78_clk _0592_ net815 VGND VGND VPWR VPWR u_pe_array.g_pe_row\[3\].g_pe_col\[3\].u_pe.act_val\[4\]
+ sky130_fd_sc_hd__dfrtp_2
XFILLER_0_43_332 VGND VGND VPWR VPWR sky130_fd_sc_hd__fill_2
XFILLER_0_43_321 VGND VGND VPWR VPWR sky130_fd_sc_hd__decap_3
X_3706_ u_pe_array.g_pe_row\[3\].g_pe_col\[3\].u_pe.psum_out\[4\] _0904_ _0905_ VGND
+ VGND VPWR VPWR _0921_ sky130_fd_sc_hd__a21boi_1
X_4686_ _1727_ _1731_ VGND VGND VPWR VPWR _1732_ sky130_fd_sc_hd__and2b_1
XFILLER_0_31_505 VGND VGND VPWR VPWR sky130_fd_sc_hd__fill_1
X_7474_ clknet_leaf_3_clk _0523_ VGND VGND VPWR VPWR u_pe_array.u_fifo2.buffer\[3\]\[0\]
+ sky130_fd_sc_hd__dfxtp_1
X_6425_ net248 _1814_ net70 VGND VGND VPWR VPWR _3176_ sky130_fd_sc_hd__mux2_1
X_3637_ net183 _0834_ _0857_ u_fsm.psum_shift_en VGND VGND VPWR VPWR _0023_ sky130_fd_sc_hd__a22o_1
X_6356_ _3130_ net362 _3110_ VGND VGND VPWR VPWR _3131_ sky130_fd_sc_hd__mux2_1
X_3568_ _0809_ _0810_ VGND VGND VPWR VPWR _0001_ sky130_fd_sc_hd__nor2_1
X_5307_ u_pe_array.g_pe_row\[1\].g_pe_col\[2\].u_pe.psum_out\[10\] _2158_ VGND VGND
+ VPWR VPWR _2252_ sky130_fd_sc_hd__or2_1
XFILLER_0_59_81 VPWR VGND VPWR VGND sky130_ef_sc_hd__decap_12
X_6287_ _3067_ _3069_ _3070_ _3076_ VGND VGND VPWR VPWR _3077_ sky130_fd_sc_hd__a31oi_2
X_3499_ _0754_ _0759_ VGND VGND VPWR VPWR _0760_ sky130_fd_sc_hd__and2_1
X_5238_ _2176_ _2186_ _2185_ VGND VGND VPWR VPWR _2189_ sky130_fd_sc_hd__a21oi_1
X_5169_ _2138_ VGND VGND VPWR VPWR _0274_ sky130_fd_sc_hd__clkbuf_1
XFILLER_0_98_549 VGND VGND VPWR VPWR sky130_fd_sc_hd__fill_2
XANTENNA__5796__B1 _0885_ VGND VGND VPWR VPWR sky130_fd_sc_hd__diode_2
XPHY_224 VGND VGND VPWR VPWR sky130_fd_sc_hd__decap_3
XPHY_213 VGND VGND VPWR VPWR sky130_fd_sc_hd__decap_3
XPHY_202 VGND VGND VPWR VPWR sky130_fd_sc_hd__decap_3
XFILLER_0_93_210 VGND VGND VPWR VPWR sky130_fd_sc_hd__decap_3
XFILLER_0_66_435 VGND VGND VPWR VPWR sky130_fd_sc_hd__decap_3
XANTENNA__3749__B _0869_ VGND VGND VPWR VPWR sky130_fd_sc_hd__diode_2
XFILLER_0_39_638 VGND VGND VPWR VPWR sky130_fd_sc_hd__fill_2
XANTENNA__6840__S _3397_ VGND VGND VPWR VPWR sky130_fd_sc_hd__diode_2
XANTENNA__7242__RESET_B net813 VGND VGND VPWR VPWR sky130_fd_sc_hd__diode_2
XFILLER_0_53_129 VGND VGND VPWR VPWR sky130_fd_sc_hd__fill_2
XFILLER_0_53_118 VGND VGND VPWR VPWR sky130_fd_sc_hd__fill_2
XANTENNA__3484__B _0730_ VGND VGND VPWR VPWR sky130_fd_sc_hd__diode_2
XFILLER_0_22_505 VGND VGND VPWR VPWR sky130_fd_sc_hd__fill_1
XFILLER_0_39_29 VGND VGND VPWR VPWR sky130_fd_sc_hd__fill_2
XANTENNA__5720__B1 _2592_ VGND VGND VPWR VPWR sky130_fd_sc_hd__diode_2
XANTENNA__5191__S _1661_ VGND VGND VPWR VPWR sky130_fd_sc_hd__diode_2
XFILLER_0_89_505 VGND VGND VPWR VPWR sky130_fd_sc_hd__decap_3
XFILLER_0_55_39 VPWR VGND VPWR VGND sky130_ef_sc_hd__decap_12
Xhold6 u_pe_array.g_pe_row\[3\].g_pe_col\[3\].u_pe.w_buffer\[1\] VGND VGND VPWR VPWR
+ net82 sky130_fd_sc_hd__dlygate4sd3_1
Xclkbuf_leaf_86_clk clknet_3_1__leaf_clk VGND VGND VPWR VPWR clknet_leaf_86_clk sky130_fd_sc_hd__clkbuf_16
XANTENNA__4039__B1 _0914_ VGND VGND VPWR VPWR sky130_fd_sc_hd__diode_2
XFILLER_0_71_27 VGND VGND VPWR VPWR sky130_fd_sc_hd__decap_8
XFILLER_0_69_273 VGND VGND VPWR VPWR sky130_fd_sc_hd__fill_1
XFILLER_0_57_435 VGND VGND VPWR VPWR sky130_fd_sc_hd__fill_2
XFILLER_0_84_265 VGND VGND VPWR VPWR sky130_fd_sc_hd__decap_8
XANTENNA__5539__B1 _2071_ VGND VGND VPWR VPWR sky130_fd_sc_hd__diode_2
XFILLER_0_57_468 VGND VGND VPWR VPWR sky130_fd_sc_hd__fill_1
XANTENNA__4211__B1 _1144_ VGND VGND VPWR VPWR sky130_fd_sc_hd__diode_2
XFILLER_0_37_181 VGND VGND VPWR VPWR sky130_fd_sc_hd__fill_2
XFILLER_0_111_55 VGND VGND VPWR VPWR sky130_fd_sc_hd__fill_1
XFILLER_0_108_581 VGND VGND VPWR VPWR sky130_fd_sc_hd__decap_6
XFILLER_0_105_3 VPWR VGND VPWR VGND sky130_ef_sc_hd__decap_12
XFILLER_0_80_471 VGND VGND VPWR VPWR sky130_fd_sc_hd__fill_2
Xclkbuf_leaf_10_clk clknet_3_1__leaf_clk VGND VGND VPWR VPWR clknet_leaf_10_clk sky130_fd_sc_hd__clkbuf_16
X_4540_ _1536_ u_pe_array.g_pe_row\[2\].g_pe_col\[2\].u_pe.psum_out\[8\] VGND VGND
+ VPWR VPWR _1612_ sky130_fd_sc_hd__nand2_1
Xhold417 u_pe_array.g_pe_row\[3\].g_pe_col\[0\].u_pe.psum_out\[9\] VGND VGND VPWR
+ VPWR net493 sky130_fd_sc_hd__dlygate4sd3_1
Xhold406 u_pe_array.g_pe_row\[1\].g_pe_col\[1\].u_pe.act_val\[1\] VGND VGND VPWR VPWR
+ net482 sky130_fd_sc_hd__dlygate4sd3_1
XANTENNA__6965__RESET_B net818 VGND VGND VPWR VPWR sky130_fd_sc_hd__diode_2
X_4471_ _1544_ _1548_ VGND VGND VPWR VPWR _1549_ sky130_fd_sc_hd__xor2_1
XFILLER_0_20_64 VGND VGND VPWR VPWR sky130_fd_sc_hd__fill_2
XFILLER_0_110_201 VGND VGND VPWR VPWR sky130_fd_sc_hd__fill_2
X_6210_ _2995_ _2998_ VGND VGND VPWR VPWR _3006_ sky130_fd_sc_hd__and2_1
X_7190_ clknet_leaf_65_clk _0257_ net73 VGND VGND VPWR VPWR u_pe_array.g_pe_row\[1\].g_pe_col\[2\].u_pe.move_reg\[9\]
+ sky130_fd_sc_hd__dfrtp_1
XFILLER_0_0_421 VPWR VGND VPWR VGND sky130_ef_sc_hd__decap_12
Xhold439 u_pe_array.g_pe_row\[1\].g_pe_col\[3\].u_pe.psum_out\[3\] VGND VGND VPWR
+ VPWR net515 sky130_fd_sc_hd__dlygate4sd3_1
Xhold428 u_pe_array.g_pe_row\[0\].g_pe_col\[3\].u_pe.psum_out\[1\] VGND VGND VPWR
+ VPWR net504 sky130_fd_sc_hd__dlygate4sd3_1
X_6141_ _2932_ _2939_ _2947_ VGND VGND VPWR VPWR _2948_ sky130_fd_sc_hd__a21oi_1
XFILLER_0_21_582 VGND VGND VPWR VPWR sky130_fd_sc_hd__fill_2
XTAP_700 VGND VPWR sky130_fd_sc_hd__tapvpwrvgnd_1
XFILLER_0_96_79 VGND VGND VPWR VPWR sky130_fd_sc_hd__fill_1
XANTENNA__3614__S _0755_ VGND VGND VPWR VPWR sky130_fd_sc_hd__diode_2
XFILLER_0_0_487 VPWR VGND VPWR VGND sky130_ef_sc_hd__decap_12
XTAP_722 VGND VPWR sky130_fd_sc_hd__tapvpwrvgnd_1
XTAP_711 VGND VPWR sky130_fd_sc_hd__tapvpwrvgnd_1
XTAP_733 VGND VPWR sky130_fd_sc_hd__tapvpwrvgnd_1
X_6072_ u_pe_array.g_pe_row\[0\].g_pe_col\[1\].u_pe.psum_out\[2\] _2884_ VGND VGND
+ VPWR VPWR _2885_ sky130_fd_sc_hd__xnor2_1
XTAP_777 VGND VPWR sky130_fd_sc_hd__tapvpwrvgnd_1
XTAP_766 VGND VPWR sky130_fd_sc_hd__tapvpwrvgnd_1
XTAP_744 VGND VPWR sky130_fd_sc_hd__tapvpwrvgnd_1
XTAP_755 VGND VPWR sky130_fd_sc_hd__tapvpwrvgnd_1
XTAP_799 VGND VPWR sky130_fd_sc_hd__tapvpwrvgnd_1
XTAP_788 VGND VPWR sky130_fd_sc_hd__tapvpwrvgnd_1
Xclkbuf_leaf_77_clk clknet_3_4__leaf_clk VGND VGND VPWR VPWR clknet_leaf_77_clk sky130_fd_sc_hd__clkbuf_16
XANTENNA__4817__A2 _1666_ VGND VGND VPWR VPWR sky130_fd_sc_hd__diode_2
X_5023_ u_pe_array.u_fifo2.buffer\[5\]\[5\] _1971_ _1972_ u_pe_array.u_fifo2.buffer\[1\]\[5\]
+ _1973_ VGND VGND VPWR VPWR _2014_ sky130_fd_sc_hd__a221o_1
XANTENNA__4445__S _0855_ VGND VGND VPWR VPWR sky130_fd_sc_hd__diode_2
XANTENNA__5130__A _2029_ VGND VGND VPWR VPWR sky130_fd_sc_hd__diode_2
X_6974_ clknet_leaf_87_clk _0053_ net819 VGND VGND VPWR VPWR u_pe_array.g_pe_row\[3\].g_pe_col\[2\].u_pe.psum_out\[1\]
+ sky130_fd_sc_hd__dfrtp_1
XFILLER_0_88_593 VGND VGND VPWR VPWR sky130_fd_sc_hd__fill_2
X_5925_ _2764_ _2743_ u_pe_array.g_pe_row\[0\].g_pe_col\[2\].u_pe.psum_out\[3\] VGND
+ VGND VPWR VPWR _2765_ sky130_fd_sc_hd__a21oi_1
XFILLER_0_0_85 VPWR VGND VPWR VGND sky130_ef_sc_hd__decap_12
X_5856_ _2715_ _2705_ VGND VGND VPWR VPWR _2716_ sky130_fd_sc_hd__and2b_1
XFILLER_0_75_265 VGND VGND VPWR VPWR sky130_fd_sc_hd__fill_2
XFILLER_0_61_93 VGND VGND VPWR VPWR sky130_fd_sc_hd__fill_2
X_4807_ _1828_ net3 _0754_ VGND VGND VPWR VPWR _1829_ sky130_fd_sc_hd__mux2_1
XFILLER_0_90_246 VGND VGND VPWR VPWR sky130_fd_sc_hd__decap_6
XFILLER_0_56_490 VPWR VGND VPWR VGND sky130_ef_sc_hd__decap_12
XFILLER_0_8_587 VGND VGND VPWR VPWR sky130_fd_sc_hd__fill_1
X_5787_ u_pe_array.g_pe_row\[0\].g_pe_col\[3\].u_pe.act_val\[4\] _2611_ VGND VGND
+ VPWR VPWR _2653_ sky130_fd_sc_hd__and2b_1
X_4738_ _1778_ _1768_ VGND VGND VPWR VPWR _1779_ sky130_fd_sc_hd__and2b_1
XFILLER_0_43_162 VGND VGND VPWR VPWR sky130_fd_sc_hd__decap_4
XFILLER_0_43_140 VGND VGND VPWR VPWR sky130_fd_sc_hd__fill_1
X_7526_ clknet_leaf_3_clk _0575_ VGND VGND VPWR VPWR u_pe_array.u_fifo2.buffer\[7\]\[0\]
+ sky130_fd_sc_hd__dfxtp_1
X_4669_ u_pe_array.g_pe_row\[2\].g_pe_col\[1\].u_pe.w_reg\[0\] u_pe_array.g_pe_row\[2\].g_pe_col\[1\].u_pe.act_val\[5\]
+ VGND VGND VPWR VPWR _1716_ sky130_fd_sc_hd__nand2_1
XFILLER_0_16_387 VGND VGND VPWR VPWR sky130_fd_sc_hd__decap_6
X_7457_ clknet_leaf_0_clk _0506_ VGND VGND VPWR VPWR u_pe_array.u_fifo2.buffer\[1\]\[9\]
+ sky130_fd_sc_hd__dfxtp_1
XFILLER_0_3_281 VPWR VGND VPWR VGND sky130_ef_sc_hd__decap_12
X_6408_ _3167_ VGND VGND VPWR VPWR _0484_ sky130_fd_sc_hd__clkbuf_1
XFILLER_0_101_223 VGND VGND VPWR VPWR sky130_fd_sc_hd__fill_1
X_7388_ clknet_leaf_50_clk _0441_ net817 VGND VGND VPWR VPWR u_pe_array.g_pe_row\[0\].g_pe_col\[1\].u_pe.psum_out\[12\]
+ sky130_fd_sc_hd__dfrtp_1
XFILLER_0_31_379 VGND VGND VPWR VPWR sky130_fd_sc_hd__fill_2
XFILLER_0_101_267 VGND VGND VPWR VPWR sky130_fd_sc_hd__fill_2
X_6339_ _3119_ VGND VGND VPWR VPWR _0463_ sky130_fd_sc_hd__clkbuf_1
XANTENNA__4808__A2 _1666_ VGND VGND VPWR VPWR sky130_fd_sc_hd__diode_2
Xclkbuf_leaf_68_clk clknet_3_5__leaf_clk VGND VGND VPWR VPWR clknet_leaf_68_clk sky130_fd_sc_hd__clkbuf_16
XFILLER_0_79_593 VGND VGND VPWR VPWR sky130_fd_sc_hd__fill_2
XFILLER_0_79_582 VGND VGND VPWR VPWR sky130_fd_sc_hd__decap_3
XANTENNA__7423__RESET_B net74 VGND VGND VPWR VPWR sky130_fd_sc_hd__diode_2
XANTENNA__6172__A_N _2873_ VGND VGND VPWR VPWR sky130_fd_sc_hd__diode_2
XANTENNA__3795__A2 _0834_ VGND VGND VPWR VPWR sky130_fd_sc_hd__diode_2
XFILLER_0_39_457 VGND VGND VPWR VPWR sky130_fd_sc_hd__fill_2
XANTENNA__6194__B1 _0866_ VGND VGND VPWR VPWR sky130_fd_sc_hd__diode_2
XFILLER_0_19_192 VGND VGND VPWR VPWR sky130_fd_sc_hd__decap_3
XFILLER_0_50_600 VGND VGND VPWR VPWR sky130_fd_sc_hd__decap_6
XFILLER_0_22_302 VGND VGND VPWR VPWR sky130_fd_sc_hd__fill_2
XFILLER_0_105_551 VGND VGND VPWR VPWR sky130_fd_sc_hd__fill_1
XFILLER_0_34_162 VGND VGND VPWR VPWR sky130_fd_sc_hd__decap_4
XFILLER_0_34_173 VGND VGND VPWR VPWR sky130_fd_sc_hd__fill_1
XFILLER_0_105_595 VPWR VGND VPWR VGND sky130_ef_sc_hd__decap_12
XFILLER_0_50_666 VGND VGND VPWR VPWR sky130_fd_sc_hd__fill_2
XFILLER_0_66_27 VGND VGND VPWR VPWR sky130_fd_sc_hd__fill_1
Xclkbuf_leaf_59_clk clknet_3_6__leaf_clk VGND VGND VPWR VPWR clknet_leaf_59_clk sky130_fd_sc_hd__clkbuf_16
XFILLER_0_89_346 VPWR VGND VPWR VGND sky130_ef_sc_hd__decap_12
XFILLER_0_89_335 VGND VGND VPWR VPWR sky130_fd_sc_hd__fill_1
XFILLER_0_82_26 VGND VGND VPWR VPWR sky130_fd_sc_hd__fill_2
XANTENNA__4265__S _0828_ VGND VGND VPWR VPWR sky130_fd_sc_hd__diode_2
XANTENNA__7164__RESET_B net817 VGND VGND VPWR VPWR sky130_fd_sc_hd__diode_2
X_3971_ _0832_ VGND VGND VPWR VPWR _1138_ sky130_fd_sc_hd__buf_6
XANTENNA__6421__A1 _1810_ VGND VGND VPWR VPWR sky130_fd_sc_hd__diode_2
XFILLER_0_15_53 VGND VGND VPWR VPWR sky130_fd_sc_hd__fill_1
XANTENNA__3786__A2 _0834_ VGND VGND VPWR VPWR sky130_fd_sc_hd__diode_2
XFILLER_0_9_318 VPWR VGND VPWR VGND sky130_ef_sc_hd__decap_12
XFILLER_0_18_608 VGND VGND VPWR VPWR sky130_fd_sc_hd__fill_2
X_5710_ net759 _2463_ _2592_ _2593_ VGND VGND VPWR VPWR _0360_ sky130_fd_sc_hd__a22o_1
X_6690_ net369 _3321_ VGND VGND VPWR VPWR _0612_ sky130_fd_sc_hd__xnor2_1
XFILLER_0_57_265 VGND VGND VPWR VPWR sky130_fd_sc_hd__fill_2
X_5641_ _2532_ _2478_ u_pe_array.g_pe_row\[1\].g_pe_col\[0\].u_pe.psum_out\[6\] VGND
+ VGND VPWR VPWR _2534_ sky130_fd_sc_hd__a21o_1
XFILLER_0_45_438 VGND VGND VPWR VPWR sky130_fd_sc_hd__decap_3
XFILLER_0_5_502 VGND VGND VPWR VPWR sky130_fd_sc_hd__fill_2
XANTENNA__3609__S _0819_ VGND VGND VPWR VPWR sky130_fd_sc_hd__diode_2
X_5572_ net156 _2463_ _2473_ _2336_ VGND VGND VPWR VPWR _0342_ sky130_fd_sc_hd__a22o_1
X_4523_ _1573_ _1583_ _1584_ VGND VGND VPWR VPWR _1597_ sky130_fd_sc_hd__o21a_1
XFILLER_0_25_173 VGND VGND VPWR VPWR sky130_fd_sc_hd__fill_2
X_7311_ clknet_leaf_66_clk _0370_ net814 VGND VGND VPWR VPWR u_pe_array.g_pe_row\[0\].g_pe_col\[2\].u_pe.move_reg\[10\]
+ sky130_fd_sc_hd__dfrtp_1
Xhold203 u_pe_array.u_fifo1.buffer\[4\]\[7\] VGND VGND VPWR VPWR net279 sky130_fd_sc_hd__dlygate4sd3_1
Xhold214 u_pe_array.u_fifo1.buffer\[6\]\[9\] VGND VGND VPWR VPWR net290 sky130_fd_sc_hd__dlygate4sd3_1
X_7242_ clknet_leaf_41_clk _0305_ net813 VGND VGND VPWR VPWR u_pe_array.g_pe_row\[1\].g_pe_col\[0\].u_pe.act_val\[1\]
+ sky130_fd_sc_hd__dfrtp_2
Xhold225 u_pe_array.g_pe_row\[1\].g_pe_col\[0\].u_pe.move_reg\[12\] VGND VGND VPWR
+ VPWR net301 sky130_fd_sc_hd__dlygate4sd3_1
Xhold247 u_pe_array.u_fifo1.buffer\[1\]\[6\] VGND VGND VPWR VPWR net323 sky130_fd_sc_hd__dlygate4sd3_1
X_4454_ _0865_ VGND VGND VPWR VPWR _1534_ sky130_fd_sc_hd__buf_8
Xhold236 u_pe_array.u_fifo2.buffer\[4\]\[11\] VGND VGND VPWR VPWR net312 sky130_fd_sc_hd__dlygate4sd3_1
Xhold269 u_pe_array.u_fifo2.buffer\[3\]\[11\] VGND VGND VPWR VPWR net345 sky130_fd_sc_hd__dlygate4sd3_1
Xhold258 u_pe_array.u_fifo2.buffer\[6\]\[10\] VGND VGND VPWR VPWR net334 sky130_fd_sc_hd__dlygate4sd3_1
X_7173_ clknet_leaf_42_clk _0240_ net813 VGND VGND VPWR VPWR u_pe_array.g_pe_row\[2\].g_pe_col\[0\].u_pe.psum_out\[7\]
+ sky130_fd_sc_hd__dfrtp_4
X_4385_ u_pe_array.g_pe_row\[2\].g_pe_col\[3\].u_pe.psum_out\[8\] u_pe_array.g_pe_row\[2\].g_pe_col\[3\].u_pe.psum_out\[7\]
+ _1407_ VGND VGND VPWR VPWR _1485_ sky130_fd_sc_hd__and3b_1
X_6124_ _2931_ _2932_ VGND VGND VPWR VPWR _2933_ sky130_fd_sc_hd__nor2_1
XTAP_530 VGND VPWR sky130_fd_sc_hd__tapvpwrvgnd_1
XTAP_541 VGND VPWR sky130_fd_sc_hd__tapvpwrvgnd_1
XTAP_552 VGND VPWR sky130_fd_sc_hd__tapvpwrvgnd_1
X_6055_ u_pe_array.g_pe_row\[0\].g_pe_col\[1\].u_pe.w_reg\[0\] u_pe_array.g_pe_row\[0\].g_pe_col\[1\].u_pe.act_val\[0\]
+ u_pe_array.g_pe_row\[0\].g_pe_col\[1\].u_pe.psum_out\[0\] VGND VGND VPWR VPWR _2870_
+ sky130_fd_sc_hd__and3_1
XTAP_574 VGND VPWR sky130_fd_sc_hd__tapvpwrvgnd_1
XTAP_563 VGND VPWR sky130_fd_sc_hd__tapvpwrvgnd_1
XTAP_585 VGND VPWR sky130_fd_sc_hd__tapvpwrvgnd_1
XTAP_596 VGND VPWR sky130_fd_sc_hd__tapvpwrvgnd_1
X_5006_ u_pe_array.u_fifo2.buffer\[3\]\[3\] _1969_ _1970_ u_pe_array.u_fifo2.buffer\[2\]\[3\]
+ _1998_ VGND VGND VPWR VPWR _1999_ sky130_fd_sc_hd__a221o_1
X_6957_ clknet_leaf_81_clk _0038_ net818 VGND VGND VPWR VPWR u_pe_array.g_pe_row\[3\].g_pe_col\[2\].u_pe.w_buffer\[1\]
+ sky130_fd_sc_hd__dfrtp_1
XFILLER_0_48_221 VGND VGND VPWR VPWR sky130_fd_sc_hd__fill_1
X_6888_ net439 _3103_ _3427_ VGND VGND VPWR VPWR _3428_ sky130_fd_sc_hd__mux2_1
X_5908_ _2740_ _2748_ _2749_ _2571_ net612 VGND VGND VPWR VPWR _0402_ sky130_fd_sc_hd__a32o_1
XFILLER_0_91_555 VGND VGND VPWR VPWR sky130_fd_sc_hd__fill_2
XFILLER_0_29_490 VGND VGND VPWR VPWR sky130_fd_sc_hd__fill_2
X_5839_ _2258_ _2699_ _2700_ _2571_ net655 VGND VGND VPWR VPWR _0382_ sky130_fd_sc_hd__a32o_1
XFILLER_0_36_438 VGND VGND VPWR VPWR sky130_fd_sc_hd__fill_2
XFILLER_0_63_257 VGND VGND VPWR VPWR sky130_fd_sc_hd__decap_8
XFILLER_0_51_408 VGND VGND VPWR VPWR sky130_fd_sc_hd__fill_2
X_7509_ clknet_leaf_0_clk _0558_ VGND VGND VPWR VPWR u_pe_array.u_fifo2.buffer\[5\]\[9\]
+ sky130_fd_sc_hd__dfxtp_1
XANTENNA__6479__A1 _1814_ VGND VGND VPWR VPWR sky130_fd_sc_hd__diode_2
XANTENNA__5734__S _2469_ VGND VGND VPWR VPWR sky130_fd_sc_hd__diode_2
XFILLER_0_102_554 VPWR VGND VPWR VGND sky130_ef_sc_hd__decap_12
XANTENNA__5961__C _2743_ VGND VGND VPWR VPWR sky130_fd_sc_hd__diode_2
XFILLER_0_31_187 VGND VGND VPWR VPWR sky130_fd_sc_hd__decap_4
XANTENNA__6565__S _3239_ VGND VGND VPWR VPWR sky130_fd_sc_hd__diode_2
XFILLER_0_36_19 VGND VGND VPWR VPWR sky130_fd_sc_hd__fill_1
XANTENNA_input13_A rst_n VGND VGND VPWR VPWR sky130_fd_sc_hd__diode_2
XFILLER_0_98_165 VGND VGND VPWR VPWR sky130_fd_sc_hd__fill_2
XFILLER_0_98_187 VGND VGND VPWR VPWR sky130_fd_sc_hd__fill_2
XFILLER_0_52_29 VGND VGND VPWR VPWR sky130_fd_sc_hd__decap_3
XANTENNA__4414__B1 _1144_ VGND VGND VPWR VPWR sky130_fd_sc_hd__diode_2
XFILLER_0_39_232 VGND VGND VPWR VPWR sky130_fd_sc_hd__decap_8
XFILLER_0_82_511 VGND VGND VPWR VPWR sky130_fd_sc_hd__fill_1
XANTENNA__4813__S _0754_ VGND VGND VPWR VPWR sky130_fd_sc_hd__diode_2
XFILLER_0_39_265 VGND VGND VPWR VPWR sky130_fd_sc_hd__decap_4
XFILLER_0_39_276 VGND VGND VPWR VPWR sky130_fd_sc_hd__fill_2
XFILLER_0_27_449 VGND VGND VPWR VPWR sky130_fd_sc_hd__fill_2
XFILLER_0_82_566 VGND VGND VPWR VPWR sky130_fd_sc_hd__fill_2
XANTENNA__5914__B1 _2743_ VGND VGND VPWR VPWR sky130_fd_sc_hd__diode_2
XFILLER_0_112_307 VGND VGND VPWR VPWR sky130_fd_sc_hd__fill_1
XFILLER_0_23_633 VGND VGND VPWR VPWR sky130_fd_sc_hd__fill_2
XFILLER_0_22_121 VGND VGND VPWR VPWR sky130_fd_sc_hd__fill_1
XFILLER_0_77_15 VGND VGND VPWR VPWR sky130_fd_sc_hd__decap_4
XANTENNA__3940__A2 _0875_ VGND VGND VPWR VPWR sky130_fd_sc_hd__diode_2
X_4170_ _1301_ _1302_ VGND VGND VPWR VPWR _1303_ sky130_fd_sc_hd__or2b_1
XFILLER_0_89_110 VGND VGND VPWR VPWR sky130_fd_sc_hd__fill_2
XANTENNA__4653__B1 _0887_ VGND VGND VPWR VPWR sky130_fd_sc_hd__diode_2
XANTENNA__7345__RESET_B net13 VGND VGND VPWR VPWR sky130_fd_sc_hd__diode_2
X_6811_ _3386_ VGND VGND VPWR VPWR _0668_ sky130_fd_sc_hd__clkbuf_1
XFILLER_0_26_85 VGND VGND VPWR VPWR sky130_fd_sc_hd__fill_1
XANTENNA__4405__B1 _0914_ VGND VGND VPWR VPWR sky130_fd_sc_hd__diode_2
X_6742_ _3349_ VGND VGND VPWR VPWR _0636_ sky130_fd_sc_hd__clkbuf_1
X_3954_ u_pe_array.g_pe_row\[2\].g_pe_col\[0\].u_pe.act_val\[3\] u_pe_array.g_pe_row\[2\].g_pe_col\[0\].u_pe.psum_out\[3\]
+ _0755_ VGND VGND VPWR VPWR _1128_ sky130_fd_sc_hd__mux2_1
XFILLER_0_9_148 VPWR VGND VPWR VGND sky130_ef_sc_hd__decap_12
XFILLER_0_85_393 VGND VGND VPWR VPWR sky130_fd_sc_hd__fill_2
XFILLER_0_73_544 VGND VGND VPWR VPWR sky130_fd_sc_hd__fill_2
X_6673_ net461 _3308_ VGND VGND VPWR VPWR _0607_ sky130_fd_sc_hd__xor2_1
XANTENNA__6980__RESET_B net74 VGND VGND VPWR VPWR sky130_fd_sc_hd__diode_2
X_3885_ _1057_ _1060_ _1058_ VGND VGND VPWR VPWR _1071_ sky130_fd_sc_hd__o21ba_1
XFILLER_0_73_566 VGND VGND VPWR VPWR sky130_fd_sc_hd__fill_2
X_5624_ _2495_ _2505_ _2504_ VGND VGND VPWR VPWR _2519_ sky130_fd_sc_hd__a21o_1
XANTENNA__4708__A1 _1672_ VGND VGND VPWR VPWR sky130_fd_sc_hd__diode_2
XFILLER_0_5_321 VGND VGND VPWR VPWR sky130_fd_sc_hd__decap_3
XFILLER_0_60_238 VGND VGND VPWR VPWR sky130_fd_sc_hd__fill_1
XFILLER_0_13_143 VGND VGND VPWR VPWR sky130_fd_sc_hd__fill_2
XANTENNA__5554__S _0769_ VGND VGND VPWR VPWR sky130_fd_sc_hd__diode_2
X_5555_ net678 _2463_ _1655_ _2464_ VGND VGND VPWR VPWR _0334_ sky130_fd_sc_hd__a22o_1
X_5486_ _2382_ _2393_ _2394_ VGND VGND VPWR VPWR _2407_ sky130_fd_sc_hd__o21a_1
XFILLER_0_77_3 VPWR VGND VPWR VGND sky130_ef_sc_hd__decap_12
X_4506_ u_pe_array.g_pe_row\[2\].g_pe_col\[2\].u_pe.psum_out\[5\] _1580_ VGND VGND
+ VPWR VPWR _1581_ sky130_fd_sc_hd__xnor2_1
X_4437_ net175 _1392_ _1523_ _1399_ VGND VGND VPWR VPWR _0157_ sky130_fd_sc_hd__a22o_1
X_7225_ clknet_leaf_82_clk net91 net73 VGND VGND VPWR VPWR u_pe_array.g_pe_row\[1\].g_pe_col\[2\].u_pe.w_reg\[1\]
+ sky130_fd_sc_hd__dfrtp_1
XFILLER_0_1_593 VPWR VGND VPWR VGND sky130_ef_sc_hd__decap_12
X_7156_ clknet_leaf_74_clk _0225_ net814 VGND VGND VPWR VPWR u_pe_array.g_pe_row\[1\].g_pe_col\[3\].u_pe.act_val\[5\]
+ sky130_fd_sc_hd__dfrtp_1
X_6107_ _2915_ _2916_ VGND VGND VPWR VPWR _2917_ sky130_fd_sc_hd__xnor2_1
XANTENNA__4892__B1 _0885_ VGND VGND VPWR VPWR sky130_fd_sc_hd__diode_2
XTAP_360 VGND VPWR sky130_fd_sc_hd__tapvpwrvgnd_1
X_4368_ _0914_ _1469_ VGND VGND VPWR VPWR _1470_ sky130_fd_sc_hd__nor2_1
XANTENNA_input5_A h_in0[4] VGND VGND VPWR VPWR sky130_fd_sc_hd__diode_2
X_7087_ clknet_leaf_13_clk _0160_ net816 VGND VGND VPWR VPWR u_pe_array.g_pe_row\[2\].g_pe_col\[1\].u_pe.move_reg\[9\]
+ sky130_fd_sc_hd__dfrtp_1
XANTENNA__3802__S _0745_ VGND VGND VPWR VPWR sky130_fd_sc_hd__diode_2
X_4299_ _1273_ _1405_ _1406_ _1144_ net400 VGND VGND VPWR VPWR _0136_ sky130_fd_sc_hd__a32o_1
XTAP_382 VGND VPWR sky130_fd_sc_hd__tapvpwrvgnd_1
XTAP_371 VGND VPWR sky130_fd_sc_hd__tapvpwrvgnd_1
XTAP_393 VGND VPWR sky130_fd_sc_hd__tapvpwrvgnd_1
X_6038_ u_pe_array.g_pe_row\[0\].g_pe_col\[1\].u_pe.act_val\[5\] u_pe_array.g_pe_row\[0\].g_pe_col\[1\].u_pe.psum_out\[5\]
+ _0756_ VGND VGND VPWR VPWR _2861_ sky130_fd_sc_hd__mux2_1
XANTENNA__5436__A2 _1714_ VGND VGND VPWR VPWR sky130_fd_sc_hd__diode_2
XANTENNA__7086__RESET_B net816 VGND VGND VPWR VPWR sky130_fd_sc_hd__diode_2
XANTENNA__6633__A1 net10 VGND VGND VPWR VPWR sky130_fd_sc_hd__diode_2
XANTENNA__7015__RESET_B net818 VGND VGND VPWR VPWR sky130_fd_sc_hd__diode_2
XTAP_1504 VGND VPWR sky130_fd_sc_hd__tapvpwrvgnd_1
XTAP_1515 VGND VPWR sky130_fd_sc_hd__tapvpwrvgnd_1
XFILLER_0_96_636 VGND VGND VPWR VPWR sky130_fd_sc_hd__fill_1
XFILLER_0_68_316 VGND VGND VPWR VPWR sky130_fd_sc_hd__fill_2
XPHY_22 VGND VGND VPWR VPWR sky130_fd_sc_hd__decap_3
XPHY_11 VGND VGND VPWR VPWR sky130_fd_sc_hd__decap_3
XTAP_1548 VGND VPWR sky130_fd_sc_hd__tapvpwrvgnd_1
XTAP_1537 VGND VPWR sky130_fd_sc_hd__tapvpwrvgnd_1
XTAP_1526 VGND VPWR sky130_fd_sc_hd__tapvpwrvgnd_1
XPHY_33 VGND VGND VPWR VPWR sky130_fd_sc_hd__decap_3
XPHY_44 VGND VGND VPWR VPWR sky130_fd_sc_hd__decap_3
XPHY_55 VGND VGND VPWR VPWR sky130_fd_sc_hd__decap_3
XTAP_1559 VGND VPWR sky130_fd_sc_hd__tapvpwrvgnd_1
XPHY_88 VGND VGND VPWR VPWR sky130_fd_sc_hd__decap_3
XPHY_66 VGND VGND VPWR VPWR sky130_fd_sc_hd__decap_3
XPHY_77 VGND VGND VPWR VPWR sky130_fd_sc_hd__decap_3
XPHY_99 VGND VGND VPWR VPWR sky130_fd_sc_hd__decap_3
XFILLER_0_9_671 VGND VGND VPWR VPWR sky130_fd_sc_hd__fill_1
XANTENNA__3757__B _0869_ VGND VGND VPWR VPWR sky130_fd_sc_hd__diode_2
XFILLER_0_36_224 VGND VGND VPWR VPWR sky130_fd_sc_hd__decap_3
XFILLER_0_91_341 VGND VGND VPWR VPWR sky130_fd_sc_hd__decap_3
XFILLER_0_106_156 VGND VGND VPWR VPWR sky130_fd_sc_hd__fill_2
XFILLER_0_51_249 VGND VGND VPWR VPWR sky130_fd_sc_hd__fill_1
XFILLER_0_32_485 VGND VGND VPWR VPWR sky130_fd_sc_hd__fill_2
XFILLER_0_102_373 VGND VGND VPWR VPWR sky130_fd_sc_hd__fill_2
XFILLER_0_63_39 VPWR VGND VPWR VGND sky130_ef_sc_hd__decap_12
XFILLER_0_86_135 VGND VGND VPWR VPWR sky130_fd_sc_hd__decap_4
XFILLER_0_86_168 VGND VGND VPWR VPWR sky130_fd_sc_hd__fill_1
XANTENNA__5060__B1 _2029_ VGND VGND VPWR VPWR sky130_fd_sc_hd__diode_2
XFILLER_0_103_67 VGND VGND VPWR VPWR sky130_fd_sc_hd__fill_1
XFILLER_0_82_396 VGND VGND VPWR VPWR sky130_fd_sc_hd__fill_2
XFILLER_0_82_385 VGND VGND VPWR VPWR sky130_fd_sc_hd__fill_1
X_3670_ _0885_ VGND VGND VPWR VPWR _0887_ sky130_fd_sc_hd__clkbuf_16
X_5340_ u_pe_array.u_fifo1.rd_ptr\[1\] u_pe_array.u_fifo1.rd_ptr\[0\] _2271_ u_pe_array.u_fifo1.rd_ptr\[2\]
+ VGND VGND VPWR VPWR _2280_ sky130_fd_sc_hd__and4_2
XANTENNA__6312__B1 _2174_ VGND VGND VPWR VPWR sky130_fd_sc_hd__diode_2
X_5271_ _2217_ _2218_ _2219_ VGND VGND VPWR VPWR _2220_ sky130_fd_sc_hd__or3_1
XFILLER_0_50_293 VGND VGND VPWR VPWR sky130_fd_sc_hd__fill_2
X_4222_ _1334_ _1341_ _1349_ VGND VGND VPWR VPWR _1350_ sky130_fd_sc_hd__a21oi_1
X_7010_ clknet_leaf_10_clk _0087_ net74 VGND VGND VPWR VPWR u_pe_array.g_pe_row\[3\].g_pe_col\[1\].u_pe.psum_out\[7\]
+ sky130_fd_sc_hd__dfrtp_4
XFILLER_0_10_168 VGND VGND VPWR VPWR sky130_fd_sc_hd__decap_3
X_4153_ u_pe_array.g_pe_row\[3\].g_pe_col\[0\].u_pe.psum_out\[2\] _1286_ VGND VGND
+ VPWR VPWR _1287_ sky130_fd_sc_hd__xnor2_1
X_4084_ _1236_ _1237_ _1228_ VGND VGND VPWR VPWR _1238_ sky130_fd_sc_hd__a21oi_1
XANTENNA__6615__A1 _1810_ VGND VGND VPWR VPWR sky130_fd_sc_hd__diode_2
XANTENNA__6091__A2 _2387_ VGND VGND VPWR VPWR sky130_fd_sc_hd__diode_2
XFILLER_0_78_625 VGND VGND VPWR VPWR sky130_fd_sc_hd__fill_2
XFILLER_0_77_102 VGND VGND VPWR VPWR sky130_fd_sc_hd__decap_3
XFILLER_0_93_606 VGND VGND VPWR VPWR sky130_fd_sc_hd__fill_2
XFILLER_0_53_61 VGND VGND VPWR VPWR sky130_fd_sc_hd__fill_2
XANTENNA__5549__S _0770_ VGND VGND VPWR VPWR sky130_fd_sc_hd__diode_2
XFILLER_0_93_617 VGND VGND VPWR VPWR sky130_fd_sc_hd__decap_4
XFILLER_0_53_83 VGND VGND VPWR VPWR sky130_fd_sc_hd__fill_2
XFILLER_0_46_500 VGND VGND VPWR VPWR sky130_fd_sc_hd__fill_2
X_4986_ u_pe_array.u_fifo2.buffer\[4\]\[1\] _1965_ _1966_ u_pe_array.u_fifo2.buffer\[7\]\[1\]
+ VGND VGND VPWR VPWR _1981_ sky130_fd_sc_hd__a22o_1
X_6725_ net494 _3114_ net65 VGND VGND VPWR VPWR _3341_ sky130_fd_sc_hd__mux2_1
XFILLER_0_46_533 VGND VGND VPWR VPWR sky130_fd_sc_hd__fill_2
X_3937_ _1103_ _1107_ _1114_ _1116_ _1113_ VGND VGND VPWR VPWR _1117_ sky130_fd_sc_hd__a32o_1
X_6656_ _3108_ _3297_ _3298_ VGND VGND VPWR VPWR _3299_ sky130_fd_sc_hd__and3_1
XFILLER_0_33_205 VGND VGND VPWR VPWR sky130_fd_sc_hd__fill_2
XFILLER_0_33_216 VGND VGND VPWR VPWR sky130_fd_sc_hd__fill_2
X_3868_ u_pe_array.g_pe_row\[3\].g_pe_col\[2\].u_pe.psum_out\[5\] _1054_ VGND VGND
+ VPWR VPWR _1055_ sky130_fd_sc_hd__xnor2_1
XANTENNA__3593__A _0827_ VGND VGND VPWR VPWR sky130_fd_sc_hd__diode_2
XANTENNA__4157__A2 _1152_ VGND VGND VPWR VPWR sky130_fd_sc_hd__diode_2
X_5607_ _2498_ _2502_ VGND VGND VPWR VPWR _2503_ sky130_fd_sc_hd__xnor2_1
X_3799_ net776 _0996_ _0837_ _0998_ VGND VGND VPWR VPWR _0044_ sky130_fd_sc_hd__a22o_1
X_6587_ net213 _1810_ _3254_ VGND VGND VPWR VPWR _3262_ sky130_fd_sc_hd__mux2_1
XFILLER_0_103_148 VGND VGND VPWR VPWR sky130_fd_sc_hd__fill_1
XFILLER_0_103_126 VGND VGND VPWR VPWR sky130_fd_sc_hd__fill_2
X_5538_ _2444_ _2447_ _2452_ VGND VGND VPWR VPWR _2454_ sky130_fd_sc_hd__or3_1
XFILLER_0_41_260 VGND VGND VPWR VPWR sky130_fd_sc_hd__fill_2
XANTENNA__6854__A1 _3132_ VGND VGND VPWR VPWR sky130_fd_sc_hd__diode_2
X_5469_ u_pe_array.g_pe_row\[1\].g_pe_col\[1\].u_pe.psum_out\[5\] _2390_ VGND VGND
+ VPWR VPWR _2391_ sky130_fd_sc_hd__xnor2_1
X_7208_ clknet_leaf_71_clk _0273_ net814 VGND VGND VPWR VPWR u_pe_array.g_pe_row\[1\].g_pe_col\[3\].u_pe.psum_out\[12\]
+ sky130_fd_sc_hd__dfrtp_1
XANTENNA__7267__RESET_B net812 VGND VGND VPWR VPWR sky130_fd_sc_hd__diode_2
X_7139_ clknet_leaf_9_clk _0208_ VGND VGND VPWR VPWR u_pe_array.u_fifo2.buffer\[8\]\[3\]
+ sky130_fd_sc_hd__dfxtp_1
XANTENNA__5409__A2 _2144_ VGND VGND VPWR VPWR sky130_fd_sc_hd__diode_2
XTAP_1323 VGND VPWR sky130_fd_sc_hd__tapvpwrvgnd_1
XTAP_1312 VGND VPWR sky130_fd_sc_hd__tapvpwrvgnd_1
XTAP_1301 VGND VPWR sky130_fd_sc_hd__tapvpwrvgnd_1
XTAP_1356 VGND VPWR sky130_fd_sc_hd__tapvpwrvgnd_1
XTAP_1345 VGND VPWR sky130_fd_sc_hd__tapvpwrvgnd_1
XTAP_1334 VGND VPWR sky130_fd_sc_hd__tapvpwrvgnd_1
XFILLER_0_84_639 VGND VGND VPWR VPWR sky130_fd_sc_hd__decap_3
XTAP_1389 VGND VPWR sky130_fd_sc_hd__tapvpwrvgnd_1
XTAP_1378 VGND VPWR sky130_fd_sc_hd__tapvpwrvgnd_1
XTAP_1367 VGND VPWR sky130_fd_sc_hd__tapvpwrvgnd_1
XFILLER_0_64_330 VGND VGND VPWR VPWR sky130_fd_sc_hd__fill_2
XFILLER_0_37_555 VGND VGND VPWR VPWR sky130_fd_sc_hd__decap_3
XFILLER_0_107_432 VPWR VGND VPWR VGND sky130_ef_sc_hd__decap_12
XFILLER_0_92_672 VGND VGND VPWR VPWR sky130_fd_sc_hd__fill_2
Xinput18 v_in0[3] VGND VGND VPWR VPWR net18 sky130_fd_sc_hd__clkbuf_2
XFILLER_0_64_363 VGND VGND VPWR VPWR sky130_fd_sc_hd__fill_1
XFILLER_0_52_514 VGND VGND VPWR VPWR sky130_fd_sc_hd__fill_1
Xinput29 w_in_flat[2] VGND VGND VPWR VPWR net29 sky130_fd_sc_hd__buf_1
XANTENNA__5896__A2 _2738_ VGND VGND VPWR VPWR sky130_fd_sc_hd__diode_2
XFILLER_0_60_580 VGND VGND VPWR VPWR sky130_fd_sc_hd__decap_6
XFILLER_0_103_671 VGND VGND VPWR VPWR sky130_fd_sc_hd__fill_1
XFILLER_0_20_455 VGND VGND VPWR VPWR sky130_fd_sc_hd__fill_2
XFILLER_0_102_192 VGND VGND VPWR VPWR sky130_fd_sc_hd__fill_2
XFILLER_0_59_113 VGND VGND VPWR VPWR sky130_fd_sc_hd__decap_8
XANTENNA__6919__RESET_B net73 VGND VGND VPWR VPWR sky130_fd_sc_hd__diode_2
XFILLER_0_90_15 VGND VGND VPWR VPWR sky130_fd_sc_hd__decap_6
X_4840_ _1845_ _1849_ VGND VGND VPWR VPWR _1850_ sky130_fd_sc_hd__xnor2_1
XANTENNA__5369__S _0755_ VGND VGND VPWR VPWR sky130_fd_sc_hd__diode_2
XFILLER_0_75_617 VGND VGND VPWR VPWR sky130_fd_sc_hd__fill_2
XFILLER_0_59_179 VGND VGND VPWR VPWR sky130_fd_sc_hd__fill_2
XFILLER_0_114_66 VPWR VGND VPWR VGND sky130_ef_sc_hd__decap_12
XFILLER_0_7_405 VGND VGND VPWR VPWR sky130_fd_sc_hd__fill_2
XFILLER_0_7_427 VGND VGND VPWR VPWR sky130_fd_sc_hd__fill_1
X_6510_ net345 _1818_ _3208_ VGND VGND VPWR VPWR _3220_ sky130_fd_sc_hd__mux2_1
XFILLER_0_28_566 VGND VGND VPWR VPWR sky130_fd_sc_hd__fill_2
X_4771_ _1805_ VGND VGND VPWR VPWR _0209_ sky130_fd_sc_hd__clkbuf_1
X_7490_ clknet_leaf_5_clk _0539_ VGND VGND VPWR VPWR u_pe_array.u_fifo2.buffer\[4\]\[3\]
+ sky130_fd_sc_hd__dfxtp_1
XFILLER_0_43_503 VGND VGND VPWR VPWR sky130_fd_sc_hd__fill_1
X_3722_ _0933_ _0934_ _0935_ VGND VGND VPWR VPWR _0936_ sky130_fd_sc_hd__or3_1
XFILLER_0_28_599 VGND VGND VPWR VPWR sky130_fd_sc_hd__fill_2
XFILLER_0_99_57 VGND VGND VPWR VPWR sky130_fd_sc_hd__decap_4
XFILLER_0_82_182 VGND VGND VPWR VPWR sky130_fd_sc_hd__decap_3
XFILLER_0_70_344 VGND VGND VPWR VPWR sky130_fd_sc_hd__fill_1
X_3653_ _0860_ _0871_ VGND VGND VPWR VPWR _0872_ sky130_fd_sc_hd__xnor2_1
X_6441_ _3184_ VGND VGND VPWR VPWR _0500_ sky130_fd_sc_hd__clkbuf_1
XANTENNA__5887__A2 _2600_ VGND VGND VPWR VPWR sky130_fd_sc_hd__diode_2
X_6372_ _1792_ u_pe_array.u_fifo2.wr_ptr\[1\] u_pe_array.u_fifo2.wr_ptr\[2\] _3136_
+ VGND VGND VPWR VPWR _3142_ sky130_fd_sc_hd__and4_1
XFILLER_0_2_121 VPWR VGND VPWR VGND sky130_ef_sc_hd__decap_12
XANTENNA__3617__S _0755_ VGND VGND VPWR VPWR sky130_fd_sc_hd__diode_2
XANTENNA__6220__C _2992_ VGND VGND VPWR VPWR sky130_fd_sc_hd__diode_2
X_5323_ _2250_ _2255_ _2262_ _2265_ _2261_ VGND VGND VPWR VPWR _2266_ sky130_fd_sc_hd__a32o_1
XFILLER_0_51_591 VGND VGND VPWR VPWR sky130_fd_sc_hd__fill_2
X_3584_ _0819_ _0792_ u_fsm.v_cnt\[0\] VGND VGND VPWR VPWR _0822_ sky130_fd_sc_hd__o21ba_1
XANTENNA__3898__A1 _0864_ VGND VGND VPWR VPWR sky130_fd_sc_hd__diode_2
XFILLER_0_2_165 VPWR VGND VPWR VGND sky130_ef_sc_hd__decap_12
XFILLER_0_11_466 VGND VGND VPWR VPWR sky130_fd_sc_hd__decap_3
XANTENNA__7360__RESET_B net813 VGND VGND VPWR VPWR sky130_fd_sc_hd__diode_2
X_5254_ u_pe_array.g_pe_row\[1\].g_pe_col\[2\].u_pe.psum_out\[5\] _2203_ VGND VGND
+ VPWR VPWR _2204_ sky130_fd_sc_hd__xnor2_1
X_4205_ _1333_ _1334_ VGND VGND VPWR VPWR _1335_ sky130_fd_sc_hd__nor2_1
X_5185_ u_pe_array.g_pe_row\[1\].g_pe_col\[2\].u_pe.psum_out\[6\] u_pe_array.g_pe_row\[1\].g_pe_col\[2\].u_pe.move_reg\[6\]
+ _1661_ VGND VGND VPWR VPWR _2147_ sky130_fd_sc_hd__mux2_1
X_4136_ _1271_ VGND VGND VPWR VPWR _1272_ sky130_fd_sc_hd__inv_2
X_4067_ _1145_ u_pe_array.g_pe_row\[3\].g_pe_col\[1\].u_pe.psum_out\[7\] _1221_ _1222_
+ VGND VGND VPWR VPWR _1223_ sky130_fd_sc_hd__a22oi_1
XFILLER_0_78_444 VGND VGND VPWR VPWR sky130_fd_sc_hd__fill_2
XANTENNA__5787__B _2611_ VGND VGND VPWR VPWR sky130_fd_sc_hd__diode_2
Xwire64 net65 VGND VGND VPWR VPWR net64 sky130_fd_sc_hd__buf_2
XFILLER_0_19_511 VGND VGND VPWR VPWR sky130_fd_sc_hd__fill_2
XFILLER_0_46_330 VGND VGND VPWR VPWR sky130_fd_sc_hd__decap_3
X_4969_ u_pe_array.u_fifo2.rd_ptr\[1\] u_pe_array.u_fifo2.rd_ptr\[0\] _1958_ u_pe_array.u_fifo2.rd_ptr\[2\]
+ VGND VGND VPWR VPWR _1965_ sky130_fd_sc_hd__and4bb_2
X_6708_ net253 _3124_ net66 VGND VGND VPWR VPWR _3332_ sky130_fd_sc_hd__mux2_1
XFILLER_0_74_672 VGND VGND VPWR VPWR sky130_fd_sc_hd__fill_2
XFILLER_0_73_160 VGND VGND VPWR VPWR sky130_fd_sc_hd__decap_3
XFILLER_0_46_374 VGND VGND VPWR VPWR sky130_fd_sc_hd__fill_2
XANTENNA__5327__A1 u_pe_array.g_pe_row\[1\].g_pe_col\[1\].u_pe.w_buffer\[0\] VGND
+ VGND VPWR VPWR sky130_fd_sc_hd__diode_2
XFILLER_0_61_333 VGND VGND VPWR VPWR sky130_fd_sc_hd__decap_3
X_6639_ net623 _0833_ VGND VGND VPWR VPWR _3289_ sky130_fd_sc_hd__and2_1
XANTENNA__4212__A _1275_ VGND VGND VPWR VPWR sky130_fd_sc_hd__diode_2
XFILLER_0_61_366 VGND VGND VPWR VPWR sky130_fd_sc_hd__fill_1
XFILLER_0_42_580 VGND VGND VPWR VPWR sky130_fd_sc_hd__fill_2
XANTENNA__6838__S _3397_ VGND VGND VPWR VPWR sky130_fd_sc_hd__diode_2
XFILLER_0_100_641 VGND VGND VPWR VPWR sky130_fd_sc_hd__decap_3
XANTENNA__7030__RESET_B net815 VGND VGND VPWR VPWR sky130_fd_sc_hd__diode_2
XANTENNA__6573__S _3254_ VGND VGND VPWR VPWR sky130_fd_sc_hd__diode_2
XFILLER_0_69_444 VGND VGND VPWR VPWR sky130_fd_sc_hd__fill_2
XTAP_1131 VGND VPWR sky130_fd_sc_hd__tapvpwrvgnd_1
XTAP_1120 VGND VPWR sky130_fd_sc_hd__tapvpwrvgnd_1
XFILLER_0_69_466 VGND VGND VPWR VPWR sky130_fd_sc_hd__fill_1
XFILLER_0_57_617 VGND VGND VPWR VPWR sky130_fd_sc_hd__decap_3
XFILLER_0_56_105 VGND VGND VPWR VPWR sky130_fd_sc_hd__fill_2
XANTENNA__5189__S _1661_ VGND VGND VPWR VPWR sky130_fd_sc_hd__diode_2
XANTENNA_clkbuf_leaf_70_clk_A clknet_3_5__leaf_clk VGND VGND VPWR VPWR sky130_fd_sc_hd__diode_2
XFILLER_0_96_274 VGND VGND VPWR VPWR sky130_fd_sc_hd__decap_3
XTAP_1164 VGND VPWR sky130_fd_sc_hd__tapvpwrvgnd_1
XTAP_1153 VGND VPWR sky130_fd_sc_hd__tapvpwrvgnd_1
XTAP_1142 VGND VPWR sky130_fd_sc_hd__tapvpwrvgnd_1
XFILLER_0_69_499 VGND VGND VPWR VPWR sky130_fd_sc_hd__decap_3
XTAP_1197 VGND VPWR sky130_fd_sc_hd__tapvpwrvgnd_1
XTAP_1186 VGND VPWR sky130_fd_sc_hd__tapvpwrvgnd_1
XTAP_1175 VGND VPWR sky130_fd_sc_hd__tapvpwrvgnd_1
XFILLER_0_60_29 VPWR VGND VPWR VGND sky130_ef_sc_hd__decap_12
XANTENNA__4369__A2 _1152_ VGND VGND VPWR VPWR sky130_fd_sc_hd__diode_2
XANTENNA__5566__B2 _2336_ VGND VGND VPWR VPWR sky130_fd_sc_hd__diode_2
XFILLER_0_80_620 VGND VGND VPWR VPWR sky130_fd_sc_hd__fill_2
XANTENNA_clkbuf_leaf_85_clk_A clknet_3_1__leaf_clk VGND VGND VPWR VPWR sky130_fd_sc_hd__diode_2
XFILLER_0_8_19 VGND VGND VPWR VPWR sky130_fd_sc_hd__fill_1
XFILLER_0_40_528 VGND VGND VPWR VPWR sky130_fd_sc_hd__fill_2
XANTENNA__7189__RESET_B net73 VGND VGND VPWR VPWR sky130_fd_sc_hd__diode_2
XFILLER_0_33_580 VGND VGND VPWR VPWR sky130_fd_sc_hd__decap_8
XANTENNA__7118__RESET_B net816 VGND VGND VPWR VPWR sky130_fd_sc_hd__diode_2
XANTENNA__4479__D _1536_ VGND VGND VPWR VPWR sky130_fd_sc_hd__diode_2
XFILLER_0_0_625 VPWR VGND VPWR VGND sky130_ef_sc_hd__decap_12
XTAP_926 VGND VPWR sky130_fd_sc_hd__tapvpwrvgnd_1
XTAP_915 VGND VPWR sky130_fd_sc_hd__tapvpwrvgnd_1
XTAP_904 VGND VPWR sky130_fd_sc_hd__tapvpwrvgnd_1
XTAP_959 VGND VPWR sky130_fd_sc_hd__tapvpwrvgnd_1
XTAP_948 VGND VPWR sky130_fd_sc_hd__tapvpwrvgnd_1
XTAP_937 VGND VPWR sky130_fd_sc_hd__tapvpwrvgnd_1
XFILLER_0_109_55 VGND VGND VPWR VPWR sky130_fd_sc_hd__fill_1
XANTENNA_clkbuf_leaf_23_clk_A clknet_3_2__leaf_clk VGND VGND VPWR VPWR sky130_fd_sc_hd__diode_2
X_6990_ clknet_leaf_35_clk _0069_ net816 VGND VGND VPWR VPWR u_pe_array.g_pe_row\[3\].g_pe_col\[0\].u_pe.act_val\[2\]
+ sky130_fd_sc_hd__dfrtp_2
XFILLER_0_79_219 VGND VGND VPWR VPWR sky130_fd_sc_hd__decap_3
XANTENNA_clkbuf_leaf_38_clk_A clknet_3_6__leaf_clk VGND VGND VPWR VPWR sky130_fd_sc_hd__diode_2
X_5941_ u_pe_array.g_pe_row\[0\].g_pe_col\[2\].u_pe.act_val\[3\] u_pe_array.g_pe_row\[0\].g_pe_col\[2\].u_pe.w_reg\[0\]
+ _2767_ _2766_ VGND VGND VPWR VPWR _2780_ sky130_fd_sc_hd__a31o_1
XFILLER_0_87_241 VGND VGND VPWR VPWR sky130_fd_sc_hd__fill_1
XANTENNA__6215__C _2992_ VGND VGND VPWR VPWR sky130_fd_sc_hd__diode_2
XFILLER_0_87_285 VGND VGND VPWR VPWR sky130_fd_sc_hd__fill_2
X_5872_ u_pe_array.g_pe_row\[1\].g_pe_col\[1\].u_pe.psum_out\[1\] u_pe_array.g_pe_row\[1\].g_pe_col\[1\].u_pe.act_val\[1\]
+ _0745_ VGND VGND VPWR VPWR _2727_ sky130_fd_sc_hd__mux2_1
X_7611_ clknet_leaf_25_clk _0660_ VGND VGND VPWR VPWR u_pe_array.u_fifo1.buffer\[3\]\[8\]
+ sky130_fd_sc_hd__dfxtp_1
XFILLER_0_7_202 VGND VGND VPWR VPWR sky130_fd_sc_hd__decap_4
X_4823_ _1838_ VGND VGND VPWR VPWR _0228_ sky130_fd_sc_hd__clkbuf_1
X_4754_ _1792_ u_pe_array.u_fifo2.wr_ptr\[1\] VGND VGND VPWR VPWR _1793_ sky130_fd_sc_hd__nor2_1
XFILLER_0_28_352 VGND VGND VPWR VPWR sky130_fd_sc_hd__fill_2
XFILLER_0_28_385 VGND VGND VPWR VPWR sky130_fd_sc_hd__decap_4
X_7542_ clknet_leaf_81_clk _0591_ net818 VGND VGND VPWR VPWR u_pe_array.g_pe_row\[3\].g_pe_col\[3\].u_pe.act_val\[3\]
+ sky130_fd_sc_hd__dfrtp_4
XFILLER_0_71_653 VGND VGND VPWR VPWR sky130_fd_sc_hd__decap_3
XFILLER_0_55_193 VGND VGND VPWR VPWR sky130_fd_sc_hd__decap_4
XFILLER_0_50_62 VGND VGND VPWR VPWR sky130_fd_sc_hd__fill_2
X_7473_ clknet_leaf_5_clk _0522_ VGND VGND VPWR VPWR u_pe_array.u_fifo2.buffer\[2\]\[12\]
+ sky130_fd_sc_hd__dfxtp_1
X_3705_ u_pe_array.g_pe_row\[3\].g_pe_col\[3\].u_pe.psum_out\[5\] _0919_ VGND VGND
+ VPWR VPWR _0920_ sky130_fd_sc_hd__xnor2_1
XFILLER_0_28_396 VGND VGND VPWR VPWR sky130_fd_sc_hd__fill_1
X_4685_ _1729_ _1730_ VGND VGND VPWR VPWR _1731_ sky130_fd_sc_hd__or2_1
XFILLER_0_3_430 VGND VGND VPWR VPWR sky130_fd_sc_hd__fill_1
X_6424_ _3175_ VGND VGND VPWR VPWR _0492_ sky130_fd_sc_hd__clkbuf_1
XANTENNA__7541__RESET_B net74 VGND VGND VPWR VPWR sky130_fd_sc_hd__diode_2
X_3636_ u_pe_array.g_pe_row\[2\].g_pe_col\[2\].u_pe.psum_out\[12\] net811 _0855_ VGND
+ VGND VPWR VPWR _0857_ sky130_fd_sc_hd__mux2_1
XFILLER_0_113_287 VGND VGND VPWR VPWR sky130_fd_sc_hd__fill_2
X_6355_ _1787_ _1139_ net50 VGND VGND VPWR VPWR _3130_ sky130_fd_sc_hd__a21o_4
X_3567_ u_fsm.cnt\[1\] u_fsm.cnt\[0\] VGND VGND VPWR VPWR _0810_ sky130_fd_sc_hd__xnor2_1
XANTENNA__5562__S _1661_ VGND VGND VPWR VPWR sky130_fd_sc_hd__diode_2
X_6286_ _3075_ VGND VGND VPWR VPWR _3076_ sky130_fd_sc_hd__inv_2
X_5306_ u_pe_array.g_pe_row\[1\].g_pe_col\[2\].u_pe.psum_out\[10\] _2158_ VGND VGND
+ VPWR VPWR _2251_ sky130_fd_sc_hd__nand2_1
XFILLER_0_59_93 VPWR VGND VPWR VGND sky130_ef_sc_hd__decap_12
XFILLER_0_11_274 VGND VGND VPWR VPWR sky130_fd_sc_hd__fill_2
XFILLER_0_11_263 VGND VGND VPWR VPWR sky130_fd_sc_hd__decap_3
X_3498_ u_pe_array.g_pe_row\[1\].g_pe_col\[0\].u_pe.act_val\[1\] u_pe_array.g_pe_row\[1\].g_pe_col\[0\].u_pe.psum_out\[1\]
+ _0756_ VGND VGND VPWR VPWR _0759_ sky130_fd_sc_hd__mux2_1
X_5237_ net648 _1714_ _2174_ _2188_ VGND VGND VPWR VPWR _0292_ sky130_fd_sc_hd__a22o_1
XFILLER_0_11_285 VGND VGND VPWR VPWR sky130_fd_sc_hd__fill_1
XANTENNA__4296__B2 _1399_ VGND VGND VPWR VPWR sky130_fd_sc_hd__diode_2
X_5168_ u_pe_array.g_pe_row\[0\].g_pe_col\[2\].u_pe.w_buffer\[0\] net799 _0828_ VGND
+ VGND VPWR VPWR _2138_ sky130_fd_sc_hd__mux2_1
XANTENNA__6037__A2 _2738_ VGND VGND VPWR VPWR sky130_fd_sc_hd__diode_2
X_4119_ net653 _1138_ _1258_ _1262_ VGND VGND VPWR VPWR _0100_ sky130_fd_sc_hd__a22o_1
X_5099_ _2060_ _2061_ _2075_ VGND VGND VPWR VPWR _2077_ sky130_fd_sc_hd__nor3_2
XFILLER_0_39_617 VGND VGND VPWR VPWR sky130_fd_sc_hd__fill_2
XPHY_225 VGND VGND VPWR VPWR sky130_fd_sc_hd__decap_3
XPHY_214 VGND VGND VPWR VPWR sky130_fd_sc_hd__decap_3
XPHY_203 VGND VGND VPWR VPWR sky130_fd_sc_hd__decap_3
XFILLER_0_93_222 VGND VGND VPWR VPWR sky130_fd_sc_hd__fill_2
XFILLER_0_66_458 VGND VGND VPWR VPWR sky130_fd_sc_hd__fill_2
XFILLER_0_66_447 VGND VGND VPWR VPWR sky130_fd_sc_hd__decap_3
XFILLER_0_47_650 VGND VGND VPWR VPWR sky130_fd_sc_hd__fill_2
XFILLER_0_53_108 VGND VGND VPWR VPWR sky130_fd_sc_hd__fill_2
XFILLER_0_19_352 VGND VGND VPWR VPWR sky130_fd_sc_hd__fill_1
XFILLER_0_74_480 VGND VGND VPWR VPWR sky130_fd_sc_hd__decap_3
XANTENNA__3765__B _0869_ VGND VGND VPWR VPWR sky130_fd_sc_hd__diode_2
XFILLER_0_61_163 VGND VGND VPWR VPWR sky130_fd_sc_hd__fill_2
XFILLER_0_34_377 VGND VGND VPWR VPWR sky130_fd_sc_hd__fill_1
XFILLER_0_15_591 VGND VGND VPWR VPWR sky130_fd_sc_hd__fill_1
XANTENNA__7282__RESET_B net814 VGND VGND VPWR VPWR sky130_fd_sc_hd__diode_2
XANTENNA_hold694_A u_pe_array.g_pe_row\[3\].g_pe_col\[3\].u_pe.act_val\[3\] VGND VGND
+ VPWR VPWR sky130_fd_sc_hd__diode_2
XFILLER_0_104_298 VGND VGND VPWR VPWR sky130_fd_sc_hd__fill_1
XFILLER_0_104_276 VGND VGND VPWR VPWR sky130_fd_sc_hd__decap_3
XANTENNA__7211__RESET_B net75 VGND VGND VPWR VPWR sky130_fd_sc_hd__diode_2
XFILLER_0_30_561 VGND VGND VPWR VPWR sky130_fd_sc_hd__decap_8
Xhold7 u_pe_array.g_pe_row\[3\].g_pe_col\[2\].u_pe.w_buffer\[0\] VGND VGND VPWR VPWR
+ net83 sky130_fd_sc_hd__dlygate4sd3_1
XANTENNA__4816__S _0754_ VGND VGND VPWR VPWR sky130_fd_sc_hd__diode_2
XANTENNA__3798__A0 _0743_ VGND VGND VPWR VPWR sky130_fd_sc_hd__diode_2
XFILLER_0_97_583 VGND VGND VPWR VPWR sky130_fd_sc_hd__fill_1
XFILLER_0_84_222 VGND VGND VPWR VPWR sky130_fd_sc_hd__decap_3
XFILLER_0_29_127 VGND VGND VPWR VPWR sky130_fd_sc_hd__decap_4
XANTENNA__5539__A1 _2258_ VGND VGND VPWR VPWR sky130_fd_sc_hd__diode_2
XANTENNA__4211__A1 _1273_ VGND VGND VPWR VPWR sky130_fd_sc_hd__diode_2
XFILLER_0_65_480 VGND VGND VPWR VPWR sky130_fd_sc_hd__fill_2
XFILLER_0_53_631 VGND VGND VPWR VPWR sky130_fd_sc_hd__fill_2
XANTENNA__3675__B u_pe_array.g_pe_row\[3\].g_pe_col\[3\].u_pe.act_val\[3\] VGND VGND
+ VPWR VPWR sky130_fd_sc_hd__diode_2
XFILLER_0_52_141 VGND VGND VPWR VPWR sky130_fd_sc_hd__fill_2
XFILLER_0_25_344 VGND VGND VPWR VPWR sky130_fd_sc_hd__fill_2
Xhold407 u_pe_array.u_fifo1.buffer\[1\]\[0\] VGND VGND VPWR VPWR net483 sky130_fd_sc_hd__dlygate4sd3_1
Xhold418 u_pe_array.u_fifo1.buffer\[1\]\[2\] VGND VGND VPWR VPWR net494 sky130_fd_sc_hd__dlygate4sd3_1
X_4470_ u_pe_array.g_pe_row\[2\].g_pe_col\[2\].u_pe.psum_out\[2\] _1547_ VGND VGND
+ VPWR VPWR _1548_ sky130_fd_sc_hd__xnor2_1
XFILLER_0_40_314 VGND VGND VPWR VPWR sky130_fd_sc_hd__decap_4
Xhold429 u_pe_array.u_fifo1.buffer\[6\]\[1\] VGND VGND VPWR VPWR net505 sky130_fd_sc_hd__dlygate4sd3_1
X_6140_ _2933_ _2934_ _2940_ _2928_ _2946_ VGND VGND VPWR VPWR _2947_ sky130_fd_sc_hd__a32o_1
XFILLER_0_0_433 VGND VGND VPWR VPWR sky130_fd_sc_hd__fill_2
XTAP_701 VGND VPWR sky130_fd_sc_hd__tapvpwrvgnd_1
XFILLER_0_110_268 VPWR VGND VPWR VGND sky130_ef_sc_hd__decap_12
XFILLER_0_21_594 VGND VGND VPWR VPWR sky130_fd_sc_hd__fill_2
XTAP_723 VGND VPWR sky130_fd_sc_hd__tapvpwrvgnd_1
XTAP_712 VGND VPWR sky130_fd_sc_hd__tapvpwrvgnd_1
XTAP_734 VGND VPWR sky130_fd_sc_hd__tapvpwrvgnd_1
X_6071_ _2882_ _2883_ VGND VGND VPWR VPWR _2884_ sky130_fd_sc_hd__xnor2_1
XANTENNA__5475__B1 _0885_ VGND VGND VPWR VPWR sky130_fd_sc_hd__diode_2
XTAP_767 VGND VPWR sky130_fd_sc_hd__tapvpwrvgnd_1
XFILLER_0_0_499 VGND VGND VPWR VPWR sky130_fd_sc_hd__decap_4
XFILLER_0_29_63 VGND VGND VPWR VPWR sky130_fd_sc_hd__fill_1
XANTENNA__6934__RESET_B net819 VGND VGND VPWR VPWR sky130_fd_sc_hd__diode_2
XTAP_745 VGND VPWR sky130_fd_sc_hd__tapvpwrvgnd_1
XTAP_756 VGND VPWR sky130_fd_sc_hd__tapvpwrvgnd_1
XTAP_789 VGND VPWR sky130_fd_sc_hd__tapvpwrvgnd_1
XTAP_778 VGND VPWR sky130_fd_sc_hd__tapvpwrvgnd_1
X_5022_ u_pe_array.u_fifo2.buffer\[4\]\[5\] _1965_ _1966_ u_pe_array.u_fifo2.buffer\[7\]\[5\]
+ VGND VGND VPWR VPWR _2013_ sky130_fd_sc_hd__a22o_1
X_6973_ clknet_leaf_92_clk _0052_ net819 VGND VGND VPWR VPWR u_pe_array.g_pe_row\[3\].g_pe_col\[2\].u_pe.psum_out\[0\]
+ sky130_fd_sc_hd__dfrtp_1
XFILLER_0_75_200 VGND VGND VPWR VPWR sky130_fd_sc_hd__fill_1
XANTENNA__3789__B1 _0837_ VGND VGND VPWR VPWR sky130_fd_sc_hd__diode_2
X_5924_ u_pe_array.g_pe_row\[0\].g_pe_col\[2\].u_pe.act_val\[2\] VGND VGND VPWR VPWR
+ _2764_ sky130_fd_sc_hd__inv_2
XFILLER_0_75_233 VPWR VGND VPWR VGND sky130_ef_sc_hd__decap_12
XANTENNA__4450__B2 _1399_ VGND VGND VPWR VPWR sky130_fd_sc_hd__diode_2
XFILLER_0_36_609 VGND VGND VPWR VPWR sky130_fd_sc_hd__fill_1
X_5855_ _2713_ _2714_ VGND VGND VPWR VPWR _2715_ sky130_fd_sc_hd__or2_1
X_4806_ u_pe_array.g_pe_row\[1\].g_pe_col\[2\].u_pe.act_val\[2\] u_pe_array.g_pe_row\[1\].g_pe_col\[2\].u_pe.psum_out\[2\]
+ _0756_ VGND VGND VPWR VPWR _1828_ sky130_fd_sc_hd__mux2_1
XFILLER_0_8_533 VPWR VGND VPWR VGND sky130_ef_sc_hd__decap_12
XFILLER_0_0_97 VPWR VGND VPWR VGND sky130_ef_sc_hd__decap_12
X_5786_ _2651_ _2652_ net716 _0875_ VGND VGND VPWR VPWR _0377_ sky130_fd_sc_hd__a2bb2o_1
XFILLER_0_71_461 VGND VGND VPWR VPWR sky130_fd_sc_hd__decap_3
X_4737_ _1776_ _1777_ VGND VGND VPWR VPWR _1778_ sky130_fd_sc_hd__or2_1
X_7525_ clknet_leaf_7_clk _0574_ VGND VGND VPWR VPWR u_pe_array.u_fifo2.buffer\[6\]\[12\]
+ sky130_fd_sc_hd__dfxtp_1
X_4668_ u_pe_array.g_pe_row\[2\].g_pe_col\[1\].u_pe.act_val\[4\] _1672_ VGND VGND
+ VPWR VPWR _1715_ sky130_fd_sc_hd__and2b_1
XFILLER_0_16_399 VGND VGND VPWR VPWR sky130_fd_sc_hd__decap_3
X_7456_ clknet_leaf_0_clk _0505_ VGND VGND VPWR VPWR u_pe_array.u_fifo2.buffer\[1\]\[8\]
+ sky130_fd_sc_hd__dfxtp_1
X_3619_ net729 _0834_ _0837_ _0847_ VGND VGND VPWR VPWR _0015_ sky130_fd_sc_hd__a22o_1
X_6407_ net407 _1788_ _3166_ VGND VGND VPWR VPWR _3167_ sky130_fd_sc_hd__mux2_1
X_7387_ clknet_leaf_47_clk _0440_ net817 VGND VGND VPWR VPWR u_pe_array.g_pe_row\[0\].g_pe_col\[1\].u_pe.psum_out\[11\]
+ sky130_fd_sc_hd__dfrtp_1
X_4599_ net386 net175 _0855_ VGND VGND VPWR VPWR _1658_ sky130_fd_sc_hd__mux2_1
XFILLER_0_3_293 VPWR VGND VPWR VGND sky130_ef_sc_hd__decap_12
XFILLER_0_101_279 VGND VGND VPWR VPWR sky130_fd_sc_hd__fill_1
X_6338_ _3118_ net565 _3110_ VGND VGND VPWR VPWR _3119_ sky130_fd_sc_hd__mux2_1
X_6269_ u_pe_array.g_pe_row\[0\].g_pe_col\[0\].u_pe.psum_out\[7\] _2992_ VGND VGND
+ VPWR VPWR _3060_ sky130_fd_sc_hd__or2_1
XFILLER_0_79_561 VGND VGND VPWR VPWR sky130_fd_sc_hd__decap_3
XANTENNA__5618__A2_N u_pe_array.g_pe_row\[1\].g_pe_col\[0\].u_pe.w_reg\[0\] VGND VGND
+ VPWR VPWR sky130_fd_sc_hd__diode_2
XFILLER_0_66_200 VGND VGND VPWR VPWR sky130_fd_sc_hd__decap_8
XANTENNA__5975__B _2743_ VGND VGND VPWR VPWR sky130_fd_sc_hd__diode_2
XFILLER_0_109_335 VGND VGND VPWR VPWR sky130_fd_sc_hd__fill_1
XANTENNA__6152__A _2873_ VGND VGND VPWR VPWR sky130_fd_sc_hd__diode_2
XFILLER_0_94_586 VGND VGND VPWR VPWR sky130_fd_sc_hd__fill_2
XANTENNA__6194__A1 _2740_ VGND VGND VPWR VPWR sky130_fd_sc_hd__diode_2
XFILLER_0_81_247 VGND VGND VPWR VPWR sky130_fd_sc_hd__decap_4
XFILLER_0_66_299 VGND VGND VPWR VPWR sky130_fd_sc_hd__fill_1
XFILLER_0_81_269 VGND VGND VPWR VPWR sky130_fd_sc_hd__fill_2
XFILLER_0_35_664 VGND VGND VPWR VPWR sky130_fd_sc_hd__fill_1
XANTENNA__3952__A0 net17 VGND VGND VPWR VPWR sky130_fd_sc_hd__diode_2
XFILLER_0_50_612 VGND VGND VPWR VPWR sky130_fd_sc_hd__fill_2
XFILLER_0_105_585 VGND VGND VPWR VPWR sky130_fd_sc_hd__decap_4
XFILLER_0_50_645 VGND VGND VPWR VPWR sky130_fd_sc_hd__fill_2
XFILLER_0_22_369 VGND VGND VPWR VPWR sky130_fd_sc_hd__fill_2
XANTENNA__4400__A _1407_ VGND VGND VPWR VPWR sky130_fd_sc_hd__diode_2
XANTENNA__3483__A2 _0745_ VGND VGND VPWR VPWR sky130_fd_sc_hd__diode_2
XFILLER_0_89_358 VPWR VGND VPWR VGND sky130_ef_sc_hd__decap_12
XFILLER_0_77_509 VGND VGND VPWR VPWR sky130_fd_sc_hd__fill_2
X_3970_ net109 _0996_ _1137_ _1004_ VGND VGND VPWR VPWR _0076_ sky130_fd_sc_hd__a22o_1
XFILLER_0_97_391 VGND VGND VPWR VPWR sky130_fd_sc_hd__fill_1
XFILLER_0_57_233 VGND VGND VPWR VPWR sky130_fd_sc_hd__decap_3
X_5640_ _2532_ u_pe_array.g_pe_row\[1\].g_pe_col\[0\].u_pe.psum_out\[6\] _2478_ VGND
+ VGND VPWR VPWR _2533_ sky130_fd_sc_hd__nand3_2
XFILLER_0_31_31 VGND VGND VPWR VPWR sky130_fd_sc_hd__decap_4
XANTENNA__7133__RESET_B net76 VGND VGND VPWR VPWR sky130_fd_sc_hd__diode_2
X_5571_ u_pe_array.g_pe_row\[1\].g_pe_col\[3\].u_pe.psum_out\[10\] u_pe_array.g_pe_row\[1\].g_pe_col\[3\].u_pe.move_reg\[10\]
+ _2469_ VGND VGND VPWR VPWR _2473_ sky130_fd_sc_hd__mux2_1
XFILLER_0_26_653 VGND VGND VPWR VPWR sky130_fd_sc_hd__fill_2
XFILLER_0_26_675 VGND VGND VPWR VPWR sky130_fd_sc_hd__fill_2
X_4522_ _1594_ _1595_ VGND VGND VPWR VPWR _1596_ sky130_fd_sc_hd__nor2_1
X_7310_ clknet_leaf_66_clk net245 net814 VGND VGND VPWR VPWR u_pe_array.g_pe_row\[0\].g_pe_col\[2\].u_pe.move_reg\[9\]
+ sky130_fd_sc_hd__dfrtp_1
Xhold226 u_pe_array.u_fifo1.buffer\[0\]\[6\] VGND VGND VPWR VPWR net302 sky130_fd_sc_hd__dlygate4sd3_1
Xhold204 u_pe_array.u_fifo1.buffer\[3\]\[12\] VGND VGND VPWR VPWR net280 sky130_fd_sc_hd__dlygate4sd3_1
X_7241_ clknet_leaf_39_clk _0304_ net813 VGND VGND VPWR VPWR u_pe_array.g_pe_row\[1\].g_pe_col\[0\].u_pe.act_val\[0\]
+ sky130_fd_sc_hd__dfrtp_4
Xhold215 u_fsm.state\[1\] VGND VGND VPWR VPWR net291 sky130_fd_sc_hd__dlygate4sd3_1
X_4453_ _1532_ VGND VGND VPWR VPWR _1533_ sky130_fd_sc_hd__inv_2
Xhold237 u_pe_array.u_fifo1.buffer\[6\]\[6\] VGND VGND VPWR VPWR net313 sky130_fd_sc_hd__dlygate4sd3_1
Xhold248 u_pe_array.u_fifo1.buffer\[8\]\[6\] VGND VGND VPWR VPWR net324 sky130_fd_sc_hd__dlygate4sd3_1
Xhold259 u_pe_array.u_fifo2.buffer\[1\]\[7\] VGND VGND VPWR VPWR net335 sky130_fd_sc_hd__dlygate4sd3_1
XFILLER_0_13_369 VPWR VGND VPWR VGND sky130_ef_sc_hd__decap_12
XANTENNA__3625__S _0734_ VGND VGND VPWR VPWR sky130_fd_sc_hd__diode_2
XFILLER_0_40_166 VGND VGND VPWR VPWR sky130_fd_sc_hd__decap_4
X_7172_ clknet_leaf_42_clk _0239_ net817 VGND VGND VPWR VPWR u_pe_array.g_pe_row\[2\].g_pe_col\[0\].u_pe.psum_out\[6\]
+ sky130_fd_sc_hd__dfrtp_1
XFILLER_0_0_263 VGND VGND VPWR VPWR sky130_fd_sc_hd__decap_8
X_4384_ _1407_ u_pe_array.g_pe_row\[2\].g_pe_col\[3\].u_pe.psum_out\[7\] _1482_ _1483_
+ VGND VGND VPWR VPWR _1484_ sky130_fd_sc_hd__a22oi_1
X_6123_ _2930_ _2926_ VGND VGND VPWR VPWR _2932_ sky130_fd_sc_hd__and2b_1
XTAP_520 VGND VPWR sky130_fd_sc_hd__tapvpwrvgnd_1
XTAP_531 VGND VPWR sky130_fd_sc_hd__tapvpwrvgnd_1
XTAP_542 VGND VPWR sky130_fd_sc_hd__tapvpwrvgnd_1
X_6054_ u_pe_array.g_pe_row\[0\].g_pe_col\[1\].u_pe.w_reg\[0\] u_pe_array.g_pe_row\[0\].g_pe_col\[1\].u_pe.act_val\[0\]
+ u_pe_array.g_pe_row\[0\].g_pe_col\[1\].u_pe.psum_out\[0\] VGND VGND VPWR VPWR _2869_
+ sky130_fd_sc_hd__a21o_1
XTAP_553 VGND VPWR sky130_fd_sc_hd__tapvpwrvgnd_1
XTAP_575 VGND VPWR sky130_fd_sc_hd__tapvpwrvgnd_1
XTAP_564 VGND VPWR sky130_fd_sc_hd__tapvpwrvgnd_1
XTAP_586 VGND VPWR sky130_fd_sc_hd__tapvpwrvgnd_1
XTAP_597 VGND VPWR sky130_fd_sc_hd__tapvpwrvgnd_1
X_5005_ u_pe_array.u_fifo2.buffer\[5\]\[3\] _1971_ _1972_ u_pe_array.u_fifo2.buffer\[1\]\[3\]
+ _1973_ VGND VGND VPWR VPWR _1998_ sky130_fd_sc_hd__a221o_1
XFILLER_0_22_3 VGND VGND VPWR VPWR sky130_fd_sc_hd__decap_3
X_6956_ clknet_leaf_87_clk _0037_ net819 VGND VGND VPWR VPWR u_pe_array.g_pe_row\[3\].g_pe_col\[2\].u_pe.w_buffer\[0\]
+ sky130_fd_sc_hd__dfrtp_1
XFILLER_0_76_542 VGND VGND VPWR VPWR sky130_fd_sc_hd__fill_2
X_5907_ u_pe_array.g_pe_row\[0\].g_pe_col\[2\].u_pe.act_val\[1\] u_pe_array.g_pe_row\[0\].g_pe_col\[2\].u_pe.w_reg\[0\]
+ _2746_ _2747_ VGND VGND VPWR VPWR _2749_ sky130_fd_sc_hd__nand4_1
X_6887_ _3426_ VGND VGND VPWR VPWR _3427_ sky130_fd_sc_hd__buf_4
XFILLER_0_48_277 VGND VGND VPWR VPWR sky130_fd_sc_hd__fill_2
XFILLER_0_36_417 VGND VGND VPWR VPWR sky130_fd_sc_hd__decap_3
XFILLER_0_106_305 VGND VGND VPWR VPWR sky130_fd_sc_hd__fill_1
XFILLER_0_63_225 VGND VGND VPWR VPWR sky130_fd_sc_hd__fill_2
XFILLER_0_29_480 VGND VGND VPWR VPWR sky130_fd_sc_hd__decap_6
X_5838_ _2690_ _2693_ _2698_ VGND VGND VPWR VPWR _2700_ sky130_fd_sc_hd__or3_1
XFILLER_0_106_338 VGND VGND VPWR VPWR sky130_fd_sc_hd__fill_2
X_5769_ _2634_ _2636_ VGND VGND VPWR VPWR _2637_ sky130_fd_sc_hd__nor2_1
X_7508_ clknet_leaf_0_clk _0557_ VGND VGND VPWR VPWR u_pe_array.u_fifo2.buffer\[5\]\[8\]
+ sky130_fd_sc_hd__dfxtp_1
XFILLER_0_114_371 VGND VGND VPWR VPWR sky130_fd_sc_hd__fill_1
XFILLER_0_114_393 VPWR VGND VPWR VGND sky130_ef_sc_hd__decap_12
XFILLER_0_102_533 VGND VGND VPWR VPWR sky130_fd_sc_hd__decap_4
X_7439_ clknet_leaf_2_clk _0488_ VGND VGND VPWR VPWR u_pe_array.u_fifo2.buffer\[0\]\[4\]
+ sky130_fd_sc_hd__dfxtp_1
XFILLER_0_31_177 VGND VGND VPWR VPWR sky130_fd_sc_hd__fill_2
XFILLER_0_102_566 VGND VGND VPWR VPWR sky130_fd_sc_hd__decap_3
XANTENNA__6846__S _3397_ VGND VGND VPWR VPWR sky130_fd_sc_hd__diode_2
XFILLER_0_99_601 VGND VGND VPWR VPWR sky130_fd_sc_hd__decap_3
XANTENNA__6581__S _3254_ VGND VGND VPWR VPWR sky130_fd_sc_hd__diode_2
XANTENNA__4414__A1 _1273_ VGND VGND VPWR VPWR sky130_fd_sc_hd__diode_2
XFILLER_0_39_222 VGND VGND VPWR VPWR sky130_fd_sc_hd__fill_2
XFILLER_0_94_361 VGND VGND VPWR VPWR sky130_fd_sc_hd__decap_3
XFILLER_0_82_501 VGND VGND VPWR VPWR sky130_fd_sc_hd__decap_3
XANTENNA__5197__S _1661_ VGND VGND VPWR VPWR sky130_fd_sc_hd__diode_2
XFILLER_0_39_255 VGND VGND VPWR VPWR sky130_fd_sc_hd__fill_1
XFILLER_0_109_187 VGND VGND VPWR VPWR sky130_fd_sc_hd__decap_4
XFILLER_0_54_258 VGND VGND VPWR VPWR sky130_fd_sc_hd__decap_4
XFILLER_0_10_317 VGND VGND VPWR VPWR sky130_fd_sc_hd__decap_3
XFILLER_0_93_15 VGND VGND VPWR VPWR sky130_fd_sc_hd__decap_6
XANTENNA__4102__B1 _0887_ VGND VGND VPWR VPWR sky130_fd_sc_hd__diode_2
XANTENNA__4276__S _0769_ VGND VGND VPWR VPWR sky130_fd_sc_hd__diode_2
XANTENNA__7385__RESET_B net13 VGND VGND VPWR VPWR sky130_fd_sc_hd__diode_2
XFILLER_0_89_166 VGND VGND VPWR VPWR sky130_fd_sc_hd__fill_2
X_6810_ net445 _3116_ _3382_ VGND VGND VPWR VPWR _3386_ sky130_fd_sc_hd__mux2_1
XFILLER_0_77_306 VGND VGND VPWR VPWR sky130_fd_sc_hd__fill_2
XFILLER_0_9_105 VGND VGND VPWR VPWR sky130_fd_sc_hd__fill_1
X_6741_ net361 _3130_ net64 VGND VGND VPWR VPWR _3349_ sky130_fd_sc_hd__mux2_1
X_3953_ net656 _0996_ _0837_ _1127_ VGND VGND VPWR VPWR _0069_ sky130_fd_sc_hd__a22o_1
XFILLER_0_58_564 VGND VGND VPWR VPWR sky130_fd_sc_hd__fill_1
XANTENNA__7314__RESET_B net814 VGND VGND VPWR VPWR sky130_fd_sc_hd__diode_2
X_6672_ _3308_ _3309_ VGND VGND VPWR VPWR _0606_ sky130_fd_sc_hd__nor2_1
XFILLER_0_45_225 VGND VGND VPWR VPWR sky130_fd_sc_hd__decap_3
X_3884_ _1068_ _1069_ VGND VGND VPWR VPWR _1070_ sky130_fd_sc_hd__or2_2
XFILLER_0_42_85 VGND VGND VPWR VPWR sky130_fd_sc_hd__decap_4
X_5623_ _2516_ _2517_ VGND VGND VPWR VPWR _2518_ sky130_fd_sc_hd__nand2_1
XFILLER_0_5_311 VGND VGND VPWR VPWR sky130_fd_sc_hd__fill_2
XFILLER_0_26_450 VGND VGND VPWR VPWR sky130_fd_sc_hd__fill_2
XFILLER_0_14_645 VPWR VGND VPWR VGND sky130_ef_sc_hd__decap_12
X_5554_ u_pe_array.g_pe_row\[1\].g_pe_col\[3\].u_pe.psum_out\[2\] u_pe_array.g_pe_row\[1\].g_pe_col\[3\].u_pe.act_val\[2\]
+ _0769_ VGND VGND VPWR VPWR _2464_ sky130_fd_sc_hd__mux2_1
X_5485_ _2404_ _2405_ VGND VGND VPWR VPWR _2406_ sky130_fd_sc_hd__nor2_1
X_4505_ _1578_ _1579_ VGND VGND VPWR VPWR _1580_ sky130_fd_sc_hd__xnor2_1
XFILLER_0_13_177 VGND VGND VPWR VPWR sky130_fd_sc_hd__fill_2
X_4436_ u_pe_array.g_pe_row\[3\].g_pe_col\[1\].u_pe.psum_out\[6\] net135 _0855_ VGND
+ VGND VPWR VPWR _1523_ sky130_fd_sc_hd__mux2_1
X_7224_ clknet_leaf_61_clk net92 net73 VGND VGND VPWR VPWR u_pe_array.g_pe_row\[1\].g_pe_col\[2\].u_pe.w_reg\[0\]
+ sky130_fd_sc_hd__dfrtp_4
XFILLER_0_6_41 VPWR VGND VPWR VGND sky130_ef_sc_hd__decap_12
XFILLER_0_1_561 VGND VGND VPWR VPWR sky130_fd_sc_hd__fill_1
XFILLER_0_111_385 VGND VGND VPWR VPWR sky130_fd_sc_hd__fill_2
X_4367_ _1454_ _1467_ _1460_ VGND VGND VPWR VPWR _1469_ sky130_fd_sc_hd__nor3_1
X_7155_ clknet_leaf_74_clk _0224_ net814 VGND VGND VPWR VPWR u_pe_array.g_pe_row\[1\].g_pe_col\[3\].u_pe.act_val\[4\]
+ sky130_fd_sc_hd__dfrtp_1
X_6106_ u_pe_array.g_pe_row\[0\].g_pe_col\[1\].u_pe.w_reg\[0\] u_pe_array.g_pe_row\[0\].g_pe_col\[1\].u_pe.act_val\[5\]
+ VGND VGND VPWR VPWR _2916_ sky130_fd_sc_hd__nand2_1
XTAP_350 VGND VPWR sky130_fd_sc_hd__tapvpwrvgnd_1
XFILLER_0_6_85 VPWR VGND VPWR VGND sky130_ef_sc_hd__decap_12
X_7086_ clknet_leaf_12_clk _0159_ net816 VGND VGND VPWR VPWR u_pe_array.g_pe_row\[2\].g_pe_col\[1\].u_pe.move_reg\[8\]
+ sky130_fd_sc_hd__dfrtp_1
X_4298_ u_pe_array.g_pe_row\[2\].g_pe_col\[3\].u_pe.w_reg\[0\] u_pe_array.g_pe_row\[2\].g_pe_col\[3\].u_pe.act_val\[0\]
+ u_pe_array.g_pe_row\[2\].g_pe_col\[3\].u_pe.psum_out\[0\] VGND VGND VPWR VPWR _1406_
+ sky130_fd_sc_hd__nand3_1
XTAP_383 VGND VPWR sky130_fd_sc_hd__tapvpwrvgnd_1
XTAP_372 VGND VPWR sky130_fd_sc_hd__tapvpwrvgnd_1
XTAP_361 VGND VPWR sky130_fd_sc_hd__tapvpwrvgnd_1
XTAP_394 VGND VPWR sky130_fd_sc_hd__tapvpwrvgnd_1
X_6037_ net651 _2738_ _2592_ _2860_ VGND VGND VPWR VPWR _0420_ sky130_fd_sc_hd__a22o_1
XTAP_1505 VGND VPWR sky130_fd_sc_hd__tapvpwrvgnd_1
XPHY_12 VGND VGND VPWR VPWR sky130_fd_sc_hd__decap_3
XTAP_1538 VGND VPWR sky130_fd_sc_hd__tapvpwrvgnd_1
XTAP_1527 VGND VPWR sky130_fd_sc_hd__tapvpwrvgnd_1
XTAP_1516 VGND VPWR sky130_fd_sc_hd__tapvpwrvgnd_1
XFILLER_0_49_520 VGND VGND VPWR VPWR sky130_fd_sc_hd__fill_2
XPHY_23 VGND VGND VPWR VPWR sky130_fd_sc_hd__decap_3
XPHY_34 VGND VGND VPWR VPWR sky130_fd_sc_hd__decap_3
XPHY_45 VGND VGND VPWR VPWR sky130_fd_sc_hd__decap_3
XPHY_56 VGND VGND VPWR VPWR sky130_fd_sc_hd__decap_3
XTAP_1549 VGND VPWR sky130_fd_sc_hd__tapvpwrvgnd_1
XFILLER_0_76_361 VGND VGND VPWR VPWR sky130_fd_sc_hd__decap_3
XPHY_89 VGND VGND VPWR VPWR sky130_fd_sc_hd__decap_3
XANTENNA__7055__RESET_B net819 VGND VGND VPWR VPWR sky130_fd_sc_hd__diode_2
XPHY_67 VGND VGND VPWR VPWR sky130_fd_sc_hd__decap_3
X_6939_ clknet_leaf_85_clk _0022_ net74 VGND VGND VPWR VPWR u_pe_array.g_pe_row\[3\].g_pe_col\[2\].u_pe.move_reg\[11\]
+ sky130_fd_sc_hd__dfrtp_1
XPHY_78 VGND VGND VPWR VPWR sky130_fd_sc_hd__decap_3
XFILLER_0_76_394 VGND VGND VPWR VPWR sky130_fd_sc_hd__fill_2
XFILLER_0_64_545 VGND VGND VPWR VPWR sky130_fd_sc_hd__fill_1
XFILLER_0_64_523 VGND VGND VPWR VPWR sky130_fd_sc_hd__fill_2
XFILLER_0_51_206 VGND VGND VPWR VPWR sky130_fd_sc_hd__fill_1
XFILLER_0_32_431 VGND VGND VPWR VPWR sky130_fd_sc_hd__fill_2
XFILLER_0_114_190 VGND VGND VPWR VPWR sky130_fd_sc_hd__decap_4
XFILLER_0_102_363 VGND VGND VPWR VPWR sky130_fd_sc_hd__fill_1
Xhold590 u_pe_array.g_pe_row\[1\].g_pe_col\[2\].u_pe.psum_out\[5\] VGND VGND VPWR
+ VPWR net666 sky130_fd_sc_hd__dlygate4sd3_1
XFILLER_0_87_615 VGND VGND VPWR VPWR sky130_fd_sc_hd__fill_1
XFILLER_0_59_317 VGND VGND VPWR VPWR sky130_fd_sc_hd__fill_2
XFILLER_0_86_158 VGND VGND VPWR VPWR sky130_fd_sc_hd__decap_4
XFILLER_0_7_609 VGND VGND VPWR VPWR sky130_fd_sc_hd__decap_6
XFILLER_0_103_57 VGND VGND VPWR VPWR sky130_fd_sc_hd__decap_3
XANTENNA__3610__A2 _0834_ VGND VGND VPWR VPWR sky130_fd_sc_hd__diode_2
XFILLER_0_27_258 VGND VGND VPWR VPWR sky130_fd_sc_hd__fill_1
XFILLER_0_27_269 VGND VGND VPWR VPWR sky130_fd_sc_hd__decap_4
XFILLER_0_82_375 VGND VGND VPWR VPWR sky130_fd_sc_hd__fill_2
XFILLER_0_113_617 VPWR VGND VPWR VGND sky130_ef_sc_hd__decap_12
XFILLER_0_23_442 VGND VGND VPWR VPWR sky130_fd_sc_hd__fill_2
XFILLER_0_23_453 VGND VGND VPWR VPWR sky130_fd_sc_hd__fill_2
X_5270_ _2199_ _2208_ VGND VGND VPWR VPWR _2219_ sky130_fd_sc_hd__and2_1
X_4221_ _1335_ _1336_ _1342_ _1330_ _1348_ VGND VGND VPWR VPWR _1349_ sky130_fd_sc_hd__a32o_1
XANTENNA__6068__B1_N _2873_ VGND VGND VPWR VPWR sky130_fd_sc_hd__diode_2
X_4152_ _1284_ _1285_ VGND VGND VPWR VPWR _1286_ sky130_fd_sc_hd__xnor2_1
X_4083_ _1145_ u_pe_array.g_pe_row\[3\].g_pe_col\[1\].u_pe.psum_out\[10\] VGND VGND
+ VPWR VPWR _1237_ sky130_fd_sc_hd__or2_1
XFILLER_0_86_670 VGND VGND VPWR VPWR sky130_fd_sc_hd__fill_2
X_4985_ u_pe_array.u_fifo2.buffer\[0\]\[1\] _1962_ VGND VGND VPWR VPWR _1980_ sky130_fd_sc_hd__or2_1
X_6724_ _3340_ VGND VGND VPWR VPWR _0627_ sky130_fd_sc_hd__clkbuf_1
XFILLER_0_92_128 VGND VGND VPWR VPWR sky130_fd_sc_hd__decap_3
XFILLER_0_58_372 VGND VGND VPWR VPWR sky130_fd_sc_hd__fill_1
XANTENNA__6394__A4 _1787_ VGND VGND VPWR VPWR sky130_fd_sc_hd__diode_2
XFILLER_0_46_512 VGND VGND VPWR VPWR sky130_fd_sc_hd__decap_3
X_3936_ u_pe_array.g_pe_row\[3\].g_pe_col\[2\].u_pe.psum_out\[9\] u_pe_array.g_pe_row\[3\].g_pe_col\[2\].u_pe.psum_out\[10\]
+ _1009_ VGND VGND VPWR VPWR _1116_ sky130_fd_sc_hd__o21a_1
XFILLER_0_73_353 VGND VGND VPWR VPWR sky130_fd_sc_hd__fill_2
XFILLER_0_18_258 VGND VGND VPWR VPWR sky130_fd_sc_hd__fill_2
X_6655_ _3106_ _3296_ VGND VGND VPWR VPWR _3298_ sky130_fd_sc_hd__nand2_1
XANTENNA__5565__S _2469_ VGND VGND VPWR VPWR sky130_fd_sc_hd__diode_2
X_3867_ u_pe_array.g_pe_row\[3\].g_pe_col\[2\].u_pe.act_val\[4\] _1009_ VGND VGND
+ VPWR VPWR _1054_ sky130_fd_sc_hd__and2b_1
XFILLER_0_103_105 VGND VGND VPWR VPWR sky130_fd_sc_hd__fill_2
X_5606_ _2500_ _2501_ VGND VGND VPWR VPWR _2502_ sky130_fd_sc_hd__nor2_1
X_3798_ _0743_ _0997_ _0754_ VGND VGND VPWR VPWR _0998_ sky130_fd_sc_hd__mux2_1
X_6586_ _3261_ VGND VGND VPWR VPWR _0568_ sky130_fd_sc_hd__clkbuf_1
X_5537_ _2444_ _2447_ _2452_ VGND VGND VPWR VPWR _2453_ sky130_fd_sc_hd__o21ai_1
XFILLER_0_14_464 VPWR VGND VPWR VGND sky130_ef_sc_hd__decap_12
XFILLER_0_78_81 VGND VGND VPWR VPWR sky130_fd_sc_hd__decap_3
X_5468_ _2388_ _2389_ VGND VGND VPWR VPWR _2390_ sky130_fd_sc_hd__xnor2_1
X_7207_ clknet_leaf_70_clk _0272_ net814 VGND VGND VPWR VPWR u_pe_array.g_pe_row\[1\].g_pe_col\[3\].u_pe.psum_out\[11\]
+ sky130_fd_sc_hd__dfrtp_1
X_5399_ u_pe_array.g_pe_row\[0\].g_pe_col\[0\].u_pe.psum_out\[6\] u_pe_array.g_pe_row\[0\].g_pe_col\[0\].u_pe.move_reg\[6\]
+ _1661_ VGND VGND VPWR VPWR _2333_ sky130_fd_sc_hd__mux2_1
XANTENNA__3813__S _0734_ VGND VGND VPWR VPWR sky130_fd_sc_hd__diode_2
XFILLER_0_1_391 VGND VGND VPWR VPWR sky130_fd_sc_hd__fill_1
X_4419_ net430 _1152_ _0887_ _1514_ VGND VGND VPWR VPWR _0148_ sky130_fd_sc_hd__a22o_1
X_7138_ clknet_leaf_3_clk _0207_ VGND VGND VPWR VPWR u_pe_array.u_fifo2.buffer\[8\]\[2\]
+ sky130_fd_sc_hd__dfxtp_1
X_7069_ clknet_leaf_89_clk _0142_ net74 VGND VGND VPWR VPWR u_pe_array.g_pe_row\[2\].g_pe_col\[3\].u_pe.psum_out\[6\]
+ sky130_fd_sc_hd__dfrtp_1
XANTENNA__7236__RESET_B net812 VGND VGND VPWR VPWR sky130_fd_sc_hd__diode_2
XFILLER_0_96_445 VGND VGND VPWR VPWR sky130_fd_sc_hd__decap_4
XTAP_1313 VGND VPWR sky130_fd_sc_hd__tapvpwrvgnd_1
XTAP_1302 VGND VPWR sky130_fd_sc_hd__tapvpwrvgnd_1
XTAP_1357 VGND VPWR sky130_fd_sc_hd__tapvpwrvgnd_1
XTAP_1346 VGND VPWR sky130_fd_sc_hd__tapvpwrvgnd_1
XTAP_1335 VGND VPWR sky130_fd_sc_hd__tapvpwrvgnd_1
XTAP_1324 VGND VPWR sky130_fd_sc_hd__tapvpwrvgnd_1
XFILLER_0_56_309 VGND VGND VPWR VPWR sky130_fd_sc_hd__fill_2
XFILLER_0_49_350 VGND VGND VPWR VPWR sky130_fd_sc_hd__fill_2
XTAP_1379 VGND VPWR sky130_fd_sc_hd__tapvpwrvgnd_1
XTAP_1368 VGND VPWR sky130_fd_sc_hd__tapvpwrvgnd_1
XFILLER_0_83_128 VGND VGND VPWR VPWR sky130_fd_sc_hd__decap_3
XFILLER_0_83_117 VGND VGND VPWR VPWR sky130_fd_sc_hd__fill_2
XFILLER_0_49_383 VGND VGND VPWR VPWR sky130_fd_sc_hd__fill_2
XFILLER_0_49_372 VGND VGND VPWR VPWR sky130_fd_sc_hd__fill_2
XFILLER_0_9_480 VPWR VGND VPWR VGND sky130_ef_sc_hd__decap_12
XFILLER_0_107_455 VGND VGND VPWR VPWR sky130_fd_sc_hd__fill_1
XFILLER_0_107_444 VGND VGND VPWR VPWR sky130_fd_sc_hd__decap_4
Xinput19 v_in0[4] VGND VGND VPWR VPWR net19 sky130_fd_sc_hd__clkbuf_4
XFILLER_0_58_29 VPWR VGND VPWR VGND sky130_ef_sc_hd__decap_12
XFILLER_0_20_467 VGND VGND VPWR VPWR sky130_fd_sc_hd__fill_1
XANTENNA__5504__A _2345_ VGND VGND VPWR VPWR sky130_fd_sc_hd__diode_2
XANTENNA_output37_A net37 VGND VGND VPWR VPWR sky130_fd_sc_hd__diode_2
XFILLER_0_87_401 VGND VGND VPWR VPWR sky130_fd_sc_hd__decap_4
XFILLER_0_87_456 VGND VGND VPWR VPWR sky130_fd_sc_hd__fill_2
XFILLER_0_59_169 VGND VGND VPWR VPWR sky130_fd_sc_hd__decap_3
XANTENNA__6959__RESET_B net816 VGND VGND VPWR VPWR sky130_fd_sc_hd__diode_2
XANTENNA__5033__B2 _1665_ VGND VGND VPWR VPWR sky130_fd_sc_hd__diode_2
XFILLER_0_114_78 VGND VGND VPWR VPWR sky130_fd_sc_hd__decap_6
X_4770_ _1804_ net573 _1796_ VGND VGND VPWR VPWR _1805_ sky130_fd_sc_hd__mux2_1
XFILLER_0_83_673 VGND VGND VPWR VPWR sky130_fd_sc_hd__fill_2
X_3721_ _0912_ _0924_ VGND VGND VPWR VPWR _0935_ sky130_fd_sc_hd__and2_1
XFILLER_0_28_578 VGND VGND VPWR VPWR sky130_fd_sc_hd__decap_3
XFILLER_0_28_589 VGND VGND VPWR VPWR sky130_fd_sc_hd__fill_2
XFILLER_0_43_548 VGND VGND VPWR VPWR sky130_fd_sc_hd__fill_1
X_3652_ _0868_ _0870_ VGND VGND VPWR VPWR _0871_ sky130_fd_sc_hd__xor2_1
XANTENNA__6533__A1 _1812_ VGND VGND VPWR VPWR sky130_fd_sc_hd__diode_2
X_6440_ net467 _1802_ net69 VGND VGND VPWR VPWR _3184_ sky130_fd_sc_hd__mux2_1
XFILLER_0_113_447 VGND VGND VPWR VPWR sky130_fd_sc_hd__fill_1
X_6371_ _3140_ _3138_ _3141_ _1791_ VGND VGND VPWR VPWR _0473_ sky130_fd_sc_hd__o2bb2a_1
X_3583_ u_fsm.v_cnt\[0\] _0820_ VGND VGND VPWR VPWR _0821_ sky130_fd_sc_hd__and2_1
XANTENNA__4302__B _1407_ VGND VGND VPWR VPWR sky130_fd_sc_hd__diode_2
X_5322_ u_pe_array.g_pe_row\[1\].g_pe_col\[2\].u_pe.psum_out\[9\] u_pe_array.g_pe_row\[1\].g_pe_col\[2\].u_pe.psum_out\[10\]
+ _2158_ VGND VGND VPWR VPWR _2265_ sky130_fd_sc_hd__o21a_1
XFILLER_0_2_133 VGND VGND VPWR VPWR sky130_fd_sc_hd__decap_6
XANTENNA__6297__B1 _2992_ VGND VGND VPWR VPWR sky130_fd_sc_hd__diode_2
XANTENNA__4021__C _1145_ VGND VGND VPWR VPWR sky130_fd_sc_hd__diode_2
XFILLER_0_2_177 VPWR VGND VPWR VGND sky130_ef_sc_hd__decap_12
X_5253_ _2201_ _2202_ VGND VGND VPWR VPWR _2203_ sky130_fd_sc_hd__xnor2_1
XFILLER_0_11_489 VGND VGND VPWR VPWR sky130_fd_sc_hd__decap_8
X_4204_ _1332_ _1328_ VGND VGND VPWR VPWR _1334_ sky130_fd_sc_hd__nor2b_1
X_5184_ net599 _2144_ _1655_ _2146_ VGND VGND VPWR VPWR _0281_ sky130_fd_sc_hd__a22o_1
X_4135_ u_pe_array.g_pe_row\[3\].g_pe_col\[0\].u_pe.w_reg\[0\] u_pe_array.g_pe_row\[3\].g_pe_col\[0\].u_pe.act_val\[0\]
+ u_pe_array.g_pe_row\[3\].g_pe_col\[0\].u_pe.psum_out\[0\] VGND VGND VPWR VPWR _1271_
+ sky130_fd_sc_hd__and3_1
X_4066_ _1145_ u_pe_array.g_pe_row\[3\].g_pe_col\[1\].u_pe.psum_out\[8\] VGND VGND
+ VPWR VPWR _1222_ sky130_fd_sc_hd__or2_1
XFILLER_0_64_83 VGND VGND VPWR VPWR sky130_fd_sc_hd__fill_1
XFILLER_0_78_456 VGND VGND VPWR VPWR sky130_fd_sc_hd__decap_4
Xwire65 _3338_ VGND VGND VPWR VPWR net65 sky130_fd_sc_hd__buf_2
XFILLER_0_38_309 VGND VGND VPWR VPWR sky130_fd_sc_hd__decap_4
XFILLER_0_93_437 VGND VGND VPWR VPWR sky130_fd_sc_hd__decap_3
XANTENNA__6772__A1 _3134_ VGND VGND VPWR VPWR sky130_fd_sc_hd__diode_2
XFILLER_0_19_556 VGND VGND VPWR VPWR sky130_fd_sc_hd__decap_4
X_4968_ u_pe_array.u_fifo2.rd_ptr\[0\] _1958_ u_pe_array.u_fifo2.rd_ptr\[2\] u_pe_array.u_fifo2.rd_ptr\[1\]
+ VGND VGND VPWR VPWR _1964_ sky130_fd_sc_hd__and4b_2
X_6707_ _3331_ VGND VGND VPWR VPWR _0619_ sky130_fd_sc_hd__clkbuf_1
X_4899_ u_pe_array.g_pe_row\[2\].g_pe_col\[0\].u_pe.psum_out\[5\] _1891_ _1903_ VGND
+ VGND VPWR VPWR _1904_ sky130_fd_sc_hd__a21o_1
XFILLER_0_74_662 VGND VGND VPWR VPWR sky130_fd_sc_hd__fill_1
XFILLER_0_19_589 VGND VGND VPWR VPWR sky130_fd_sc_hd__fill_2
XANTENNA__3808__S _0734_ VGND VGND VPWR VPWR sky130_fd_sc_hd__diode_2
X_3919_ _0864_ _1100_ _1101_ _0867_ net627 VGND VGND VPWR VPWR _0061_ sky130_fd_sc_hd__a32o_1
XANTENNA_clkbuf_3_2__f_clk_A clknet_0_clk VGND VGND VPWR VPWR sky130_fd_sc_hd__diode_2
X_6638_ net747 _0833_ _0836_ _3288_ VGND VGND VPWR VPWR _0593_ sky130_fd_sc_hd__a22o_1
XFILLER_0_6_472 VGND VGND VPWR VPWR sky130_fd_sc_hd__decap_4
XFILLER_0_104_447 VGND VGND VPWR VPWR sky130_fd_sc_hd__fill_2
XFILLER_0_21_209 VPWR VGND VPWR VGND sky130_ef_sc_hd__decap_12
X_6569_ net250 _1820_ _3239_ VGND VGND VPWR VPWR _3252_ sky130_fd_sc_hd__mux2_1
XFILLER_0_14_283 VGND VGND VPWR VPWR sky130_fd_sc_hd__fill_2
XANTENNA__6288__B1 net71 VGND VGND VPWR VPWR sky130_fd_sc_hd__diode_2
XANTENNA__6854__S _3397_ VGND VGND VPWR VPWR sky130_fd_sc_hd__diode_2
XANTENNA__7070__RESET_B net819 VGND VGND VPWR VPWR sky130_fd_sc_hd__diode_2
XTAP_1132 VGND VPWR sky130_fd_sc_hd__tapvpwrvgnd_1
XTAP_1110 VGND VPWR sky130_fd_sc_hd__tapvpwrvgnd_1
XTAP_1121 VGND VPWR sky130_fd_sc_hd__tapvpwrvgnd_1
XANTENNA__6212__B1 _2174_ VGND VGND VPWR VPWR sky130_fd_sc_hd__diode_2
XTAP_1165 VGND VPWR sky130_fd_sc_hd__tapvpwrvgnd_1
XTAP_1154 VGND VPWR sky130_fd_sc_hd__tapvpwrvgnd_1
XTAP_1143 VGND VPWR sky130_fd_sc_hd__tapvpwrvgnd_1
XTAP_1198 VGND VPWR sky130_fd_sc_hd__tapvpwrvgnd_1
XTAP_1187 VGND VPWR sky130_fd_sc_hd__tapvpwrvgnd_1
XTAP_1176 VGND VPWR sky130_fd_sc_hd__tapvpwrvgnd_1
XANTENNA__5566__A2 _2463_ VGND VGND VPWR VPWR sky130_fd_sc_hd__diode_2
XFILLER_0_65_673 VGND VGND VPWR VPWR sky130_fd_sc_hd__fill_2
XFILLER_0_52_301 VGND VGND VPWR VPWR sky130_fd_sc_hd__decap_3
XFILLER_0_25_526 VGND VGND VPWR VPWR sky130_fd_sc_hd__fill_2
XFILLER_0_114_9 VGND VGND VPWR VPWR sky130_fd_sc_hd__fill_2
XFILLER_0_107_241 VGND VGND VPWR VPWR sky130_fd_sc_hd__decap_8
XFILLER_0_80_654 VGND VGND VPWR VPWR sky130_fd_sc_hd__fill_2
XFILLER_0_25_559 VGND VGND VPWR VPWR sky130_fd_sc_hd__fill_1
XFILLER_0_80_676 VGND VGND VPWR VPWR sky130_fd_sc_hd__fill_1
XFILLER_0_0_637 VGND VGND VPWR VPWR sky130_fd_sc_hd__decap_6
XTAP_916 VGND VPWR sky130_fd_sc_hd__tapvpwrvgnd_1
XTAP_905 VGND VPWR sky130_fd_sc_hd__tapvpwrvgnd_1
XFILLER_0_20_253 VGND VGND VPWR VPWR sky130_fd_sc_hd__decap_4
XFILLER_0_85_49 VGND VGND VPWR VPWR sky130_fd_sc_hd__decap_6
XTAP_949 VGND VPWR sky130_fd_sc_hd__tapvpwrvgnd_1
XTAP_938 VGND VPWR sky130_fd_sc_hd__tapvpwrvgnd_1
XTAP_927 VGND VPWR sky130_fd_sc_hd__tapvpwrvgnd_1
XANTENNA__7158__RESET_B net814 VGND VGND VPWR VPWR sky130_fd_sc_hd__diode_2
XFILLER_0_109_89 VGND VGND VPWR VPWR sky130_fd_sc_hd__fill_1
X_5940_ _2777_ _2778_ VGND VGND VPWR VPWR _2779_ sky130_fd_sc_hd__nor2_1
XANTENNA__4284__S _0855_ VGND VGND VPWR VPWR sky130_fd_sc_hd__diode_2
XFILLER_0_48_607 VGND VGND VPWR VPWR sky130_fd_sc_hd__fill_1
X_7610_ clknet_leaf_24_clk _0659_ VGND VGND VPWR VPWR u_pe_array.u_fifo1.buffer\[3\]\[7\]
+ sky130_fd_sc_hd__dfxtp_1
X_5871_ net606 _2600_ _2592_ _2726_ VGND VGND VPWR VPWR _0388_ sky130_fd_sc_hd__a22o_1
XFILLER_0_75_426 VGND VGND VPWR VPWR sky130_fd_sc_hd__fill_2
XFILLER_0_7_214 VGND VGND VPWR VPWR sky130_fd_sc_hd__decap_8
X_4822_ net614 _0833_ VGND VGND VPWR VPWR _1838_ sky130_fd_sc_hd__and2_1
XFILLER_0_28_320 VGND VGND VPWR VPWR sky130_fd_sc_hd__fill_2
XANTENNA__5557__A2 _2463_ VGND VGND VPWR VPWR sky130_fd_sc_hd__diode_2
X_4753_ u_pe_array.u_fifo2.wr_ptr\[0\] VGND VGND VPWR VPWR _1792_ sky130_fd_sc_hd__clkbuf_4
XFILLER_0_7_225 VGND VGND VPWR VPWR sky130_fd_sc_hd__decap_3
X_7541_ clknet_leaf_80_clk _0590_ net74 VGND VGND VPWR VPWR u_pe_array.g_pe_row\[3\].g_pe_col\[3\].u_pe.act_val\[2\]
+ sky130_fd_sc_hd__dfrtp_4
XFILLER_0_7_258 VGND VGND VPWR VPWR sky130_fd_sc_hd__decap_3
X_3704_ _0917_ _0918_ VGND VGND VPWR VPWR _0919_ sky130_fd_sc_hd__xnor2_1
XANTENNA__6506__A1 _1814_ VGND VGND VPWR VPWR sky130_fd_sc_hd__diode_2
X_7472_ clknet_leaf_0_clk _0521_ VGND VGND VPWR VPWR u_pe_array.u_fifo2.buffer\[2\]\[11\]
+ sky130_fd_sc_hd__dfxtp_1
XANTENNA__6231__C _2992_ VGND VGND VPWR VPWR sky130_fd_sc_hd__diode_2
XFILLER_0_70_131 VGND VGND VPWR VPWR sky130_fd_sc_hd__decap_3
X_4684_ _1672_ _1728_ u_pe_array.g_pe_row\[2\].g_pe_col\[1\].u_pe.psum_out\[6\] VGND
+ VGND VPWR VPWR _1730_ sky130_fd_sc_hd__a21oi_1
XFILLER_0_43_345 VGND VGND VPWR VPWR sky130_fd_sc_hd__fill_1
X_6423_ net300 _1812_ net70 VGND VGND VPWR VPWR _3175_ sky130_fd_sc_hd__mux2_1
XFILLER_0_70_197 VGND VGND VPWR VPWR sky130_fd_sc_hd__decap_3
XFILLER_0_70_164 VGND VGND VPWR VPWR sky130_fd_sc_hd__fill_2
XFILLER_0_3_453 VGND VGND VPWR VPWR sky130_fd_sc_hd__decap_3
XFILLER_0_3_442 VGND VGND VPWR VPWR sky130_fd_sc_hd__decap_3
X_3635_ net141 _0834_ _0856_ u_fsm.psum_shift_en VGND VGND VPWR VPWR _0022_ sky130_fd_sc_hd__a22o_1
X_6354_ _3129_ VGND VGND VPWR VPWR _0468_ sky130_fd_sc_hd__clkbuf_1
X_3566_ net464 _0809_ VGND VGND VPWR VPWR _0000_ sky130_fd_sc_hd__nor2_1
X_6285_ _3059_ _3073_ _3074_ VGND VGND VPWR VPWR _3075_ sky130_fd_sc_hd__a21oi_1
X_5305_ _2243_ _2244_ _2249_ _2246_ _2240_ VGND VGND VPWR VPWR _2250_ sky130_fd_sc_hd__a32o_1
X_3497_ _0758_ VGND VGND VPWR VPWR net36 sky130_fd_sc_hd__clkbuf_1
X_5236_ _2176_ _2187_ VGND VGND VPWR VPWR _2188_ sky130_fd_sc_hd__xor2_1
XFILLER_0_11_297 VGND VGND VPWR VPWR sky130_fd_sc_hd__decap_4
XANTENNA__4296__A2 _1392_ VGND VGND VPWR VPWR sky130_fd_sc_hd__diode_2
X_5167_ net422 _1714_ _0887_ _2137_ VGND VGND VPWR VPWR _0273_ sky130_fd_sc_hd__a22o_1
XANTENNA__4983__A _1787_ VGND VGND VPWR VPWR sky130_fd_sc_hd__diode_2
XFILLER_0_75_93 VGND VGND VPWR VPWR sky130_fd_sc_hd__fill_1
X_4118_ u_pe_array.g_pe_row\[3\].g_pe_col\[3\].u_pe.psum_out\[5\] u_pe_array.g_pe_row\[3\].g_pe_col\[3\].u_pe.act_val\[5\]
+ _0769_ VGND VGND VPWR VPWR _1262_ sky130_fd_sc_hd__mux2_1
X_5098_ _2060_ _2061_ _2075_ VGND VGND VPWR VPWR _2076_ sky130_fd_sc_hd__o21a_1
X_4049_ _1193_ _1199_ _1206_ VGND VGND VPWR VPWR _1207_ sky130_fd_sc_hd__o21ai_1
XFILLER_0_78_253 VGND VGND VPWR VPWR sky130_fd_sc_hd__decap_3
XPHY_215 VGND VGND VPWR VPWR sky130_fd_sc_hd__decap_3
XPHY_204 VGND VGND VPWR VPWR sky130_fd_sc_hd__decap_3
XFILLER_0_93_201 VGND VGND VPWR VPWR sky130_fd_sc_hd__fill_2
XFILLER_0_39_629 VGND VGND VPWR VPWR sky130_fd_sc_hd__fill_2
XPHY_226 VGND VGND VPWR VPWR sky130_fd_sc_hd__decap_3
XFILLER_0_109_528 VPWR VGND VPWR VGND sky130_ef_sc_hd__decap_12
XANTENNA__6745__A1 _3134_ VGND VGND VPWR VPWR sky130_fd_sc_hd__diode_2
XANTENNA__3559__A1 _0787_ VGND VGND VPWR VPWR sky130_fd_sc_hd__diode_2
XFILLER_0_47_673 VGND VGND VPWR VPWR sky130_fd_sc_hd__fill_2
XFILLER_0_19_364 VGND VGND VPWR VPWR sky130_fd_sc_hd__fill_2
XANTENNA__4223__A _1275_ VGND VGND VPWR VPWR sky130_fd_sc_hd__diode_2
XFILLER_0_62_643 VGND VGND VPWR VPWR sky130_fd_sc_hd__fill_1
XFILLER_0_46_194 VGND VGND VPWR VPWR sky130_fd_sc_hd__fill_2
XFILLER_0_104_200 VGND VGND VPWR VPWR sky130_fd_sc_hd__fill_2
XFILLER_0_61_142 VGND VGND VPWR VPWR sky130_fd_sc_hd__fill_1
XANTENNA__5720__A2 _2463_ VGND VGND VPWR VPWR sky130_fd_sc_hd__diode_2
XFILLER_0_30_584 VGND VGND VPWR VPWR sky130_fd_sc_hd__fill_2
XFILLER_0_100_494 VGND VGND VPWR VPWR sky130_fd_sc_hd__decap_3
XFILLER_0_100_472 VGND VGND VPWR VPWR sky130_fd_sc_hd__fill_2
XANTENNA__7251__RESET_B net813 VGND VGND VPWR VPWR sky130_fd_sc_hd__diode_2
Xhold8 u_pe_array.g_pe_row\[3\].g_pe_col\[0\].u_pe.w_buffer\[0\] VGND VGND VPWR VPWR
+ net84 sky130_fd_sc_hd__dlygate4sd3_1
XFILLER_0_89_518 VGND VGND VPWR VPWR sky130_fd_sc_hd__fill_2
XFILLER_0_97_551 VGND VGND VPWR VPWR sky130_fd_sc_hd__fill_2
XFILLER_0_69_253 VGND VGND VPWR VPWR sky130_fd_sc_hd__fill_1
XFILLER_0_84_201 VGND VGND VPWR VPWR sky130_fd_sc_hd__decap_4
XFILLER_0_57_415 VGND VGND VPWR VPWR sky130_fd_sc_hd__decap_3
XANTENNA__4747__B1 _0887_ VGND VGND VPWR VPWR sky130_fd_sc_hd__diode_2
XFILLER_0_44_109 VGND VGND VPWR VPWR sky130_fd_sc_hd__fill_2
XFILLER_0_65_492 VGND VGND VPWR VPWR sky130_fd_sc_hd__decap_8
XFILLER_0_20_33 VGND VGND VPWR VPWR sky130_fd_sc_hd__fill_2
XFILLER_0_25_356 VGND VGND VPWR VPWR sky130_fd_sc_hd__fill_1
XFILLER_0_111_57 VPWR VGND VPWR VGND sky130_ef_sc_hd__decap_12
XANTENNA__3970__B2 _1004_ VGND VGND VPWR VPWR sky130_fd_sc_hd__diode_2
Xhold408 u_pe_array.u_fifo2.buffer\[2\]\[3\] VGND VGND VPWR VPWR net484 sky130_fd_sc_hd__dlygate4sd3_1
XFILLER_0_96_15 VPWR VGND VPWR VGND sky130_ef_sc_hd__decap_12
XANTENNA__7339__RESET_B net812 VGND VGND VPWR VPWR sky130_fd_sc_hd__diode_2
Xhold419 u_pe_array.u_fifo1.buffer\[8\]\[3\] VGND VGND VPWR VPWR net495 sky130_fd_sc_hd__dlygate4sd3_1
XFILLER_0_0_401 VPWR VGND VPWR VGND sky130_ef_sc_hd__decap_12
XTAP_702 VGND VPWR sky130_fd_sc_hd__tapvpwrvgnd_1
XTAP_724 VGND VPWR sky130_fd_sc_hd__tapvpwrvgnd_1
XTAP_713 VGND VPWR sky130_fd_sc_hd__tapvpwrvgnd_1
X_6070_ u_pe_array.g_pe_row\[0\].g_pe_col\[1\].u_pe.w_reg\[0\] u_pe_array.g_pe_row\[0\].g_pe_col\[1\].u_pe.act_val\[2\]
+ VGND VGND VPWR VPWR _2883_ sky130_fd_sc_hd__nand2_1
XTAP_768 VGND VPWR sky130_fd_sc_hd__tapvpwrvgnd_1
XTAP_757 VGND VPWR sky130_fd_sc_hd__tapvpwrvgnd_1
XTAP_735 VGND VPWR sky130_fd_sc_hd__tapvpwrvgnd_1
XTAP_746 VGND VPWR sky130_fd_sc_hd__tapvpwrvgnd_1
XTAP_779 VGND VPWR sky130_fd_sc_hd__tapvpwrvgnd_1
X_5021_ u_pe_array.u_fifo2.buffer\[0\]\[5\] _1962_ VGND VGND VPWR VPWR _2012_ sky130_fd_sc_hd__or2_1
XANTENNA__6494__S _3208_ VGND VGND VPWR VPWR sky130_fd_sc_hd__diode_2
XFILLER_0_45_41 VGND VGND VPWR VPWR sky130_fd_sc_hd__fill_1
XANTENNA__6974__RESET_B net819 VGND VGND VPWR VPWR sky130_fd_sc_hd__diode_2
XFILLER_0_45_85 VGND VGND VPWR VPWR sky130_fd_sc_hd__fill_2
X_6972_ clknet_leaf_81_clk net80 net815 VGND VGND VPWR VPWR u_pe_array.g_pe_row\[3\].g_pe_col\[2\].u_pe.w_reg\[1\]
+ sky130_fd_sc_hd__dfrtp_1
XANTENNA__4450__A2 _1524_ VGND VGND VPWR VPWR sky130_fd_sc_hd__diode_2
X_5923_ u_pe_array.g_pe_row\[0\].g_pe_col\[2\].u_pe.act_val\[3\] u_pe_array.g_pe_row\[0\].g_pe_col\[2\].u_pe.w_reg\[0\]
+ VGND VGND VPWR VPWR _2763_ sky130_fd_sc_hd__nand2_1
XFILLER_0_75_245 VPWR VGND VPWR VGND sky130_ef_sc_hd__decap_12
XFILLER_0_61_51 VGND VGND VPWR VPWR sky130_fd_sc_hd__decap_4
XFILLER_0_8_501 VPWR VGND VPWR VGND sky130_ef_sc_hd__decap_12
XFILLER_0_0_76 VGND VGND VPWR VPWR sky130_fd_sc_hd__decap_8
X_5854_ _2611_ u_pe_array.g_pe_row\[0\].g_pe_col\[3\].u_pe.psum_out\[11\] VGND VGND
+ VPWR VPWR _2714_ sky130_fd_sc_hd__and2b_1
XFILLER_0_75_289 VGND VGND VPWR VPWR sky130_fd_sc_hd__fill_2
XFILLER_0_8_545 VPWR VGND VPWR VGND sky130_ef_sc_hd__decap_12
X_4805_ net766 _1666_ _1655_ _1827_ VGND VGND VPWR VPWR _0221_ sky130_fd_sc_hd__a22o_1
XFILLER_0_28_150 VGND VGND VPWR VPWR sky130_fd_sc_hd__fill_2
XFILLER_0_29_673 VGND VGND VPWR VPWR sky130_fd_sc_hd__fill_2
XANTENNA__4043__A _1145_ VGND VGND VPWR VPWR sky130_fd_sc_hd__diode_2
XFILLER_0_44_632 VGND VGND VPWR VPWR sky130_fd_sc_hd__fill_2
XFILLER_0_8_589 VPWR VGND VPWR VGND sky130_ef_sc_hd__decap_12
X_7524_ clknet_leaf_93_clk _0573_ VGND VGND VPWR VPWR u_pe_array.u_fifo2.buffer\[6\]\[11\]
+ sky130_fd_sc_hd__dfxtp_1
XANTENNA__5139__A _2029_ VGND VGND VPWR VPWR sky130_fd_sc_hd__diode_2
X_5785_ _2641_ _2650_ _0913_ VGND VGND VPWR VPWR _2652_ sky130_fd_sc_hd__a21o_1
X_4736_ _1672_ u_pe_array.g_pe_row\[2\].g_pe_col\[1\].u_pe.psum_out\[11\] VGND VGND
+ VPWR VPWR _1777_ sky130_fd_sc_hd__and2b_1
XFILLER_0_44_665 VGND VGND VPWR VPWR sky130_fd_sc_hd__fill_2
XFILLER_0_28_194 VGND VGND VPWR VPWR sky130_fd_sc_hd__fill_2
X_4667_ _0866_ VGND VGND VPWR VPWR _1714_ sky130_fd_sc_hd__buf_8
X_7455_ clknet_leaf_5_clk _0504_ VGND VGND VPWR VPWR u_pe_array.u_fifo2.buffer\[1\]\[7\]
+ sky130_fd_sc_hd__dfxtp_1
XFILLER_0_16_378 VGND VGND VPWR VPWR sky130_fd_sc_hd__fill_1
XANTENNA__5573__S _2469_ VGND VGND VPWR VPWR sky130_fd_sc_hd__diode_2
X_7386_ clknet_leaf_47_clk _0439_ net13 VGND VGND VPWR VPWR u_pe_array.g_pe_row\[0\].g_pe_col\[1\].u_pe.psum_out\[10\]
+ sky130_fd_sc_hd__dfrtp_2
X_6406_ _1792_ u_pe_array.u_fifo2.wr_ptr\[1\] _3165_ VGND VGND VPWR VPWR _3166_ sky130_fd_sc_hd__nor3_4
XANTENNA__5163__B1 _2029_ VGND VGND VPWR VPWR sky130_fd_sc_hd__diode_2
X_3618_ net25 _0846_ _0819_ VGND VGND VPWR VPWR _0847_ sky130_fd_sc_hd__mux2_1
XFILLER_0_101_247 VGND VGND VPWR VPWR sky130_fd_sc_hd__decap_8
XFILLER_0_101_225 VGND VGND VPWR VPWR sky130_fd_sc_hd__fill_2
X_6337_ _1787_ _1130_ net56 VGND VGND VPWR VPWR _3118_ sky130_fd_sc_hd__a21o_2
X_4598_ net671 _1524_ _1655_ _1657_ VGND VGND VPWR VPWR _0184_ sky130_fd_sc_hd__a22o_1
X_3549_ u_fsm.ch_cnt\[0\] u_fsm.ch_cnt\[1\] VGND VGND VPWR VPWR _0795_ sky130_fd_sc_hd__nand2_1
XANTENNA__7009__RESET_B net818 VGND VGND VPWR VPWR sky130_fd_sc_hd__diode_2
X_6268_ u_pe_array.g_pe_row\[0\].g_pe_col\[0\].u_pe.psum_out\[7\] _2992_ VGND VGND
+ VPWR VPWR _3059_ sky130_fd_sc_hd__nand2_1
XFILLER_0_86_81 VGND VGND VPWR VPWR sky130_fd_sc_hd__fill_1
X_6199_ _2993_ _2994_ _2991_ VGND VGND VPWR VPWR _2996_ sky130_fd_sc_hd__o21ai_1
X_5219_ _2165_ _2171_ VGND VGND VPWR VPWR _2172_ sky130_fd_sc_hd__nand2_1
XFILLER_0_98_304 VGND VGND VPWR VPWR sky130_fd_sc_hd__decap_4
XANTENNA_clkbuf_leaf_84_clk_A clknet_3_1__leaf_clk VGND VGND VPWR VPWR sky130_fd_sc_hd__diode_2
XFILLER_0_94_521 VGND VGND VPWR VPWR sky130_fd_sc_hd__fill_2
XFILLER_0_39_404 VGND VGND VPWR VPWR sky130_fd_sc_hd__fill_2
XFILLER_0_39_426 VGND VGND VPWR VPWR sky130_fd_sc_hd__fill_2
XANTENNA__6718__A1 _3134_ VGND VGND VPWR VPWR sky130_fd_sc_hd__diode_2
XFILLER_0_54_418 VGND VGND VPWR VPWR sky130_fd_sc_hd__fill_2
XANTENNA_clkbuf_leaf_22_clk_A clknet_3_2__leaf_clk VGND VGND VPWR VPWR sky130_fd_sc_hd__diode_2
XANTENNA__3952__A1 _1126_ VGND VGND VPWR VPWR sky130_fd_sc_hd__diode_2
XFILLER_0_50_635 VGND VGND VPWR VPWR sky130_fd_sc_hd__fill_2
XFILLER_0_50_624 VGND VGND VPWR VPWR sky130_fd_sc_hd__fill_1
XANTENNA__6579__S _3254_ VGND VGND VPWR VPWR sky130_fd_sc_hd__diode_2
XANTENNA__7432__RESET_B net74 VGND VGND VPWR VPWR sky130_fd_sc_hd__diode_2
XFILLER_0_34_197 VGND VGND VPWR VPWR sky130_fd_sc_hd__fill_2
XANTENNA_clkbuf_leaf_37_clk_A clknet_3_3__leaf_clk VGND VGND VPWR VPWR sky130_fd_sc_hd__diode_2
XFILLER_0_66_29 VPWR VGND VPWR VGND sky130_ef_sc_hd__decap_12
XANTENNA__5512__A _2345_ VGND VGND VPWR VPWR sky130_fd_sc_hd__diode_2
XFILLER_0_89_326 VGND VGND VPWR VPWR sky130_fd_sc_hd__fill_2
XFILLER_0_85_521 VGND VGND VPWR VPWR sky130_fd_sc_hd__fill_2
XFILLER_0_85_543 VGND VGND VPWR VPWR sky130_fd_sc_hd__fill_2
XFILLER_0_85_587 VGND VGND VPWR VPWR sky130_fd_sc_hd__fill_2
XFILLER_0_85_565 VGND VGND VPWR VPWR sky130_fd_sc_hd__fill_2
XFILLER_0_17_109 VGND VGND VPWR VPWR sky130_fd_sc_hd__decap_3
XFILLER_0_72_237 VPWR VGND VPWR VGND sky130_ef_sc_hd__decap_12
XFILLER_0_26_621 VGND VGND VPWR VPWR sky130_fd_sc_hd__decap_3
XFILLER_0_110_3 VPWR VGND VPWR VGND sky130_ef_sc_hd__decap_12
XFILLER_0_72_259 VGND VGND VPWR VPWR sky130_fd_sc_hd__fill_1
X_5570_ net136 _2463_ _2472_ _2336_ VGND VGND VPWR VPWR _0341_ sky130_fd_sc_hd__a22o_1
XFILLER_0_53_484 VGND VGND VPWR VPWR sky130_fd_sc_hd__fill_2
XFILLER_0_5_559 VGND VGND VPWR VPWR sky130_fd_sc_hd__fill_1
X_4521_ _1593_ _1589_ VGND VGND VPWR VPWR _1595_ sky130_fd_sc_hd__and2b_1
XFILLER_0_31_87 VGND VGND VPWR VPWR sky130_fd_sc_hd__decap_3
XFILLER_0_40_101 VGND VGND VPWR VPWR sky130_fd_sc_hd__decap_6
X_7240_ clknet_leaf_42_clk _0303_ net813 VGND VGND VPWR VPWR u_pe_array.g_pe_row\[1\].g_pe_col\[1\].u_pe.w_buffer\[1\]
+ sky130_fd_sc_hd__dfrtp_1
Xhold216 u_pe_array.u_fifo1.buffer\[0\]\[11\] VGND VGND VPWR VPWR net292 sky130_fd_sc_hd__dlygate4sd3_1
Xhold205 u_pe_array.u_fifo2.buffer\[0\]\[7\] VGND VGND VPWR VPWR net281 sky130_fd_sc_hd__dlygate4sd3_1
XFILLER_0_13_348 VGND VGND VPWR VPWR sky130_fd_sc_hd__fill_1
XANTENNA__5145__B1 _2029_ VGND VGND VPWR VPWR sky130_fd_sc_hd__diode_2
X_4452_ u_pe_array.g_pe_row\[2\].g_pe_col\[2\].u_pe.w_reg\[0\] u_pe_array.g_pe_row\[2\].g_pe_col\[2\].u_pe.act_val\[0\]
+ u_pe_array.g_pe_row\[2\].g_pe_col\[2\].u_pe.psum_out\[0\] VGND VGND VPWR VPWR _1532_
+ sky130_fd_sc_hd__and3_1
XFILLER_0_40_145 VGND VGND VPWR VPWR sky130_fd_sc_hd__fill_1
Xhold238 u_pe_array.u_fifo1.buffer\[1\]\[7\] VGND VGND VPWR VPWR net314 sky130_fd_sc_hd__dlygate4sd3_1
XANTENNA__7173__RESET_B net813 VGND VGND VPWR VPWR sky130_fd_sc_hd__diode_2
Xhold227 u_pe_array.u_fifo2.buffer\[6\]\[9\] VGND VGND VPWR VPWR net303 sky130_fd_sc_hd__dlygate4sd3_1
Xhold249 u_pe_array.u_fifo2.buffer\[6\]\[11\] VGND VGND VPWR VPWR net325 sky130_fd_sc_hd__dlygate4sd3_1
XFILLER_0_40_156 VGND VGND VPWR VPWR sky130_fd_sc_hd__fill_2
X_7171_ clknet_leaf_41_clk _0238_ net813 VGND VGND VPWR VPWR u_pe_array.g_pe_row\[2\].g_pe_col\[0\].u_pe.psum_out\[5\]
+ sky130_fd_sc_hd__dfrtp_1
XFILLER_0_0_253 VGND VGND VPWR VPWR sky130_fd_sc_hd__fill_2
X_4383_ _1407_ u_pe_array.g_pe_row\[2\].g_pe_col\[3\].u_pe.psum_out\[8\] VGND VGND
+ VPWR VPWR _1483_ sky130_fd_sc_hd__or2_1
XANTENNA__7102__RESET_B net819 VGND VGND VPWR VPWR sky130_fd_sc_hd__diode_2
X_6122_ _2926_ _2930_ VGND VGND VPWR VPWR _2931_ sky130_fd_sc_hd__and2b_1
XFILLER_0_0_275 VGND VGND VPWR VPWR sky130_fd_sc_hd__decap_4
XTAP_510 VGND VPWR sky130_fd_sc_hd__tapvpwrvgnd_1
XTAP_521 VGND VPWR sky130_fd_sc_hd__tapvpwrvgnd_1
XTAP_532 VGND VPWR sky130_fd_sc_hd__tapvpwrvgnd_1
XTAP_543 VGND VPWR sky130_fd_sc_hd__tapvpwrvgnd_1
X_6053_ net409 _2738_ _2868_ _0722_ VGND VGND VPWR VPWR _0428_ sky130_fd_sc_hd__a22o_1
XTAP_554 VGND VPWR sky130_fd_sc_hd__tapvpwrvgnd_1
XTAP_576 VGND VPWR sky130_fd_sc_hd__tapvpwrvgnd_1
XTAP_565 VGND VPWR sky130_fd_sc_hd__tapvpwrvgnd_1
XFILLER_0_56_73 VGND VGND VPWR VPWR sky130_fd_sc_hd__fill_1
XTAP_587 VGND VPWR sky130_fd_sc_hd__tapvpwrvgnd_1
XTAP_598 VGND VPWR sky130_fd_sc_hd__tapvpwrvgnd_1
X_5004_ u_pe_array.u_fifo2.buffer\[4\]\[3\] _1965_ _1966_ u_pe_array.u_fifo2.buffer\[7\]\[3\]
+ VGND VGND VPWR VPWR _1997_ sky130_fd_sc_hd__a22o_1
XFILLER_0_15_3 VGND VGND VPWR VPWR sky130_fd_sc_hd__decap_6
XFILLER_0_95_318 VGND VGND VPWR VPWR sky130_fd_sc_hd__fill_1
X_6955_ clknet_leaf_79_clk _0036_ net815 VGND VGND VPWR VPWR u_pe_array.g_pe_row\[3\].g_pe_col\[3\].u_pe.psum_out\[12\]
+ sky130_fd_sc_hd__dfrtp_1
XFILLER_0_76_521 VGND VGND VPWR VPWR sky130_fd_sc_hd__fill_2
XFILLER_0_72_94 VGND VGND VPWR VPWR sky130_fd_sc_hd__fill_1
X_5906_ u_pe_array.g_pe_row\[0\].g_pe_col\[2\].u_pe.act_val\[1\] u_pe_array.g_pe_row\[0\].g_pe_col\[2\].u_pe.w_reg\[0\]
+ _2746_ _2747_ VGND VGND VPWR VPWR _2748_ sky130_fd_sc_hd__a22o_1
XFILLER_0_91_502 VGND VGND VPWR VPWR sky130_fd_sc_hd__fill_2
XFILLER_0_76_587 VGND VGND VPWR VPWR sky130_fd_sc_hd__fill_1
X_6886_ _3106_ u_pe_array.u_fifo1.wr_ptr\[1\] _3380_ VGND VGND VPWR VPWR _3426_ sky130_fd_sc_hd__and3_1
XFILLER_0_91_524 VGND VGND VPWR VPWR sky130_fd_sc_hd__decap_3
X_5837_ _2690_ _2693_ _2698_ VGND VGND VPWR VPWR _2699_ sky130_fd_sc_hd__o21ai_1
XFILLER_0_8_397 VPWR VGND VPWR VGND sky130_ef_sc_hd__decap_12
XFILLER_0_8_386 VGND VGND VPWR VPWR sky130_fd_sc_hd__fill_2
XFILLER_0_16_120 VGND VGND VPWR VPWR sky130_fd_sc_hd__fill_2
XFILLER_0_17_643 VGND VGND VPWR VPWR sky130_fd_sc_hd__fill_2
X_5768_ u_pe_array.g_pe_row\[0\].g_pe_col\[3\].u_pe.psum_out\[2\] _2622_ _2635_ VGND
+ VGND VPWR VPWR _2636_ sky130_fd_sc_hd__a21oi_1
X_4719_ _1753_ _1756_ _1761_ VGND VGND VPWR VPWR _1762_ sky130_fd_sc_hd__o21ai_1
XFILLER_0_44_462 VGND VGND VPWR VPWR sky130_fd_sc_hd__decap_3
X_7507_ clknet_leaf_5_clk _0556_ VGND VGND VPWR VPWR u_pe_array.u_fifo2.buffer\[5\]\[7\]
+ sky130_fd_sc_hd__dfxtp_1
XFILLER_0_32_613 VGND VGND VPWR VPWR sky130_fd_sc_hd__fill_1
XFILLER_0_114_361 VGND VGND VPWR VPWR sky130_fd_sc_hd__decap_3
X_5699_ u_pe_array.g_pe_row\[1\].g_pe_col\[0\].u_pe.psum_out\[9\] u_pe_array.g_pe_row\[1\].g_pe_col\[0\].u_pe.psum_out\[10\]
+ _2478_ VGND VGND VPWR VPWR _2586_ sky130_fd_sc_hd__o21a_1
XANTENNA__5136__B1 _0913_ VGND VGND VPWR VPWR sky130_fd_sc_hd__diode_2
X_7438_ clknet_leaf_9_clk _0487_ VGND VGND VPWR VPWR u_pe_array.u_fifo2.buffer\[0\]\[3\]
+ sky130_fd_sc_hd__dfxtp_1
XFILLER_0_4_581 VGND VGND VPWR VPWR sky130_fd_sc_hd__decap_6
X_7369_ clknet_leaf_48_clk net238 net812 VGND VGND VPWR VPWR u_pe_array.g_pe_row\[0\].g_pe_col\[0\].u_pe.move_reg\[8\]
+ sky130_fd_sc_hd__dfrtp_1
XFILLER_0_102_589 VGND VGND VPWR VPWR sky130_fd_sc_hd__decap_3
XFILLER_0_12_392 VPWR VGND VPWR VGND sky130_ef_sc_hd__decap_12
XANTENNA__6636__B1 _0836_ VGND VGND VPWR VPWR sky130_fd_sc_hd__diode_2
XFILLER_0_99_613 VGND VGND VPWR VPWR sky130_fd_sc_hd__decap_3
XFILLER_0_98_112 VGND VGND VPWR VPWR sky130_fd_sc_hd__fill_1
XANTENNA__6862__S _3412_ VGND VGND VPWR VPWR sky130_fd_sc_hd__diode_2
XFILLER_0_98_178 VGND VGND VPWR VPWR sky130_fd_sc_hd__fill_1
XANTENNA__6163__A _2873_ VGND VGND VPWR VPWR sky130_fd_sc_hd__diode_2
XFILLER_0_67_532 VGND VGND VPWR VPWR sky130_fd_sc_hd__fill_2
XANTENNA__3622__B1 _0837_ VGND VGND VPWR VPWR sky130_fd_sc_hd__diode_2
XFILLER_0_54_226 VGND VGND VPWR VPWR sky130_fd_sc_hd__decap_4
XFILLER_0_109_177 VGND VGND VPWR VPWR sky130_fd_sc_hd__fill_2
XFILLER_0_50_410 VGND VGND VPWR VPWR sky130_fd_sc_hd__fill_2
XFILLER_0_35_462 VGND VGND VPWR VPWR sky130_fd_sc_hd__fill_2
XFILLER_0_35_484 VGND VGND VPWR VPWR sky130_fd_sc_hd__decap_3
XFILLER_0_112_309 VPWR VGND VPWR VGND sky130_ef_sc_hd__decap_12
XFILLER_0_50_421 VGND VGND VPWR VPWR sky130_fd_sc_hd__fill_2
XFILLER_0_23_657 VGND VGND VPWR VPWR sky130_fd_sc_hd__fill_2
XFILLER_0_50_465 VGND VGND VPWR VPWR sky130_fd_sc_hd__fill_2
XANTENNA__6627__A0 _0986_ VGND VGND VPWR VPWR sky130_fd_sc_hd__diode_2
XANTENNA__3461__S _0734_ VGND VGND VPWR VPWR sky130_fd_sc_hd__diode_2
XFILLER_0_93_49 VGND VGND VPWR VPWR sky130_fd_sc_hd__fill_2
XANTENNA__4653__A2 _1152_ VGND VGND VPWR VPWR sky130_fd_sc_hd__diode_2
XFILLER_0_77_329 VGND VGND VPWR VPWR sky130_fd_sc_hd__fill_2
XFILLER_0_77_318 VGND VGND VPWR VPWR sky130_fd_sc_hd__fill_2
X_6740_ _3348_ VGND VGND VPWR VPWR _0635_ sky130_fd_sc_hd__clkbuf_1
X_3952_ net17 _1126_ _0819_ VGND VGND VPWR VPWR _1127_ sky130_fd_sc_hd__mux2_1
XFILLER_0_9_117 VGND VGND VPWR VPWR sky130_fd_sc_hd__fill_2
XFILLER_0_18_418 VGND VGND VPWR VPWR sky130_fd_sc_hd__fill_2
XANTENNA__3613__B1 _0837_ VGND VGND VPWR VPWR sky130_fd_sc_hd__diode_2
XFILLER_0_73_513 VGND VGND VPWR VPWR sky130_fd_sc_hd__fill_2
X_6671_ u_pe_array.u_fifo1.rd_ptr\[0\] _3306_ net705 VGND VGND VPWR VPWR _3309_ sky130_fd_sc_hd__a21oi_1
XFILLER_0_58_587 VGND VGND VPWR VPWR sky130_fd_sc_hd__fill_1
X_3883_ _1064_ _1065_ _1067_ VGND VGND VPWR VPWR _1069_ sky130_fd_sc_hd__a21oi_1
X_5622_ _2514_ _2515_ VGND VGND VPWR VPWR _2517_ sky130_fd_sc_hd__or2_1
XANTENNA__7354__RESET_B net818 VGND VGND VPWR VPWR sky130_fd_sc_hd__diode_2
XFILLER_0_60_207 VGND VGND VPWR VPWR sky130_fd_sc_hd__decap_8
X_5553_ _0832_ VGND VGND VPWR VPWR _2463_ sky130_fd_sc_hd__clkbuf_8
XFILLER_0_5_334 VGND VGND VPWR VPWR sky130_fd_sc_hd__fill_2
X_4504_ u_pe_array.g_pe_row\[2\].g_pe_col\[2\].u_pe.w_reg\[0\] u_pe_array.g_pe_row\[2\].g_pe_col\[2\].u_pe.act_val\[5\]
+ VGND VGND VPWR VPWR _1579_ sky130_fd_sc_hd__nand2_1
XFILLER_0_14_657 VPWR VGND VPWR VGND sky130_ef_sc_hd__decap_12
XANTENNA__3636__S _0855_ VGND VGND VPWR VPWR sky130_fd_sc_hd__diode_2
X_5484_ _2403_ _2399_ VGND VGND VPWR VPWR _2405_ sky130_fd_sc_hd__and2b_1
XFILLER_0_13_167 VGND VGND VPWR VPWR sky130_fd_sc_hd__fill_1
XFILLER_0_41_454 VGND VGND VPWR VPWR sky130_fd_sc_hd__fill_2
X_7223_ clknet_leaf_52_clk _0288_ net812 VGND VGND VPWR VPWR u_pe_array.g_pe_row\[1\].g_pe_col\[1\].u_pe.move_reg\[12\]
+ sky130_fd_sc_hd__dfrtp_1
X_4435_ net592 _1392_ _1258_ _1522_ VGND VGND VPWR VPWR _0156_ sky130_fd_sc_hd__a22o_1
XFILLER_0_111_397 VGND VGND VPWR VPWR sky130_fd_sc_hd__fill_2
X_4366_ _1454_ _1460_ _1467_ VGND VGND VPWR VPWR _1468_ sky130_fd_sc_hd__o21ai_1
XFILLER_0_6_53 VPWR VGND VPWR VGND sky130_ef_sc_hd__decap_12
X_7154_ clknet_leaf_74_clk _0223_ net814 VGND VGND VPWR VPWR u_pe_array.g_pe_row\[1\].g_pe_col\[3\].u_pe.act_val\[3\]
+ sky130_fd_sc_hd__dfrtp_2
X_6105_ u_pe_array.g_pe_row\[0\].g_pe_col\[1\].u_pe.act_val\[4\] _2873_ VGND VGND
+ VPWR VPWR _2915_ sky130_fd_sc_hd__and2b_1
XTAP_351 VGND VPWR sky130_fd_sc_hd__tapvpwrvgnd_1
XTAP_340 VGND VPWR sky130_fd_sc_hd__tapvpwrvgnd_1
XFILLER_0_6_97 VPWR VGND VPWR VGND sky130_ef_sc_hd__decap_12
XANTENNA__6094__A1 _2873_ VGND VGND VPWR VPWR sky130_fd_sc_hd__diode_2
X_7085_ clknet_leaf_12_clk _0158_ net818 VGND VGND VPWR VPWR u_pe_array.g_pe_row\[2\].g_pe_col\[1\].u_pe.move_reg\[7\]
+ sky130_fd_sc_hd__dfrtp_1
X_4297_ u_pe_array.g_pe_row\[2\].g_pe_col\[3\].u_pe.w_reg\[0\] u_pe_array.g_pe_row\[2\].g_pe_col\[3\].u_pe.act_val\[0\]
+ u_pe_array.g_pe_row\[2\].g_pe_col\[3\].u_pe.psum_out\[0\] VGND VGND VPWR VPWR _1405_
+ sky130_fd_sc_hd__a21o_1
XTAP_384 VGND VPWR sky130_fd_sc_hd__tapvpwrvgnd_1
XTAP_373 VGND VPWR sky130_fd_sc_hd__tapvpwrvgnd_1
XTAP_362 VGND VPWR sky130_fd_sc_hd__tapvpwrvgnd_1
X_6036_ u_pe_array.g_pe_row\[0\].g_pe_col\[1\].u_pe.act_val\[4\] u_pe_array.g_pe_row\[0\].g_pe_col\[1\].u_pe.psum_out\[4\]
+ _0756_ VGND VGND VPWR VPWR _2860_ sky130_fd_sc_hd__mux2_1
XTAP_395 VGND VPWR sky130_fd_sc_hd__tapvpwrvgnd_1
XTAP_1506 VGND VPWR sky130_fd_sc_hd__tapvpwrvgnd_1
XFILLER_0_68_329 VGND VGND VPWR VPWR sky130_fd_sc_hd__fill_2
XPHY_13 VGND VGND VPWR VPWR sky130_fd_sc_hd__decap_3
XTAP_1539 VGND VPWR sky130_fd_sc_hd__tapvpwrvgnd_1
XTAP_1528 VGND VPWR sky130_fd_sc_hd__tapvpwrvgnd_1
XTAP_1517 VGND VPWR sky130_fd_sc_hd__tapvpwrvgnd_1
XPHY_24 VGND VGND VPWR VPWR sky130_fd_sc_hd__decap_3
XPHY_35 VGND VGND VPWR VPWR sky130_fd_sc_hd__decap_3
XPHY_46 VGND VGND VPWR VPWR sky130_fd_sc_hd__decap_3
XPHY_57 VGND VGND VPWR VPWR sky130_fd_sc_hd__decap_3
XPHY_68 VGND VGND VPWR VPWR sky130_fd_sc_hd__decap_3
X_6938_ clknet_leaf_86_clk _0021_ net74 VGND VGND VPWR VPWR u_pe_array.g_pe_row\[3\].g_pe_col\[2\].u_pe.move_reg\[10\]
+ sky130_fd_sc_hd__dfrtp_1
XPHY_79 VGND VGND VPWR VPWR sky130_fd_sc_hd__decap_3
X_6869_ _3417_ VGND VGND VPWR VPWR _0695_ sky130_fd_sc_hd__clkbuf_1
XFILLER_0_64_513 VGND VGND VPWR VPWR sky130_fd_sc_hd__fill_2
XFILLER_0_107_615 VGND VGND VPWR VPWR sky130_fd_sc_hd__fill_1
XFILLER_0_9_673 VGND VGND VPWR VPWR sky130_fd_sc_hd__decap_4
XANTENNA__7095__RESET_B net819 VGND VGND VPWR VPWR sky130_fd_sc_hd__diode_2
XFILLER_0_8_161 VGND VGND VPWR VPWR sky130_fd_sc_hd__fill_1
XFILLER_0_36_248 VGND VGND VPWR VPWR sky130_fd_sc_hd__fill_2
XFILLER_0_106_169 VGND VGND VPWR VPWR sky130_fd_sc_hd__decap_6
XFILLER_0_17_484 VGND VGND VPWR VPWR sky130_fd_sc_hd__decap_8
XANTENNA__7024__RESET_B net74 VGND VGND VPWR VPWR sky130_fd_sc_hd__diode_2
XFILLER_0_32_421 VGND VGND VPWR VPWR sky130_fd_sc_hd__fill_1
XFILLER_0_102_320 VGND VGND VPWR VPWR sky130_fd_sc_hd__fill_2
Xhold580 u_pe_array.g_pe_row\[3\].g_pe_col\[0\].u_pe.act_val\[2\] VGND VGND VPWR VPWR
+ net656 sky130_fd_sc_hd__dlygate4sd3_1
Xhold591 u_pe_array.g_pe_row\[3\].g_pe_col\[3\].u_pe.psum_out\[3\] VGND VGND VPWR
+ VPWR net667 sky130_fd_sc_hd__dlygate4sd3_1
XANTENNA__5832__B2 _0875_ VGND VGND VPWR VPWR sky130_fd_sc_hd__diode_2
XFILLER_0_12_23 VGND VGND VPWR VPWR sky130_fd_sc_hd__fill_1
XFILLER_0_6_109 VPWR VGND VPWR VGND sky130_ef_sc_hd__decap_12
XFILLER_0_27_237 VGND VGND VPWR VPWR sky130_fd_sc_hd__decap_4
XFILLER_0_12_78 VGND VGND VPWR VPWR sky130_fd_sc_hd__decap_4
XFILLER_0_113_629 VPWR VGND VPWR VGND sky130_ef_sc_hd__decap_12
XFILLER_0_88_27 VGND VGND VPWR VPWR sky130_fd_sc_hd__fill_1
XANTENNA__3456__S _0730_ VGND VGND VPWR VPWR sky130_fd_sc_hd__diode_2
XFILLER_0_2_304 VGND VGND VPWR VPWR sky130_fd_sc_hd__fill_1
XFILLER_0_35_281 VGND VGND VPWR VPWR sky130_fd_sc_hd__decap_4
XFILLER_0_35_292 VGND VGND VPWR VPWR sky130_fd_sc_hd__decap_4
XFILLER_0_23_465 VGND VGND VPWR VPWR sky130_fd_sc_hd__fill_2
XANTENNA__6312__A2 _0867_ VGND VGND VPWR VPWR sky130_fd_sc_hd__diode_2
XFILLER_0_50_284 VGND VGND VPWR VPWR sky130_fd_sc_hd__fill_2
XFILLER_0_50_262 VGND VGND VPWR VPWR sky130_fd_sc_hd__decap_4
X_4220_ u_pe_array.g_pe_row\[3\].g_pe_col\[0\].u_pe.psum_out\[7\] VGND VGND VPWR VPWR
+ _1348_ sky130_fd_sc_hd__inv_2
X_4151_ u_pe_array.g_pe_row\[3\].g_pe_col\[0\].u_pe.act_val\[1\] _1275_ VGND VGND
+ VPWR VPWR _1285_ sky130_fd_sc_hd__and2b_1
XANTENNA__4287__S _0855_ VGND VGND VPWR VPWR sky130_fd_sc_hd__diode_2
X_4082_ _1145_ u_pe_array.g_pe_row\[3\].g_pe_col\[1\].u_pe.psum_out\[10\] VGND VGND
+ VPWR VPWR _1236_ sky130_fd_sc_hd__nand2_1
XFILLER_0_78_616 VGND VGND VPWR VPWR sky130_fd_sc_hd__fill_1
XFILLER_0_78_649 VGND VGND VPWR VPWR sky130_fd_sc_hd__fill_2
XANTENNA__5587__B1 _2071_ VGND VGND VPWR VPWR sky130_fd_sc_hd__diode_2
X_4984_ _0836_ _1977_ _1979_ _0833_ net711 VGND VGND VPWR VPWR _0248_ sky130_fd_sc_hd__a32o_1
X_6723_ net535 _3112_ net65 VGND VGND VPWR VPWR _3340_ sky130_fd_sc_hd__mux2_1
XFILLER_0_18_226 VGND VGND VPWR VPWR sky130_fd_sc_hd__decap_4
X_3935_ net548 _0875_ _0887_ _1115_ VGND VGND VPWR VPWR _0063_ sky130_fd_sc_hd__a22o_1
XFILLER_0_73_321 VGND VGND VPWR VPWR sky130_fd_sc_hd__fill_2
X_6654_ _3106_ _3296_ VGND VGND VPWR VPWR _3297_ sky130_fd_sc_hd__or2_1
X_5605_ _2499_ u_pe_array.g_pe_row\[1\].g_pe_col\[0\].u_pe.psum_out\[3\] _2478_ VGND
+ VGND VPWR VPWR _2501_ sky130_fd_sc_hd__and3_1
XFILLER_0_61_505 VGND VGND VPWR VPWR sky130_fd_sc_hd__decap_3
XFILLER_0_46_579 VGND VGND VPWR VPWR sky130_fd_sc_hd__fill_2
XFILLER_0_6_643 VGND VGND VPWR VPWR sky130_fd_sc_hd__fill_1
X_3866_ u_pe_array.g_pe_row\[3\].g_pe_col\[2\].u_pe.act_val\[5\] u_pe_array.g_pe_row\[3\].g_pe_col\[2\].u_pe.w_reg\[0\]
+ VGND VGND VPWR VPWR _1053_ sky130_fd_sc_hd__nand2_1
XFILLER_0_82_3 VGND VGND VPWR VPWR sky130_fd_sc_hd__decap_3
XANTENNA__5147__A _2029_ VGND VGND VPWR VPWR sky130_fd_sc_hd__diode_2
X_6585_ net355 _1808_ _3254_ VGND VGND VPWR VPWR _3261_ sky130_fd_sc_hd__mux2_1
X_3797_ u_pe_array.g_pe_row\[3\].g_pe_col\[2\].u_pe.psum_out\[5\] u_pe_array.g_pe_row\[3\].g_pe_col\[2\].u_pe.act_val\[5\]
+ _0745_ VGND VGND VPWR VPWR _0997_ sky130_fd_sc_hd__mux2_1
XFILLER_0_103_117 VGND VGND VPWR VPWR sky130_fd_sc_hd__fill_2
X_5536_ u_pe_array.g_pe_row\[1\].g_pe_col\[1\].u_pe.psum_out\[10\] _2448_ _2451_ VGND
+ VGND VPWR VPWR _2452_ sky130_fd_sc_hd__a21oi_1
XANTENNA__4051__A _0914_ VGND VGND VPWR VPWR sky130_fd_sc_hd__diode_2
X_5467_ u_pe_array.g_pe_row\[1\].g_pe_col\[1\].u_pe.w_reg\[0\] u_pe_array.g_pe_row\[1\].g_pe_col\[1\].u_pe.act_val\[5\]
+ VGND VGND VPWR VPWR _2389_ sky130_fd_sc_hd__nand2_1
XFILLER_0_78_71 VGND VGND VPWR VPWR sky130_fd_sc_hd__decap_4
X_7206_ clknet_leaf_72_clk _0271_ net815 VGND VGND VPWR VPWR u_pe_array.g_pe_row\[1\].g_pe_col\[3\].u_pe.psum_out\[10\]
+ sky130_fd_sc_hd__dfrtp_2
X_4418_ _1512_ _1513_ VGND VGND VPWR VPWR _1514_ sky130_fd_sc_hd__xnor2_1
XANTENNA__3522__C1 _0754_ VGND VGND VPWR VPWR sky130_fd_sc_hd__diode_2
X_5398_ _0836_ _2330_ _2332_ _0833_ net571 VGND VGND VPWR VPWR _0309_ sky130_fd_sc_hd__a32o_1
XFILLER_0_1_381 VGND VGND VPWR VPWR sky130_fd_sc_hd__fill_2
X_4349_ _1449_ _1451_ VGND VGND VPWR VPWR _1452_ sky130_fd_sc_hd__xor2_1
X_7137_ clknet_leaf_92_clk _0206_ VGND VGND VPWR VPWR u_pe_array.u_fifo2.buffer\[8\]\[1\]
+ sky130_fd_sc_hd__dfxtp_1
X_7068_ clknet_leaf_90_clk _0141_ net74 VGND VGND VPWR VPWR u_pe_array.g_pe_row\[2\].g_pe_col\[3\].u_pe.psum_out\[5\]
+ sky130_fd_sc_hd__dfrtp_1
X_6019_ u_pe_array.g_pe_row\[0\].g_pe_col\[2\].u_pe.psum_out\[9\] u_pe_array.g_pe_row\[0\].g_pe_col\[2\].u_pe.psum_out\[10\]
+ _2743_ VGND VGND VPWR VPWR _2850_ sky130_fd_sc_hd__o21a_1
XFILLER_0_96_402 VGND VGND VPWR VPWR sky130_fd_sc_hd__fill_2
XANTENNA__3825__B1 _0867_ VGND VGND VPWR VPWR sky130_fd_sc_hd__diode_2
XFILLER_0_96_435 VGND VGND VPWR VPWR sky130_fd_sc_hd__decap_4
XTAP_1314 VGND VPWR sky130_fd_sc_hd__tapvpwrvgnd_1
XTAP_1303 VGND VPWR sky130_fd_sc_hd__tapvpwrvgnd_1
XFILLER_0_68_137 VGND VGND VPWR VPWR sky130_fd_sc_hd__decap_3
XTAP_1347 VGND VPWR sky130_fd_sc_hd__tapvpwrvgnd_1
XTAP_1336 VGND VPWR sky130_fd_sc_hd__tapvpwrvgnd_1
XTAP_1325 VGND VPWR sky130_fd_sc_hd__tapvpwrvgnd_1
XANTENNA__7276__RESET_B net814 VGND VGND VPWR VPWR sky130_fd_sc_hd__diode_2
XTAP_1369 VGND VPWR sky130_fd_sc_hd__tapvpwrvgnd_1
XTAP_1358 VGND VPWR sky130_fd_sc_hd__tapvpwrvgnd_1
XFILLER_0_77_671 VGND VGND VPWR VPWR sky130_fd_sc_hd__fill_1
XANTENNA__7205__RESET_B net815 VGND VGND VPWR VPWR sky130_fd_sc_hd__diode_2
XFILLER_0_76_192 VGND VGND VPWR VPWR sky130_fd_sc_hd__fill_2
XFILLER_0_9_492 VPWR VGND VPWR VGND sky130_ef_sc_hd__decap_12
XFILLER_0_64_398 VGND VGND VPWR VPWR sky130_fd_sc_hd__fill_1
XFILLER_0_24_229 VGND VGND VPWR VPWR sky130_fd_sc_hd__fill_1
XFILLER_0_107_489 VGND VGND VPWR VPWR sky130_fd_sc_hd__fill_2
XANTENNA__6587__S _3254_ VGND VGND VPWR VPWR sky130_fd_sc_hd__diode_2
XFILLER_0_20_402 VGND VGND VPWR VPWR sky130_fd_sc_hd__fill_2
XFILLER_0_103_673 VGND VGND VPWR VPWR sky130_fd_sc_hd__decap_4
XFILLER_0_87_446 VGND VGND VPWR VPWR sky130_fd_sc_hd__fill_2
XFILLER_0_114_13 VPWR VGND VPWR VGND sky130_ef_sc_hd__decap_12
XFILLER_0_114_57 VGND VGND VPWR VPWR sky130_fd_sc_hd__fill_2
XANTENNA__5033__A2 _1666_ VGND VGND VPWR VPWR sky130_fd_sc_hd__diode_2
XFILLER_0_67_192 VGND VGND VPWR VPWR sky130_fd_sc_hd__decap_8
XFILLER_0_55_343 VGND VGND VPWR VPWR sky130_fd_sc_hd__decap_3
X_3720_ _0909_ _0922_ _0923_ VGND VGND VPWR VPWR _0934_ sky130_fd_sc_hd__o21a_1
XFILLER_0_99_37 VGND VGND VPWR VPWR sky130_fd_sc_hd__fill_1
Xclkbuf_leaf_40_clk clknet_3_6__leaf_clk VGND VGND VPWR VPWR clknet_leaf_40_clk sky130_fd_sc_hd__clkbuf_16
XANTENNA__6999__RESET_B net76 VGND VGND VPWR VPWR sky130_fd_sc_hd__diode_2
X_3651_ u_pe_array.g_pe_row\[3\].g_pe_col\[3\].u_pe.act_val\[0\] _0869_ VGND VGND
+ VPWR VPWR _0870_ sky130_fd_sc_hd__nand2_1
XFILLER_0_15_229 VGND VGND VPWR VPWR sky130_fd_sc_hd__fill_2
X_6370_ _1792_ u_pe_array.u_fifo2.wr_ptr\[1\] VGND VGND VPWR VPWR _3141_ sky130_fd_sc_hd__nand2_2
X_3582_ _0819_ _0792_ _0801_ VGND VGND VPWR VPWR _0820_ sky130_fd_sc_hd__o21ai_1
XANTENNA__6928__RESET_B net819 VGND VGND VPWR VPWR sky130_fd_sc_hd__diode_2
X_5321_ _2258_ _2263_ _2264_ _2071_ net425 VGND VGND VPWR VPWR _0300_ sky130_fd_sc_hd__a32o_1
XFILLER_0_51_571 VGND VGND VPWR VPWR sky130_fd_sc_hd__decap_6
XFILLER_0_100_109 VGND VGND VPWR VPWR sky130_fd_sc_hd__decap_3
XFILLER_0_2_189 VGND VGND VPWR VPWR sky130_fd_sc_hd__decap_6
X_5252_ u_pe_array.g_pe_row\[1\].g_pe_col\[2\].u_pe.act_val\[5\] u_pe_array.g_pe_row\[1\].g_pe_col\[2\].u_pe.w_reg\[0\]
+ VGND VGND VPWR VPWR _2202_ sky130_fd_sc_hd__nand2_1
X_4203_ _1328_ _1332_ VGND VGND VPWR VPWR _1333_ sky130_fd_sc_hd__and2b_1
X_5183_ _0767_ _1834_ _0747_ VGND VGND VPWR VPWR _2146_ sky130_fd_sc_hd__mux2_1
XFILLER_0_48_85 VGND VGND VPWR VPWR sky130_fd_sc_hd__fill_2
XANTENNA__6049__B2 _0722_ VGND VGND VPWR VPWR sky130_fd_sc_hd__diode_2
X_4134_ u_pe_array.g_pe_row\[3\].g_pe_col\[0\].u_pe.w_reg\[0\] u_pe_array.g_pe_row\[3\].g_pe_col\[0\].u_pe.act_val\[0\]
+ u_pe_array.g_pe_row\[3\].g_pe_col\[0\].u_pe.psum_out\[0\] VGND VGND VPWR VPWR _1270_
+ sky130_fd_sc_hd__a21o_1
XANTENNA__5133__C _2029_ VGND VGND VPWR VPWR sky130_fd_sc_hd__diode_2
XANTENNA__5430__A u_pe_array.g_pe_row\[1\].g_pe_col\[1\].u_pe.w_reg\[0\] VGND VGND
+ VPWR VPWR sky130_fd_sc_hd__diode_2
X_4065_ _1145_ u_pe_array.g_pe_row\[3\].g_pe_col\[1\].u_pe.psum_out\[8\] VGND VGND
+ VPWR VPWR _1221_ sky130_fd_sc_hd__nand2_1
XFILLER_0_19_502 VGND VGND VPWR VPWR sky130_fd_sc_hd__fill_2
XFILLER_0_93_449 VGND VGND VPWR VPWR sky130_fd_sc_hd__decap_3
XFILLER_0_80_83 VGND VGND VPWR VPWR sky130_fd_sc_hd__fill_1
XFILLER_0_58_170 VGND VGND VPWR VPWR sky130_fd_sc_hd__decap_3
X_4967_ u_pe_array.u_fifo2.buffer\[0\]\[0\] _1962_ VGND VGND VPWR VPWR _1963_ sky130_fd_sc_hd__or2_1
Xclkbuf_leaf_31_clk clknet_3_3__leaf_clk VGND VGND VPWR VPWR clknet_leaf_31_clk sky130_fd_sc_hd__clkbuf_16
X_6706_ net302 _3122_ net66 VGND VGND VPWR VPWR _3331_ sky130_fd_sc_hd__mux2_1
X_4898_ u_pe_array.g_pe_row\[2\].g_pe_col\[0\].u_pe.act_val\[5\] u_pe_array.g_pe_row\[2\].g_pe_col\[0\].u_pe.w_reg\[0\]
+ _1889_ VGND VGND VPWR VPWR _1903_ sky130_fd_sc_hd__and3_1
X_3918_ _1091_ _1094_ _1099_ VGND VGND VPWR VPWR _1101_ sky130_fd_sc_hd__or3_1
XFILLER_0_73_173 VGND VGND VPWR VPWR sky130_fd_sc_hd__fill_2
X_6637_ _0997_ net12 _0747_ VGND VGND VPWR VPWR _3288_ sky130_fd_sc_hd__mux2_1
X_3849_ _1026_ _1035_ _1037_ VGND VGND VPWR VPWR _1038_ sky130_fd_sc_hd__or3_1
XFILLER_0_104_415 VGND VGND VPWR VPWR sky130_fd_sc_hd__fill_2
X_6568_ _3251_ VGND VGND VPWR VPWR _0560_ sky130_fd_sc_hd__clkbuf_1
XFILLER_0_89_81 VGND VGND VPWR VPWR sky130_fd_sc_hd__decap_4
X_5519_ u_pe_array.g_pe_row\[1\].g_pe_col\[1\].u_pe.psum_out\[7\] u_pe_array.g_pe_row\[1\].g_pe_col\[1\].u_pe.psum_out\[8\]
+ _2432_ _2345_ VGND VGND VPWR VPWR _2436_ sky130_fd_sc_hd__o211a_1
X_6499_ _3214_ VGND VGND VPWR VPWR _0528_ sky130_fd_sc_hd__clkbuf_1
XFILLER_0_100_621 VPWR VGND VPWR VGND sky130_ef_sc_hd__decap_12
XANTENNA__4299__B1 _1144_ VGND VGND VPWR VPWR sky130_fd_sc_hd__diode_2
XANTENNA__6870__S _3412_ VGND VGND VPWR VPWR sky130_fd_sc_hd__diode_2
XTAP_1111 VGND VPWR sky130_fd_sc_hd__tapvpwrvgnd_1
XTAP_1122 VGND VPWR sky130_fd_sc_hd__tapvpwrvgnd_1
XTAP_1100 VGND VPWR sky130_fd_sc_hd__tapvpwrvgnd_1
XTAP_1155 VGND VPWR sky130_fd_sc_hd__tapvpwrvgnd_1
XTAP_1144 VGND VPWR sky130_fd_sc_hd__tapvpwrvgnd_1
XTAP_1133 VGND VPWR sky130_fd_sc_hd__tapvpwrvgnd_1
XFILLER_0_56_129 VGND VGND VPWR VPWR sky130_fd_sc_hd__decap_8
XTAP_1199 VGND VPWR sky130_fd_sc_hd__tapvpwrvgnd_1
XTAP_1188 VGND VPWR sky130_fd_sc_hd__tapvpwrvgnd_1
XTAP_1177 VGND VPWR sky130_fd_sc_hd__tapvpwrvgnd_1
XTAP_1166 VGND VPWR sky130_fd_sc_hd__tapvpwrvgnd_1
Xclkbuf_leaf_22_clk clknet_3_2__leaf_clk VGND VGND VPWR VPWR clknet_leaf_22_clk sky130_fd_sc_hd__clkbuf_16
XFILLER_0_25_505 VGND VGND VPWR VPWR sky130_fd_sc_hd__fill_2
XFILLER_0_107_253 VPWR VGND VPWR VGND sky130_ef_sc_hd__decap_12
XFILLER_0_25_538 VGND VGND VPWR VPWR sky130_fd_sc_hd__fill_1
XFILLER_0_37_387 VGND VGND VPWR VPWR sky130_fd_sc_hd__fill_2
XTAP_917 VGND VPWR sky130_fd_sc_hd__tapvpwrvgnd_1
XTAP_906 VGND VPWR sky130_fd_sc_hd__tapvpwrvgnd_1
XFILLER_0_109_13 VPWR VGND VPWR VGND sky130_ef_sc_hd__decap_12
XFILLER_0_85_39 VGND VGND VPWR VPWR sky130_fd_sc_hd__fill_2
XTAP_939 VGND VPWR sky130_fd_sc_hd__tapvpwrvgnd_1
XTAP_928 VGND VPWR sky130_fd_sc_hd__tapvpwrvgnd_1
Xclkbuf_leaf_89_clk clknet_3_1__leaf_clk VGND VGND VPWR VPWR clknet_leaf_89_clk sky130_fd_sc_hd__clkbuf_16
XANTENNA__7198__RESET_B net814 VGND VGND VPWR VPWR sky130_fd_sc_hd__diode_2
XANTENNA__7127__RESET_B net76 VGND VGND VPWR VPWR sky130_fd_sc_hd__diode_2
X_5870_ u_pe_array.g_pe_row\[1\].g_pe_col\[1\].u_pe.act_val\[0\] u_pe_array.g_pe_row\[1\].g_pe_col\[1\].u_pe.psum_out\[0\]
+ _0770_ VGND VGND VPWR VPWR _2726_ sky130_fd_sc_hd__mux2_1
XFILLER_0_48_619 VGND VGND VPWR VPWR sky130_fd_sc_hd__fill_2
X_4821_ _1837_ VGND VGND VPWR VPWR _0227_ sky130_fd_sc_hd__clkbuf_1
XANTENNA__5396__S _0755_ VGND VGND VPWR VPWR sky130_fd_sc_hd__diode_2
XFILLER_0_87_298 VGND VGND VPWR VPWR sky130_fd_sc_hd__fill_1
XFILLER_0_75_449 VGND VGND VPWR VPWR sky130_fd_sc_hd__fill_2
XFILLER_0_56_630 VGND VGND VPWR VPWR sky130_fd_sc_hd__fill_2
XFILLER_0_90_419 VGND VGND VPWR VPWR sky130_fd_sc_hd__fill_1
Xclkbuf_leaf_13_clk clknet_3_1__leaf_clk VGND VGND VPWR VPWR clknet_leaf_13_clk sky130_fd_sc_hd__clkbuf_16
XFILLER_0_56_674 VGND VGND VPWR VPWR sky130_fd_sc_hd__decap_3
XFILLER_0_55_151 VGND VGND VPWR VPWR sky130_fd_sc_hd__decap_6
X_4752_ _0788_ _1790_ VGND VGND VPWR VPWR _1791_ sky130_fd_sc_hd__nand2_1
XFILLER_0_16_505 VGND VGND VPWR VPWR sky130_fd_sc_hd__decap_8
X_7540_ clknet_leaf_78_clk _0589_ net815 VGND VGND VPWR VPWR u_pe_array.g_pe_row\[3\].g_pe_col\[3\].u_pe.act_val\[1\]
+ sky130_fd_sc_hd__dfrtp_1
X_4683_ _1672_ _1728_ u_pe_array.g_pe_row\[2\].g_pe_col\[1\].u_pe.psum_out\[6\] VGND
+ VGND VPWR VPWR _1729_ sky130_fd_sc_hd__and3_1
XFILLER_0_55_173 VGND VGND VPWR VPWR sky130_fd_sc_hd__fill_2
X_3703_ u_pe_array.g_pe_row\[3\].g_pe_col\[3\].u_pe.act_val\[4\] _0869_ VGND VGND
+ VPWR VPWR _0918_ sky130_fd_sc_hd__and2b_1
X_7471_ clknet_leaf_0_clk _0520_ VGND VGND VPWR VPWR u_pe_array.u_fifo2.buffer\[2\]\[10\]
+ sky130_fd_sc_hd__dfxtp_1
XFILLER_0_113_212 VPWR VGND VPWR VGND sky130_ef_sc_hd__decap_12
X_6422_ _3174_ VGND VGND VPWR VPWR _0491_ sky130_fd_sc_hd__clkbuf_1
XFILLER_0_43_368 VGND VGND VPWR VPWR sky130_fd_sc_hd__fill_2
X_3634_ u_pe_array.g_pe_row\[2\].g_pe_col\[2\].u_pe.psum_out\[11\] u_pe_array.g_pe_row\[2\].g_pe_col\[2\].u_pe.move_reg\[11\]
+ _0855_ VGND VGND VPWR VPWR _0856_ sky130_fd_sc_hd__mux2_1
XANTENNA__5714__B1 _2592_ VGND VGND VPWR VPWR sky130_fd_sc_hd__diode_2
XFILLER_0_70_176 VGND VGND VPWR VPWR sky130_fd_sc_hd__fill_2
XFILLER_0_31_519 VGND VGND VPWR VPWR sky130_fd_sc_hd__decap_3
X_6353_ _3128_ net308 _3110_ VGND VGND VPWR VPWR _3129_ sky130_fd_sc_hd__mux2_1
XANTENNA__5190__B2 _1665_ VGND VGND VPWR VPWR sky130_fd_sc_hd__diode_2
X_3565_ _0723_ u_fsm.next_state\[1\] _0808_ VGND VGND VPWR VPWR _0809_ sky130_fd_sc_hd__o21ai_2
XFILLER_0_59_51 VGND VGND VPWR VPWR sky130_fd_sc_hd__decap_4
XFILLER_0_11_210 VGND VGND VPWR VPWR sky130_fd_sc_hd__fill_2
X_6284_ u_pe_array.g_pe_row\[0\].g_pe_col\[0\].u_pe.psum_out\[8\] _3059_ VGND VGND
+ VPWR VPWR _3074_ sky130_fd_sc_hd__nor2_1
X_5304_ u_pe_array.g_pe_row\[1\].g_pe_col\[2\].u_pe.psum_out\[7\] u_pe_array.g_pe_row\[1\].g_pe_col\[2\].u_pe.psum_out\[8\]
+ _2158_ VGND VGND VPWR VPWR _2249_ sky130_fd_sc_hd__o21a_1
X_3496_ _0754_ _0757_ VGND VGND VPWR VPWR _0758_ sky130_fd_sc_hd__and2_2
X_5235_ _2185_ _2186_ VGND VGND VPWR VPWR _2187_ sky130_fd_sc_hd__and2b_1
X_5166_ _2135_ _2136_ VGND VGND VPWR VPWR _2137_ sky130_fd_sc_hd__xnor2_1
X_4117_ net586 _1138_ _1258_ _1261_ VGND VGND VPWR VPWR _0099_ sky130_fd_sc_hd__a22o_1
X_5097_ _2072_ _2074_ VGND VGND VPWR VPWR _2075_ sky130_fd_sc_hd__xor2_1
XANTENNA__7550__RESET_B net74 VGND VGND VPWR VPWR sky130_fd_sc_hd__diode_2
XFILLER_0_78_221 VGND VGND VPWR VPWR sky130_fd_sc_hd__fill_2
X_4048_ _1203_ _1205_ VGND VGND VPWR VPWR _1206_ sky130_fd_sc_hd__xor2_2
XPHY_216 VGND VGND VPWR VPWR sky130_fd_sc_hd__decap_3
XPHY_205 VGND VGND VPWR VPWR sky130_fd_sc_hd__decap_3
XFILLER_0_66_416 VGND VGND VPWR VPWR sky130_fd_sc_hd__fill_2
XPHY_227 VGND VGND VPWR VPWR sky130_fd_sc_hd__decap_3
X_5999_ _2822_ _2830_ _2831_ _2832_ VGND VGND VPWR VPWR _2833_ sky130_fd_sc_hd__a31o_1
XFILLER_0_93_279 VGND VGND VPWR VPWR sky130_fd_sc_hd__fill_1
XFILLER_0_47_663 VGND VGND VPWR VPWR sky130_fd_sc_hd__fill_1
XFILLER_0_74_493 VGND VGND VPWR VPWR sky130_fd_sc_hd__fill_2
XFILLER_0_74_471 VGND VGND VPWR VPWR sky130_fd_sc_hd__decap_4
XFILLER_0_62_611 VGND VGND VPWR VPWR sky130_fd_sc_hd__fill_2
XFILLER_0_19_376 VGND VGND VPWR VPWR sky130_fd_sc_hd__decap_6
XFILLER_0_61_132 VGND VGND VPWR VPWR sky130_fd_sc_hd__fill_2
XFILLER_0_61_121 VGND VGND VPWR VPWR sky130_fd_sc_hd__fill_2
XFILLER_0_22_508 VGND VGND VPWR VPWR sky130_fd_sc_hd__decap_3
XANTENNA__5181__A1 _1832_ VGND VGND VPWR VPWR sky130_fd_sc_hd__diode_2
XFILLER_0_30_541 VGND VGND VPWR VPWR sky130_fd_sc_hd__fill_1
XANTENNA__5335__A _2273_ VGND VGND VPWR VPWR sky130_fd_sc_hd__diode_2
XANTENNA__6130__B1 _2571_ VGND VGND VPWR VPWR sky130_fd_sc_hd__diode_2
XFILLER_0_30_596 VGND VGND VPWR VPWR sky130_fd_sc_hd__decap_3
Xhold9 u_pe_array.g_pe_row\[2\].g_pe_col\[1\].u_pe.w_buffer\[0\] VGND VGND VPWR VPWR
+ net85 sky130_fd_sc_hd__dlygate4sd3_1
XANTENNA_input29_A w_in_flat[2] VGND VGND VPWR VPWR sky130_fd_sc_hd__diode_2
XANTENNA__6166__A _2873_ VGND VGND VPWR VPWR sky130_fd_sc_hd__diode_2
XANTENNA__7291__RESET_B net813 VGND VGND VPWR VPWR sky130_fd_sc_hd__diode_2
XANTENNA__7220__RESET_B net812 VGND VGND VPWR VPWR sky130_fd_sc_hd__diode_2
XFILLER_0_84_213 VGND VGND VPWR VPWR sky130_fd_sc_hd__fill_2
XFILLER_0_38_641 VGND VGND VPWR VPWR sky130_fd_sc_hd__decap_3
XFILLER_0_84_279 VGND VGND VPWR VPWR sky130_fd_sc_hd__fill_2
XFILLER_0_84_257 VGND VGND VPWR VPWR sky130_fd_sc_hd__decap_6
XFILLER_0_37_140 VGND VGND VPWR VPWR sky130_fd_sc_hd__fill_1
XFILLER_0_38_674 VGND VGND VPWR VPWR sky130_fd_sc_hd__decap_3
XFILLER_0_25_302 VGND VGND VPWR VPWR sky130_fd_sc_hd__decap_4
XFILLER_0_37_173 VGND VGND VPWR VPWR sky130_fd_sc_hd__decap_8
XFILLER_0_80_430 VGND VGND VPWR VPWR sky130_fd_sc_hd__fill_2
XANTENNA__3675__D _0869_ VGND VGND VPWR VPWR sky130_fd_sc_hd__diode_2
XFILLER_0_111_69 VPWR VGND VPWR VGND sky130_ef_sc_hd__decap_12
XANTENNA__3970__A2 _0996_ VGND VGND VPWR VPWR sky130_fd_sc_hd__diode_2
Xhold409 u_pe_array.g_pe_row\[3\].g_pe_col\[0\].u_pe.psum_out\[1\] VGND VGND VPWR
+ VPWR net485 sky130_fd_sc_hd__dlygate4sd3_1
XANTENNA__3464__S _0730_ VGND VGND VPWR VPWR sky130_fd_sc_hd__diode_2
XFILLER_0_0_413 VGND VGND VPWR VPWR sky130_fd_sc_hd__decap_6
XFILLER_0_110_237 VGND VGND VPWR VPWR sky130_fd_sc_hd__fill_2
XFILLER_0_96_27 VGND VGND VPWR VPWR sky130_fd_sc_hd__fill_1
XFILLER_0_110_259 VGND VGND VPWR VPWR sky130_fd_sc_hd__fill_1
XANTENNA__6775__S _3366_ VGND VGND VPWR VPWR sky130_fd_sc_hd__diode_2
XTAP_703 VGND VPWR sky130_fd_sc_hd__tapvpwrvgnd_1
XTAP_725 VGND VPWR sky130_fd_sc_hd__tapvpwrvgnd_1
XTAP_714 VGND VPWR sky130_fd_sc_hd__tapvpwrvgnd_1
XANTENNA__7379__RESET_B net812 VGND VGND VPWR VPWR sky130_fd_sc_hd__diode_2
X_5020_ _0836_ _2009_ _2011_ _0833_ net509 VGND VGND VPWR VPWR _0252_ sky130_fd_sc_hd__a32o_1
XTAP_758 VGND VPWR sky130_fd_sc_hd__tapvpwrvgnd_1
XTAP_736 VGND VPWR sky130_fd_sc_hd__tapvpwrvgnd_1
XTAP_747 VGND VPWR sky130_fd_sc_hd__tapvpwrvgnd_1
XTAP_769 VGND VPWR sky130_fd_sc_hd__tapvpwrvgnd_1
Xclkbuf_leaf_2_clk clknet_3_0__leaf_clk VGND VGND VPWR VPWR clknet_leaf_2_clk sky130_fd_sc_hd__clkbuf_16
XANTENNA__7308__RESET_B net814 VGND VGND VPWR VPWR sky130_fd_sc_hd__diode_2
XANTENNA__4295__S _0855_ VGND VGND VPWR VPWR sky130_fd_sc_hd__diode_2
XANTENNA__4435__B1 _1258_ VGND VGND VPWR VPWR sky130_fd_sc_hd__diode_2
XFILLER_0_45_97 VGND VGND VPWR VPWR sky130_fd_sc_hd__decap_8
X_6971_ clknet_leaf_87_clk net83 net819 VGND VGND VPWR VPWR u_pe_array.g_pe_row\[3\].g_pe_col\[2\].u_pe.w_reg\[0\]
+ sky130_fd_sc_hd__dfrtp_4
XFILLER_0_88_574 VGND VGND VPWR VPWR sky130_fd_sc_hd__fill_2
XANTENNA__3789__A2 _0834_ VGND VGND VPWR VPWR sky130_fd_sc_hd__diode_2
XFILLER_0_0_11 VPWR VGND VPWR VGND sky130_ef_sc_hd__decap_12
X_5922_ u_pe_array.g_pe_row\[0\].g_pe_col\[2\].u_pe.act_val\[2\] u_pe_array.g_pe_row\[0\].g_pe_col\[2\].u_pe.w_reg\[0\]
+ _2752_ VGND VGND VPWR VPWR _2762_ sky130_fd_sc_hd__and3_1
XFILLER_0_8_513 VPWR VGND VPWR VGND sky130_ef_sc_hd__decap_12
X_5853_ u_pe_array.g_pe_row\[0\].g_pe_col\[3\].u_pe.psum_out\[11\] _2611_ VGND VGND
+ VPWR VPWR _2713_ sky130_fd_sc_hd__and2b_1
XFILLER_0_75_257 VGND VGND VPWR VPWR sky130_fd_sc_hd__decap_8
XANTENNA__6943__RESET_B net74 VGND VGND VPWR VPWR sky130_fd_sc_hd__diode_2
X_4804_ _1826_ net2 _0754_ VGND VGND VPWR VPWR _1827_ sky130_fd_sc_hd__mux2_1
X_5784_ _2641_ _2650_ VGND VGND VPWR VPWR _2651_ sky130_fd_sc_hd__nor2_1
X_4735_ u_pe_array.g_pe_row\[2\].g_pe_col\[1\].u_pe.psum_out\[11\] _1672_ VGND VGND
+ VPWR VPWR _1776_ sky130_fd_sc_hd__and2b_1
XFILLER_0_8_557 VPWR VGND VPWR VGND sky130_ef_sc_hd__decap_12
XFILLER_0_16_302 VGND VGND VPWR VPWR sky130_fd_sc_hd__decap_6
XFILLER_0_16_313 VGND VGND VPWR VPWR sky130_fd_sc_hd__fill_2
X_7523_ clknet_leaf_92_clk _0572_ VGND VGND VPWR VPWR u_pe_array.u_fifo2.buffer\[6\]\[10\]
+ sky130_fd_sc_hd__dfxtp_1
XFILLER_0_28_184 VGND VGND VPWR VPWR sky130_fd_sc_hd__fill_2
X_4666_ _1712_ _1713_ net757 _0916_ VGND VGND VPWR VPWR _0196_ sky130_fd_sc_hd__a2bb2o_1
XFILLER_0_9_75 VGND VGND VPWR VPWR sky130_fd_sc_hd__decap_3
X_7454_ clknet_leaf_2_clk _0503_ VGND VGND VPWR VPWR u_pe_array.u_fifo2.buffer\[1\]\[6\]
+ sky130_fd_sc_hd__dfxtp_1
XFILLER_0_114_587 VGND VGND VPWR VPWR sky130_fd_sc_hd__fill_1
X_7385_ clknet_leaf_47_clk _0438_ net13 VGND VGND VPWR VPWR u_pe_array.g_pe_row\[0\].g_pe_col\[1\].u_pe.psum_out\[9\]
+ sky130_fd_sc_hd__dfrtp_2
X_4597_ u_pe_array.g_pe_row\[2\].g_pe_col\[1\].u_pe.act_val\[5\] u_pe_array.g_pe_row\[2\].g_pe_col\[1\].u_pe.psum_out\[5\]
+ _0770_ VGND VGND VPWR VPWR _1657_ sky130_fd_sc_hd__mux2_1
X_6405_ _3164_ VGND VGND VPWR VPWR _3165_ sky130_fd_sc_hd__clkbuf_4
XFILLER_0_3_251 VGND VGND VPWR VPWR sky130_fd_sc_hd__fill_2
X_3617_ u_pe_array.g_pe_row\[2\].g_pe_col\[2\].u_pe.act_val\[4\] u_pe_array.g_pe_row\[2\].g_pe_col\[2\].u_pe.psum_out\[4\]
+ _0755_ VGND VGND VPWR VPWR _0846_ sky130_fd_sc_hd__mux2_1
X_6336_ _3117_ VGND VGND VPWR VPWR _0462_ sky130_fd_sc_hd__clkbuf_1
X_3548_ u_fsm.v_cnt\[0\] VGND VGND VPWR VPWR _0794_ sky130_fd_sc_hd__inv_2
X_6267_ u_pe_array.g_pe_row\[0\].g_pe_col\[0\].u_pe.psum_out\[7\] VGND VGND VPWR VPWR
+ _3058_ sky130_fd_sc_hd__inv_2
X_3479_ u_pe_array.g_pe_row\[3\].g_pe_col\[0\].u_pe.psum_out\[6\] _0745_ _0746_ _0747_
+ VGND VGND VPWR VPWR net58 sky130_fd_sc_hd__o211a_2
X_6198_ _2991_ _2993_ _2994_ VGND VGND VPWR VPWR _2995_ sky130_fd_sc_hd__or3_1
X_5218_ _2166_ _2170_ VGND VGND VPWR VPWR _2171_ sky130_fd_sc_hd__xor2_1
XANTENNA__7049__RESET_B net819 VGND VGND VPWR VPWR sky130_fd_sc_hd__diode_2
XANTENNA__5602__B u_pe_array.g_pe_row\[1\].g_pe_col\[0\].u_pe.w_reg\[0\] VGND VGND
+ VPWR VPWR sky130_fd_sc_hd__diode_2
X_5149_ _2120_ _2121_ _2112_ VGND VGND VPWR VPWR _2122_ sky130_fd_sc_hd__a21oi_1
XFILLER_0_98_327 VGND VGND VPWR VPWR sky130_fd_sc_hd__decap_6
XFILLER_0_79_541 VGND VGND VPWR VPWR sky130_fd_sc_hd__fill_2
XANTENNA__6179__B1 _2873_ VGND VGND VPWR VPWR sky130_fd_sc_hd__diode_2
XFILLER_0_109_337 VPWR VGND VPWR VGND sky130_ef_sc_hd__decap_12
XFILLER_0_94_577 VGND VGND VPWR VPWR sky130_fd_sc_hd__decap_3
XFILLER_0_94_566 VGND VGND VPWR VPWR sky130_fd_sc_hd__fill_1
XANTENNA__5049__B _2029_ VGND VGND VPWR VPWR sky130_fd_sc_hd__diode_2
XFILLER_0_35_622 VGND VGND VPWR VPWR sky130_fd_sc_hd__fill_2
XFILLER_0_105_521 VGND VGND VPWR VPWR sky130_fd_sc_hd__fill_2
XANTENNA__5154__B2 _0916_ VGND VGND VPWR VPWR sky130_fd_sc_hd__diode_2
XFILLER_0_22_349 VGND VGND VPWR VPWR sky130_fd_sc_hd__fill_2
XANTENNA__6103__B1 net71 VGND VGND VPWR VPWR sky130_fd_sc_hd__diode_2
XANTENNA__6595__S _3254_ VGND VGND VPWR VPWR sky130_fd_sc_hd__diode_2
XANTENNA__7401__RESET_B net817 VGND VGND VPWR VPWR sky130_fd_sc_hd__diode_2
XFILLER_0_100_281 VGND VGND VPWR VPWR sky130_fd_sc_hd__decap_3
XANTENNA__4665__B1 _0914_ VGND VGND VPWR VPWR sky130_fd_sc_hd__diode_2
XFILLER_0_82_29 VGND VGND VPWR VPWR sky130_fd_sc_hd__decap_8
XFILLER_0_15_34 VGND VGND VPWR VPWR sky130_fd_sc_hd__decap_3
XFILLER_0_97_393 VPWR VGND VPWR VGND sky130_ef_sc_hd__decap_12
XFILLER_0_15_78 VGND VGND VPWR VPWR sky130_fd_sc_hd__fill_1
XFILLER_0_85_555 VGND VGND VPWR VPWR sky130_fd_sc_hd__fill_2
XFILLER_0_5_505 VPWR VGND VPWR VGND sky130_ef_sc_hd__decap_12
XANTENNA__4196__A2 _1152_ VGND VGND VPWR VPWR sky130_fd_sc_hd__diode_2
XFILLER_0_72_249 VGND VGND VPWR VPWR sky130_fd_sc_hd__decap_3
XFILLER_0_53_452 VGND VGND VPWR VPWR sky130_fd_sc_hd__decap_3
XFILLER_0_25_110 VGND VGND VPWR VPWR sky130_fd_sc_hd__fill_2
XFILLER_0_31_66 VGND VGND VPWR VPWR sky130_fd_sc_hd__fill_2
XFILLER_0_13_316 VGND VGND VPWR VPWR sky130_fd_sc_hd__fill_2
X_4520_ _1589_ _1593_ VGND VGND VPWR VPWR _1594_ sky130_fd_sc_hd__and2b_1
XFILLER_0_41_614 VGND VGND VPWR VPWR sky130_fd_sc_hd__fill_2
XFILLER_0_103_3 VPWR VGND VPWR VGND sky130_ef_sc_hd__decap_12
Xhold206 u_pe_array.u_fifo2.buffer\[4\]\[9\] VGND VGND VPWR VPWR net282 sky130_fd_sc_hd__dlygate4sd3_1
X_4451_ u_pe_array.g_pe_row\[2\].g_pe_col\[2\].u_pe.w_reg\[0\] u_pe_array.g_pe_row\[2\].g_pe_col\[2\].u_pe.act_val\[0\]
+ u_pe_array.g_pe_row\[2\].g_pe_col\[2\].u_pe.psum_out\[0\] VGND VGND VPWR VPWR _1531_
+ sky130_fd_sc_hd__a21o_1
Xhold217 u_pe_array.g_pe_row\[0\].g_pe_col\[3\].u_pe.move_reg\[11\] VGND VGND VPWR
+ VPWR net293 sky130_fd_sc_hd__dlygate4sd3_1
XFILLER_0_40_135 VGND VGND VPWR VPWR sky130_fd_sc_hd__decap_4
X_7170_ clknet_leaf_41_clk _0237_ net813 VGND VGND VPWR VPWR u_pe_array.g_pe_row\[2\].g_pe_col\[0\].u_pe.psum_out\[4\]
+ sky130_fd_sc_hd__dfrtp_1
Xhold239 u_pe_array.u_fifo2.buffer\[8\]\[7\] VGND VGND VPWR VPWR net315 sky130_fd_sc_hd__dlygate4sd3_1
Xhold228 u_pe_array.u_fifo2.buffer\[2\]\[7\] VGND VGND VPWR VPWR net304 sky130_fd_sc_hd__dlygate4sd3_1
X_6121_ _2928_ _2929_ VGND VGND VPWR VPWR _2930_ sky130_fd_sc_hd__or2_1
X_4382_ _1407_ u_pe_array.g_pe_row\[2\].g_pe_col\[3\].u_pe.psum_out\[8\] VGND VGND
+ VPWR VPWR _1482_ sky130_fd_sc_hd__nand2_1
XTAP_500 VGND VPWR sky130_fd_sc_hd__tapvpwrvgnd_1
XTAP_511 VGND VPWR sky130_fd_sc_hd__tapvpwrvgnd_1
XTAP_522 VGND VPWR sky130_fd_sc_hd__tapvpwrvgnd_1
XTAP_533 VGND VPWR sky130_fd_sc_hd__tapvpwrvgnd_1
X_6052_ u_pe_array.g_pe_row\[0\].g_pe_col\[1\].u_pe.psum_out\[12\] net162 _0729_ VGND
+ VGND VPWR VPWR _2868_ sky130_fd_sc_hd__mux2_1
XFILLER_0_56_41 VPWR VGND VPWR VGND sky130_ef_sc_hd__decap_12
XTAP_544 VGND VPWR sky130_fd_sc_hd__tapvpwrvgnd_1
XTAP_566 VGND VPWR sky130_fd_sc_hd__tapvpwrvgnd_1
XTAP_555 VGND VPWR sky130_fd_sc_hd__tapvpwrvgnd_1
XTAP_577 VGND VPWR sky130_fd_sc_hd__tapvpwrvgnd_1
XTAP_588 VGND VPWR sky130_fd_sc_hd__tapvpwrvgnd_1
XTAP_599 VGND VPWR sky130_fd_sc_hd__tapvpwrvgnd_1
X_5003_ u_pe_array.u_fifo2.buffer\[0\]\[3\] _1962_ VGND VGND VPWR VPWR _1996_ sky130_fd_sc_hd__or2_1
X_6954_ clknet_leaf_80_clk _0035_ net815 VGND VGND VPWR VPWR u_pe_array.g_pe_row\[3\].g_pe_col\[3\].u_pe.psum_out\[11\]
+ sky130_fd_sc_hd__dfrtp_1
XANTENNA__5620__A2 u_pe_array.g_pe_row\[1\].g_pe_col\[0\].u_pe.w_reg\[0\] VGND VGND
+ VPWR VPWR sky130_fd_sc_hd__diode_2
X_5905_ _2744_ _2745_ _2742_ VGND VGND VPWR VPWR _2747_ sky130_fd_sc_hd__o21ai_1
X_6885_ _3425_ VGND VGND VPWR VPWR _0703_ sky130_fd_sc_hd__clkbuf_1
XANTENNA__4054__A _1145_ VGND VGND VPWR VPWR sky130_fd_sc_hd__diode_2
XFILLER_0_91_514 VGND VGND VPWR VPWR sky130_fd_sc_hd__fill_2
X_5836_ u_pe_array.g_pe_row\[0\].g_pe_col\[3\].u_pe.psum_out\[8\] _2695_ _2697_ _2687_
+ VGND VGND VPWR VPWR _2698_ sky130_fd_sc_hd__a22o_1
XANTENNA__5908__B1 _2571_ VGND VGND VPWR VPWR sky130_fd_sc_hd__diode_2
X_5767_ u_pe_array.g_pe_row\[0\].g_pe_col\[3\].u_pe.w_reg\[0\] u_pe_array.g_pe_row\[0\].g_pe_col\[3\].u_pe.act_val\[2\]
+ _2620_ VGND VGND VPWR VPWR _2635_ sky130_fd_sc_hd__and3_1
X_5698_ net778 _2387_ _2174_ _2585_ VGND VGND VPWR VPWR _0356_ sky130_fd_sc_hd__a22o_1
X_4718_ u_pe_array.g_pe_row\[2\].g_pe_col\[1\].u_pe.psum_out\[8\] _1758_ _1760_ _1750_
+ VGND VGND VPWR VPWR _1761_ sky130_fd_sc_hd__a22o_1
X_7506_ clknet_leaf_93_clk _0555_ VGND VGND VPWR VPWR u_pe_array.u_fifo2.buffer\[5\]\[6\]
+ sky130_fd_sc_hd__dfxtp_1
X_4649_ _1695_ _1697_ VGND VGND VPWR VPWR _1698_ sky130_fd_sc_hd__nor2_1
XFILLER_0_31_113 VGND VGND VPWR VPWR sky130_fd_sc_hd__fill_2
XFILLER_0_31_124 VGND VGND VPWR VPWR sky130_fd_sc_hd__decap_8
X_7437_ clknet_leaf_3_clk _0486_ VGND VGND VPWR VPWR u_pe_array.u_fifo2.buffer\[0\]\[2\]
+ sky130_fd_sc_hd__dfxtp_1
XANTENNA__6884__A1 _3134_ VGND VGND VPWR VPWR sky130_fd_sc_hd__diode_2
X_7368_ clknet_leaf_48_clk _0423_ net812 VGND VGND VPWR VPWR u_pe_array.g_pe_row\[0\].g_pe_col\[0\].u_pe.move_reg\[7\]
+ sky130_fd_sc_hd__dfrtp_1
Xhold740 u_pe_array.g_pe_row\[0\].g_pe_col\[2\].u_pe.psum_out\[8\] VGND VGND VPWR
+ VPWR net824 sky130_fd_sc_hd__dlygate4sd3_1
X_7299_ clknet_leaf_32_clk _0358_ net817 VGND VGND VPWR VPWR u_pe_array.g_pe_row\[0\].g_pe_col\[3\].u_pe.w_buffer\[0\]
+ sky130_fd_sc_hd__dfrtp_4
X_6319_ u_pe_array.u_fifo1.count\[1\] u_pe_array.u_fifo1.count\[2\] u_pe_array.u_fifo1.count\[0\]
+ u_pe_array.u_fifo1.count\[3\] VGND VGND VPWR VPWR _3104_ sky130_fd_sc_hd__or4bb_1
XANTENNA__6636__B2 _3287_ VGND VGND VPWR VPWR sky130_fd_sc_hd__diode_2
XFILLER_0_99_669 VGND VGND VPWR VPWR sky130_fd_sc_hd__decap_3
XANTENNA_hold545_A u_pe_array.g_pe_row\[2\].g_pe_col\[0\].u_pe.move_reg\[7\] VGND
+ VGND VPWR VPWR sky130_fd_sc_hd__diode_2
XFILLER_0_79_393 VGND VGND VPWR VPWR sky130_fd_sc_hd__fill_2
XFILLER_0_67_544 VGND VGND VPWR VPWR sky130_fd_sc_hd__fill_2
XFILLER_0_109_101 VGND VGND VPWR VPWR sky130_fd_sc_hd__fill_2
XFILLER_0_94_341 VPWR VGND VPWR VGND sky130_ef_sc_hd__decap_12
XFILLER_0_94_330 VGND VGND VPWR VPWR sky130_fd_sc_hd__fill_1
XFILLER_0_35_474 VGND VGND VPWR VPWR sky130_fd_sc_hd__decap_3
XFILLER_0_50_433 VGND VGND VPWR VPWR sky130_fd_sc_hd__fill_2
XFILLER_0_22_113 VGND VGND VPWR VPWR sky130_fd_sc_hd__fill_2
XFILLER_0_50_477 VGND VGND VPWR VPWR sky130_fd_sc_hd__fill_2
XANTENNA__5523__A _2345_ VGND VGND VPWR VPWR sky130_fd_sc_hd__diode_2
XANTENNA__6627__A1 net7 VGND VGND VPWR VPWR sky130_fd_sc_hd__diode_2
XANTENNA__4102__A2 _1152_ VGND VGND VPWR VPWR sky130_fd_sc_hd__diode_2
XFILLER_0_89_102 VGND VGND VPWR VPWR sky130_fd_sc_hd__fill_2
XANTENNA__4139__A u_pe_array.g_pe_row\[3\].g_pe_col\[0\].u_pe.w_reg\[0\] VGND VGND
+ VPWR VPWR sky130_fd_sc_hd__diode_2
XFILLER_0_26_33 VGND VGND VPWR VPWR sky130_fd_sc_hd__fill_2
XFILLER_0_26_55 VGND VGND VPWR VPWR sky130_fd_sc_hd__fill_2
X_3951_ u_pe_array.g_pe_row\[2\].g_pe_col\[0\].u_pe.act_val\[2\] u_pe_array.g_pe_row\[2\].g_pe_col\[0\].u_pe.psum_out\[2\]
+ _0755_ VGND VGND VPWR VPWR _1126_ sky130_fd_sc_hd__mux2_2
XFILLER_0_73_503 VGND VGND VPWR VPWR sky130_fd_sc_hd__fill_1
XANTENNA__4810__A0 _1830_ VGND VGND VPWR VPWR sky130_fd_sc_hd__diode_2
XFILLER_0_73_536 VGND VGND VPWR VPWR sky130_fd_sc_hd__fill_1
X_6670_ u_pe_array.u_fifo1.rd_ptr\[1\] u_pe_array.u_fifo1.rd_ptr\[0\] _3306_ VGND
+ VGND VPWR VPWR _3308_ sky130_fd_sc_hd__and3_1
XFILLER_0_58_599 VGND VGND VPWR VPWR sky130_fd_sc_hd__fill_2
X_3882_ _1064_ _1065_ _1067_ VGND VGND VPWR VPWR _1068_ sky130_fd_sc_hd__and3_1
XFILLER_0_42_65 VGND VGND VPWR VPWR sky130_fd_sc_hd__fill_1
XFILLER_0_73_558 VGND VGND VPWR VPWR sky130_fd_sc_hd__fill_2
X_5621_ _2514_ _2515_ VGND VGND VPWR VPWR _2516_ sky130_fd_sc_hd__nand2_1
XANTENNA__6801__B net816 VGND VGND VPWR VPWR sky130_fd_sc_hd__diode_2
XFILLER_0_45_249 VGND VGND VPWR VPWR sky130_fd_sc_hd__decap_4
XFILLER_0_60_219 VGND VGND VPWR VPWR sky130_fd_sc_hd__fill_2
X_5552_ net566 _2144_ _1655_ _2462_ VGND VGND VPWR VPWR _0333_ sky130_fd_sc_hd__a22o_1
XFILLER_0_41_400 VGND VGND VPWR VPWR sky130_fd_sc_hd__fill_1
XANTENNA_clkbuf_leaf_83_clk_A clknet_3_1__leaf_clk VGND VGND VPWR VPWR sky130_fd_sc_hd__diode_2
X_4503_ u_pe_array.g_pe_row\[2\].g_pe_col\[2\].u_pe.act_val\[4\] _1536_ VGND VGND
+ VPWR VPWR _1578_ sky130_fd_sc_hd__and2b_1
XANTENNA__7394__RESET_B net817 VGND VGND VPWR VPWR sky130_fd_sc_hd__diode_2
X_5483_ _2399_ _2403_ VGND VGND VPWR VPWR _2404_ sky130_fd_sc_hd__and2b_1
XFILLER_0_14_669 VGND VGND VPWR VPWR sky130_fd_sc_hd__decap_8
X_7222_ clknet_leaf_51_clk net165 net812 VGND VGND VPWR VPWR u_pe_array.g_pe_row\[1\].g_pe_col\[1\].u_pe.move_reg\[11\]
+ sky130_fd_sc_hd__dfrtp_1
X_4434_ u_pe_array.g_pe_row\[3\].g_pe_col\[1\].u_pe.psum_out\[5\] u_pe_array.g_pe_row\[3\].g_pe_col\[1\].u_pe.act_val\[5\]
+ _0769_ VGND VGND VPWR VPWR _1522_ sky130_fd_sc_hd__mux2_1
XANTENNA__7323__RESET_B net814 VGND VGND VPWR VPWR sky130_fd_sc_hd__diode_2
XFILLER_0_6_65 VPWR VGND VPWR VGND sky130_ef_sc_hd__decap_12
X_4365_ _1464_ _1466_ VGND VGND VPWR VPWR _1467_ sky130_fd_sc_hd__xor2_1
X_7153_ clknet_leaf_74_clk _0222_ net814 VGND VGND VPWR VPWR u_pe_array.g_pe_row\[1\].g_pe_col\[3\].u_pe.act_val\[2\]
+ sky130_fd_sc_hd__dfrtp_2
X_6104_ _2913_ _2914_ net762 _0875_ VGND VGND VPWR VPWR _0433_ sky130_fd_sc_hd__a2bb2o_1
XFILLER_0_67_51 VGND VGND VPWR VPWR sky130_fd_sc_hd__decap_4
X_7084_ clknet_leaf_12_clk _0157_ net816 VGND VGND VPWR VPWR u_pe_array.g_pe_row\[2\].g_pe_col\[1\].u_pe.move_reg\[6\]
+ sky130_fd_sc_hd__dfrtp_1
XTAP_341 VGND VPWR sky130_fd_sc_hd__tapvpwrvgnd_1
XTAP_330 VGND VPWR sky130_fd_sc_hd__tapvpwrvgnd_1
X_6035_ net784 _2738_ _2592_ _2859_ VGND VGND VPWR VPWR _0419_ sky130_fd_sc_hd__a22o_1
XTAP_385 VGND VPWR sky130_fd_sc_hd__tapvpwrvgnd_1
XTAP_374 VGND VPWR sky130_fd_sc_hd__tapvpwrvgnd_1
XTAP_363 VGND VPWR sky130_fd_sc_hd__tapvpwrvgnd_1
XTAP_352 VGND VPWR sky130_fd_sc_hd__tapvpwrvgnd_1
X_4296_ net413 _1392_ _1404_ _1399_ VGND VGND VPWR VPWR _0135_ sky130_fd_sc_hd__a22o_1
XANTENNA_clkbuf_leaf_21_clk_A clknet_3_2__leaf_clk VGND VGND VPWR VPWR sky130_fd_sc_hd__diode_2
XTAP_396 VGND VPWR sky130_fd_sc_hd__tapvpwrvgnd_1
XFILLER_0_96_639 VGND VGND VPWR VPWR sky130_fd_sc_hd__fill_2
XFILLER_0_96_628 VGND VGND VPWR VPWR sky130_fd_sc_hd__decap_8
XTAP_1529 VGND VPWR sky130_fd_sc_hd__tapvpwrvgnd_1
XTAP_1507 VGND VPWR sky130_fd_sc_hd__tapvpwrvgnd_1
XTAP_1518 VGND VPWR sky130_fd_sc_hd__tapvpwrvgnd_1
XPHY_14 VGND VGND VPWR VPWR sky130_fd_sc_hd__decap_3
XPHY_25 VGND VGND VPWR VPWR sky130_fd_sc_hd__decap_3
XPHY_36 VGND VGND VPWR VPWR sky130_fd_sc_hd__decap_3
XANTENNA__5054__B1 _1534_ VGND VGND VPWR VPWR sky130_fd_sc_hd__diode_2
XPHY_47 VGND VGND VPWR VPWR sky130_fd_sc_hd__decap_3
XANTENNA_clkbuf_leaf_36_clk_A clknet_3_3__leaf_clk VGND VGND VPWR VPWR sky130_fd_sc_hd__diode_2
XPHY_58 VGND VGND VPWR VPWR sky130_fd_sc_hd__decap_3
XPHY_69 VGND VGND VPWR VPWR sky130_fd_sc_hd__decap_3
X_6937_ clknet_leaf_86_clk _0020_ net74 VGND VGND VPWR VPWR u_pe_array.g_pe_row\[3\].g_pe_col\[2\].u_pe.move_reg\[9\]
+ sky130_fd_sc_hd__dfrtp_1
X_6868_ net450 _3118_ _3412_ VGND VGND VPWR VPWR _3417_ sky130_fd_sc_hd__mux2_1
XFILLER_0_9_641 VPWR VGND VPWR VGND sky130_ef_sc_hd__decap_12
XFILLER_0_91_333 VGND VGND VPWR VPWR sky130_fd_sc_hd__decap_3
XFILLER_0_29_290 VGND VGND VPWR VPWR sky130_fd_sc_hd__fill_2
X_5819_ _2671_ _2678_ VGND VGND VPWR VPWR _2682_ sky130_fd_sc_hd__nand2_1
XFILLER_0_106_137 VGND VGND VPWR VPWR sky130_fd_sc_hd__decap_3
X_6799_ net280 _3134_ _3366_ VGND VGND VPWR VPWR _3379_ sky130_fd_sc_hd__mux2_1
XFILLER_0_106_115 VGND VGND VPWR VPWR sky130_fd_sc_hd__fill_1
XFILLER_0_8_195 VGND VGND VPWR VPWR sky130_fd_sc_hd__fill_1
XANTENNA__5109__A1 _2029_ VGND VGND VPWR VPWR sky130_fd_sc_hd__diode_2
XANTENNA__7064__RESET_B net819 VGND VGND VPWR VPWR sky130_fd_sc_hd__diode_2
XFILLER_0_32_477 VGND VGND VPWR VPWR sky130_fd_sc_hd__fill_2
Xhold581 u_pe_array.g_pe_row\[3\].g_pe_col\[0\].u_pe.psum_out\[3\] VGND VGND VPWR
+ VPWR net657 sky130_fd_sc_hd__dlygate4sd3_1
XFILLER_0_12_190 VGND VGND VPWR VPWR sky130_fd_sc_hd__decap_4
Xhold570 u_pe_array.g_pe_row\[0\].g_pe_col\[3\].u_pe.psum_out\[10\] VGND VGND VPWR
+ VPWR net646 sky130_fd_sc_hd__dlygate4sd3_1
XANTENNA__5156__A_N _2029_ VGND VGND VPWR VPWR sky130_fd_sc_hd__diode_2
Xhold592 u_pe_array.g_pe_row\[0\].g_pe_col\[3\].u_pe.psum_out\[8\] VGND VGND VPWR
+ VPWR net668 sky130_fd_sc_hd__dlygate4sd3_1
XFILLER_0_99_433 VGND VGND VPWR VPWR sky130_fd_sc_hd__fill_2
XANTENNA__5997__B _2743_ VGND VGND VPWR VPWR sky130_fd_sc_hd__diode_2
XFILLER_0_99_466 VGND VGND VPWR VPWR sky130_fd_sc_hd__fill_1
XANTENNA_input11_A h_in1[4] VGND VGND VPWR VPWR sky130_fd_sc_hd__diode_2
XFILLER_0_87_639 VGND VGND VPWR VPWR sky130_fd_sc_hd__fill_2
XFILLER_0_67_352 VGND VGND VPWR VPWR sky130_fd_sc_hd__fill_1
XFILLER_0_103_15 VPWR VGND VPWR VGND sky130_ef_sc_hd__decap_12
XFILLER_0_27_205 VGND VGND VPWR VPWR sky130_fd_sc_hd__decap_3
XFILLER_0_55_558 VGND VGND VPWR VPWR sky130_fd_sc_hd__fill_2
XFILLER_0_82_388 VGND VGND VPWR VPWR sky130_fd_sc_hd__fill_2
XFILLER_0_70_528 VGND VGND VPWR VPWR sky130_fd_sc_hd__fill_2
XANTENNA__4556__C1 _1536_ VGND VGND VPWR VPWR sky130_fd_sc_hd__diode_2
XFILLER_0_63_591 VGND VGND VPWR VPWR sky130_fd_sc_hd__fill_2
XFILLER_0_23_422 VGND VGND VPWR VPWR sky130_fd_sc_hd__decap_3
XANTENNA__4141__B _1275_ VGND VGND VPWR VPWR sky130_fd_sc_hd__diode_2
XANTENNA__6848__A1 _3126_ VGND VGND VPWR VPWR sky130_fd_sc_hd__diode_2
XFILLER_0_11_617 VPWR VGND VPWR VGND sky130_ef_sc_hd__decap_12
XFILLER_0_23_477 VGND VGND VPWR VPWR sky130_fd_sc_hd__fill_2
X_4150_ u_pe_array.g_pe_row\[3\].g_pe_col\[0\].u_pe.w_reg\[0\] u_pe_array.g_pe_row\[3\].g_pe_col\[0\].u_pe.act_val\[2\]
+ VGND VGND VPWR VPWR _1284_ sky130_fd_sc_hd__nand2_1
XANTENNA__6076__A2 _2387_ VGND VGND VPWR VPWR sky130_fd_sc_hd__diode_2
XANTENNA__6783__S _3366_ VGND VGND VPWR VPWR sky130_fd_sc_hd__diode_2
X_4081_ _1226_ _1231_ _1234_ _1230_ VGND VGND VPWR VPWR _1235_ sky130_fd_sc_hd__a22oi_2
XANTENNA__5399__S _1661_ VGND VGND VPWR VPWR sky130_fd_sc_hd__diode_2
XFILLER_0_78_639 VGND VGND VPWR VPWR sky130_fd_sc_hd__fill_2
XANTENNA__5587__A1 _2258_ VGND VGND VPWR VPWR sky130_fd_sc_hd__diode_2
X_4983_ _1787_ _1978_ VGND VGND VPWR VPWR _1979_ sky130_fd_sc_hd__or2_1
X_6722_ _3339_ VGND VGND VPWR VPWR _0626_ sky130_fd_sc_hd__clkbuf_1
X_3934_ _1110_ _1114_ VGND VGND VPWR VPWR _1115_ sky130_fd_sc_hd__xor2_1
XFILLER_0_73_333 VGND VGND VPWR VPWR sky130_fd_sc_hd__decap_3
X_6653_ _0788_ _3104_ VGND VGND VPWR VPWR _3296_ sky130_fd_sc_hd__and2_1
X_3865_ _0864_ _1051_ _1052_ _0867_ net363 VGND VGND VPWR VPWR _0056_ sky130_fd_sc_hd__a32o_1
X_5604_ _2499_ _2478_ u_pe_array.g_pe_row\[1\].g_pe_col\[0\].u_pe.psum_out\[3\] VGND
+ VGND VPWR VPWR _2500_ sky130_fd_sc_hd__a21oi_1
XFILLER_0_73_388 VGND VGND VPWR VPWR sky130_fd_sc_hd__fill_2
XFILLER_0_61_517 VGND VGND VPWR VPWR sky130_fd_sc_hd__fill_2
X_3796_ _0832_ VGND VGND VPWR VPWR _0996_ sky130_fd_sc_hd__buf_6
X_6584_ _3260_ VGND VGND VPWR VPWR _0567_ sky130_fd_sc_hd__clkbuf_1
X_5535_ _2450_ _2440_ VGND VGND VPWR VPWR _2451_ sky130_fd_sc_hd__and2b_1
XFILLER_0_78_50 VGND VGND VPWR VPWR sky130_fd_sc_hd__decap_4
X_5466_ u_pe_array.g_pe_row\[1\].g_pe_col\[1\].u_pe.act_val\[4\] _2345_ VGND VGND
+ VPWR VPWR _2388_ sky130_fd_sc_hd__and2b_1
XFILLER_0_75_3 VGND VGND VPWR VPWR sky130_fd_sc_hd__fill_2
X_7205_ clknet_leaf_72_clk _0270_ net815 VGND VGND VPWR VPWR u_pe_array.g_pe_row\[1\].g_pe_col\[3\].u_pe.psum_out\[9\]
+ sky130_fd_sc_hd__dfrtp_1
X_4417_ u_pe_array.g_pe_row\[2\].g_pe_col\[3\].u_pe.psum_out\[12\] _1504_ VGND VGND
+ VPWR VPWR _1513_ sky130_fd_sc_hd__xor2_1
XFILLER_0_41_296 VGND VGND VPWR VPWR sky130_fd_sc_hd__fill_2
X_5397_ _1787_ _2331_ VGND VGND VPWR VPWR _2332_ sky130_fd_sc_hd__or2_1
XANTENNA__5511__B2 _0875_ VGND VGND VPWR VPWR sky130_fd_sc_hd__diode_2
XFILLER_0_1_393 VPWR VGND VPWR VGND sky130_ef_sc_hd__decap_12
XANTENNA_input3_A h_in0[2] VGND VGND VPWR VPWR sky130_fd_sc_hd__diode_2
X_4348_ u_pe_array.g_pe_row\[2\].g_pe_col\[3\].u_pe.psum_out\[5\] _1450_ VGND VGND
+ VPWR VPWR _1451_ sky130_fd_sc_hd__xnor2_1
X_7136_ clknet_leaf_9_clk _0205_ VGND VGND VPWR VPWR u_pe_array.u_fifo2.buffer\[8\]\[0\]
+ sky130_fd_sc_hd__dfxtp_1
X_4279_ net740 _1392_ _1258_ _1395_ VGND VGND VPWR VPWR _0127_ sky130_fd_sc_hd__a22o_1
X_7067_ clknet_leaf_90_clk _0140_ net819 VGND VGND VPWR VPWR u_pe_array.g_pe_row\[2\].g_pe_col\[3\].u_pe.psum_out\[4\]
+ sky130_fd_sc_hd__dfrtp_1
X_6018_ net507 _2387_ _2174_ _2849_ VGND VGND VPWR VPWR _0412_ sky130_fd_sc_hd__a22o_1
XFILLER_0_69_617 VGND VGND VPWR VPWR sky130_fd_sc_hd__fill_2
XANTENNA__3825__A1 _0864_ VGND VGND VPWR VPWR sky130_fd_sc_hd__diode_2
XFILLER_0_96_414 VGND VGND VPWR VPWR sky130_fd_sc_hd__decap_6
XTAP_1304 VGND VPWR sky130_fd_sc_hd__tapvpwrvgnd_1
XTAP_1348 VGND VPWR sky130_fd_sc_hd__tapvpwrvgnd_1
XTAP_1337 VGND VPWR sky130_fd_sc_hd__tapvpwrvgnd_1
XTAP_1326 VGND VPWR sky130_fd_sc_hd__tapvpwrvgnd_1
XTAP_1315 VGND VPWR sky130_fd_sc_hd__tapvpwrvgnd_1
XFILLER_0_77_650 VGND VGND VPWR VPWR sky130_fd_sc_hd__fill_2
XFILLER_0_49_341 VGND VGND VPWR VPWR sky130_fd_sc_hd__fill_1
XTAP_1359 VGND VPWR sky130_fd_sc_hd__tapvpwrvgnd_1
XFILLER_0_37_503 VGND VGND VPWR VPWR sky130_fd_sc_hd__fill_1
XFILLER_0_37_514 VGND VGND VPWR VPWR sky130_fd_sc_hd__fill_2
XFILLER_0_52_506 VGND VGND VPWR VPWR sky130_fd_sc_hd__decap_8
XANTENNA__7245__RESET_B net75 VGND VGND VPWR VPWR sky130_fd_sc_hd__diode_2
XFILLER_0_52_528 VGND VGND VPWR VPWR sky130_fd_sc_hd__fill_2
XANTENNA__6868__S _3412_ VGND VGND VPWR VPWR sky130_fd_sc_hd__diode_2
XFILLER_0_103_641 VPWR VGND VPWR VGND sky130_ef_sc_hd__decap_12
XFILLER_0_60_561 VPWR VGND VPWR VGND sky130_ef_sc_hd__decap_12
XFILLER_0_20_425 VGND VGND VPWR VPWR sky130_fd_sc_hd__fill_2
XFILLER_0_20_447 VGND VGND VPWR VPWR sky130_fd_sc_hd__fill_2
XANTENNA__5801__A _2611_ VGND VGND VPWR VPWR sky130_fd_sc_hd__diode_2
XFILLER_0_99_263 VGND VGND VPWR VPWR sky130_fd_sc_hd__decap_4
XFILLER_0_99_285 VGND VGND VPWR VPWR sky130_fd_sc_hd__decap_4
XFILLER_0_99_274 VGND VGND VPWR VPWR sky130_fd_sc_hd__decap_6
XFILLER_0_59_105 VGND VGND VPWR VPWR sky130_fd_sc_hd__decap_6
XFILLER_0_114_25 VGND VGND VPWR VPWR sky130_fd_sc_hd__decap_3
XFILLER_0_90_29 VGND VGND VPWR VPWR sky130_fd_sc_hd__fill_1
XFILLER_0_59_149 VGND VGND VPWR VPWR sky130_fd_sc_hd__fill_2
XANTENNA__6230__A2 _2992_ VGND VGND VPWR VPWR sky130_fd_sc_hd__diode_2
XFILLER_0_23_23 VGND VGND VPWR VPWR sky130_fd_sc_hd__decap_8
XFILLER_0_28_503 VGND VGND VPWR VPWR sky130_fd_sc_hd__fill_2
XFILLER_0_67_182 VGND VGND VPWR VPWR sky130_fd_sc_hd__fill_2
XFILLER_0_23_78 VGND VGND VPWR VPWR sky130_fd_sc_hd__decap_3
XANTENNA__3467__S _0730_ VGND VGND VPWR VPWR sky130_fd_sc_hd__diode_2
XFILLER_0_82_141 VGND VGND VPWR VPWR sky130_fd_sc_hd__fill_1
XFILLER_0_43_517 VGND VGND VPWR VPWR sky130_fd_sc_hd__fill_2
XFILLER_0_113_405 VPWR VGND VPWR VGND sky130_ef_sc_hd__decap_12
X_3650_ u_pe_array.g_pe_row\[3\].g_pe_col\[3\].u_pe.w_reg\[1\] VGND VGND VPWR VPWR
+ _0869_ sky130_fd_sc_hd__clkbuf_8
X_3581_ _0818_ VGND VGND VPWR VPWR _0819_ sky130_fd_sc_hd__buf_12
XFILLER_0_113_449 VPWR VGND VPWR VGND sky130_ef_sc_hd__decap_12
X_5320_ _2254_ _2256_ _2262_ VGND VGND VPWR VPWR _2264_ sky130_fd_sc_hd__or3_1
XFILLER_0_51_561 VGND VGND VPWR VPWR sky130_fd_sc_hd__fill_2
XFILLER_0_11_403 VGND VGND VPWR VPWR sky130_fd_sc_hd__fill_2
X_5251_ u_pe_array.g_pe_row\[1\].g_pe_col\[2\].u_pe.act_val\[4\] _2158_ VGND VGND
+ VPWR VPWR _2201_ sky130_fd_sc_hd__and2b_1
XANTENNA__6968__RESET_B net818 VGND VGND VPWR VPWR sky130_fd_sc_hd__diode_2
X_4202_ _1330_ _1331_ VGND VGND VPWR VPWR _1332_ sky130_fd_sc_hd__or2_1
X_5182_ net582 _2144_ _1655_ _2145_ VGND VGND VPWR VPWR _0280_ sky130_fd_sc_hd__a22o_1
XANTENNA__6049__A2 _2738_ VGND VGND VPWR VPWR sky130_fd_sc_hd__diode_2
X_4133_ net142 _1138_ _1269_ _1004_ VGND VGND VPWR VPWR _0107_ sky130_fd_sc_hd__a22o_1
X_4064_ _1193_ _1217_ _1218_ _1219_ VGND VGND VPWR VPWR _1220_ sky130_fd_sc_hd__o31a_1
XFILLER_0_3_55 VGND VGND VPWR VPWR sky130_fd_sc_hd__fill_1
XFILLER_0_64_41 VPWR VGND VPWR VGND sky130_ef_sc_hd__decap_12
XANTENNA__3807__B2 u_fsm.psum_shift_en VGND VGND VPWR VPWR sky130_fd_sc_hd__diode_2
XFILLER_0_78_436 VGND VGND VPWR VPWR sky130_fd_sc_hd__fill_2
XFILLER_0_64_85 VPWR VGND VPWR VGND sky130_ef_sc_hd__decap_12
Xwire67 _3194_ VGND VGND VPWR VPWR net67 sky130_fd_sc_hd__buf_2
XFILLER_0_93_406 VGND VGND VPWR VPWR sky130_fd_sc_hd__fill_2
XFILLER_0_80_40 VGND VGND VPWR VPWR sky130_fd_sc_hd__fill_2
XANTENNA__4761__S _1796_ VGND VGND VPWR VPWR sky130_fd_sc_hd__diode_2
X_6705_ _3330_ VGND VGND VPWR VPWR _0618_ sky130_fd_sc_hd__clkbuf_1
X_4966_ _1960_ _1961_ VGND VGND VPWR VPWR _1962_ sky130_fd_sc_hd__or2_2
X_4897_ _1900_ _1901_ VGND VGND VPWR VPWR _1902_ sky130_fd_sc_hd__or2_1
X_3917_ _1091_ _1094_ _1099_ VGND VGND VPWR VPWR _1100_ sky130_fd_sc_hd__o21ai_1
XFILLER_0_73_196 VGND VGND VPWR VPWR sky130_fd_sc_hd__fill_2
X_6636_ net823 _0833_ _0836_ _3287_ VGND VGND VPWR VPWR _0592_ sky130_fd_sc_hd__a22o_1
XFILLER_0_34_528 VGND VGND VPWR VPWR sky130_fd_sc_hd__decap_4
X_3848_ _1036_ VGND VGND VPWR VPWR _1037_ sky130_fd_sc_hd__inv_2
X_3779_ u_pe_array.g_pe_row\[2\].g_pe_col\[2\].u_pe.w_buffer\[1\] net80 _0828_ VGND
+ VGND VPWR VPWR _0985_ sky130_fd_sc_hd__mux2_1
X_6567_ net352 _1818_ _3239_ VGND VGND VPWR VPWR _3251_ sky130_fd_sc_hd__mux2_1
XFILLER_0_14_230 VGND VGND VPWR VPWR sky130_fd_sc_hd__fill_2
X_5518_ _2258_ _2434_ _2435_ _2071_ net546 VGND VGND VPWR VPWR _0326_ sky130_fd_sc_hd__a32o_1
X_6498_ net496 _1806_ _3208_ VGND VGND VPWR VPWR _3214_ sky130_fd_sc_hd__mux2_1
XFILLER_0_100_633 VGND VGND VPWR VPWR sky130_fd_sc_hd__decap_8
XANTENNA__5496__B1 _2071_ VGND VGND VPWR VPWR sky130_fd_sc_hd__diode_2
X_5449_ _2371_ _2372_ VGND VGND VPWR VPWR _2373_ sky130_fd_sc_hd__and2b_1
XANTENNA__4299__A1 _1273_ VGND VGND VPWR VPWR sky130_fd_sc_hd__diode_2
X_7119_ clknet_leaf_36_clk net144 net76 VGND VGND VPWR VPWR u_pe_array.g_pe_row\[2\].g_pe_col\[0\].u_pe.move_reg\[11\]
+ sky130_fd_sc_hd__dfrtp_1
XFILLER_0_69_425 VGND VGND VPWR VPWR sky130_fd_sc_hd__fill_2
XTAP_1112 VGND VPWR sky130_fd_sc_hd__tapvpwrvgnd_1
XTAP_1123 VGND VPWR sky130_fd_sc_hd__tapvpwrvgnd_1
XTAP_1101 VGND VPWR sky130_fd_sc_hd__tapvpwrvgnd_1
XANTENNA__6212__A2 _0867_ VGND VGND VPWR VPWR sky130_fd_sc_hd__diode_2
XTAP_1156 VGND VPWR sky130_fd_sc_hd__tapvpwrvgnd_1
XTAP_1145 VGND VPWR sky130_fd_sc_hd__tapvpwrvgnd_1
XTAP_1134 VGND VPWR sky130_fd_sc_hd__tapvpwrvgnd_1
XTAP_1189 VGND VPWR sky130_fd_sc_hd__tapvpwrvgnd_1
XTAP_1178 VGND VPWR sky130_fd_sc_hd__tapvpwrvgnd_1
XTAP_1167 VGND VPWR sky130_fd_sc_hd__tapvpwrvgnd_1
XANTENNA__7426__RESET_B net816 VGND VGND VPWR VPWR sky130_fd_sc_hd__diode_2
XANTENNA__6171__B _2873_ VGND VGND VPWR VPWR sky130_fd_sc_hd__diode_2
XFILLER_0_64_141 VGND VGND VPWR VPWR sky130_fd_sc_hd__decap_4
XFILLER_0_18_580 VGND VGND VPWR VPWR sky130_fd_sc_hd__fill_2
XFILLER_0_37_377 VGND VGND VPWR VPWR sky130_fd_sc_hd__fill_1
XFILLER_0_107_265 VPWR VGND VPWR VGND sky130_ef_sc_hd__decap_12
XFILLER_0_40_509 VGND VGND VPWR VPWR sky130_fd_sc_hd__fill_2
XFILLER_0_100_27 VGND VGND VPWR VPWR sky130_fd_sc_hd__fill_1
XFILLER_0_33_561 VGND VGND VPWR VPWR sky130_fd_sc_hd__decap_6
XFILLER_0_110_419 VGND VGND VPWR VPWR sky130_fd_sc_hd__fill_1
XFILLER_0_0_617 VGND VGND VPWR VPWR sky130_fd_sc_hd__fill_2
XTAP_907 VGND VPWR sky130_fd_sc_hd__tapvpwrvgnd_1
XTAP_929 VGND VPWR sky130_fd_sc_hd__tapvpwrvgnd_1
XTAP_918 VGND VPWR sky130_fd_sc_hd__tapvpwrvgnd_1
XFILLER_0_109_25 VPWR VGND VPWR VGND sky130_ef_sc_hd__decap_12
XFILLER_0_18_45 VGND VGND VPWR VPWR sky130_fd_sc_hd__decap_3
XFILLER_0_18_89 VGND VGND VPWR VPWR sky130_fd_sc_hd__decap_4
XFILLER_0_34_55 VGND VGND VPWR VPWR sky130_fd_sc_hd__fill_1
XFILLER_0_87_277 VGND VGND VPWR VPWR sky130_fd_sc_hd__decap_3
X_4820_ net629 _0833_ VGND VGND VPWR VPWR _1837_ sky130_fd_sc_hd__and2_1
XANTENNA__7167__RESET_B net817 VGND VGND VPWR VPWR sky130_fd_sc_hd__diode_2
XFILLER_0_56_642 VGND VGND VPWR VPWR sky130_fd_sc_hd__fill_2
X_4751_ u_pe_array.u_fifo2.count\[1\] u_pe_array.u_fifo2.count\[2\] u_pe_array.u_fifo2.count\[0\]
+ u_pe_array.u_fifo2.count\[3\] VGND VGND VPWR VPWR _1790_ sky130_fd_sc_hd__or4bb_1
XFILLER_0_50_21 VGND VGND VPWR VPWR sky130_fd_sc_hd__decap_3
X_4682_ u_pe_array.g_pe_row\[2\].g_pe_col\[1\].u_pe.act_val\[5\] VGND VGND VPWR VPWR
+ _1728_ sky130_fd_sc_hd__inv_2
XFILLER_0_50_54 VGND VGND VPWR VPWR sky130_fd_sc_hd__fill_2
X_3702_ u_pe_array.g_pe_row\[3\].g_pe_col\[3\].u_pe.act_val\[5\] u_pe_array.g_pe_row\[3\].g_pe_col\[3\].u_pe.w_reg\[0\]
+ VGND VGND VPWR VPWR _0917_ sky130_fd_sc_hd__nand2_1
X_7470_ clknet_leaf_0_clk _0519_ VGND VGND VPWR VPWR u_pe_array.u_fifo2.buffer\[2\]\[9\]
+ sky130_fd_sc_hd__dfxtp_1
X_3633_ _0729_ VGND VGND VPWR VPWR _0855_ sky130_fd_sc_hd__clkbuf_16
X_6421_ net281 _1810_ _3166_ VGND VGND VPWR VPWR _3174_ sky130_fd_sc_hd__mux2_1
XFILLER_0_3_422 VGND VGND VPWR VPWR sky130_fd_sc_hd__fill_2
XANTENNA__3725__B1 _0867_ VGND VGND VPWR VPWR sky130_fd_sc_hd__diode_2
XFILLER_0_24_561 VGND VGND VPWR VPWR sky130_fd_sc_hd__fill_2
XFILLER_0_113_279 VGND VGND VPWR VPWR sky130_fd_sc_hd__fill_1
X_6352_ _1787_ _1137_ net61 VGND VGND VPWR VPWR _3128_ sky130_fd_sc_hd__a21o_2
XANTENNA__5190__A2 _2144_ VGND VGND VPWR VPWR sky130_fd_sc_hd__diode_2
X_3564_ _0723_ u_fsm.next_state\[1\] _0807_ VGND VGND VPWR VPWR _0808_ sky130_fd_sc_hd__a21oi_1
XFILLER_0_11_222 VGND VGND VPWR VPWR sky130_fd_sc_hd__fill_2
X_6283_ _3071_ _3072_ VGND VGND VPWR VPWR _3073_ sky130_fd_sc_hd__nand2_1
X_5303_ net635 _1714_ _2247_ _2248_ VGND VGND VPWR VPWR _0298_ sky130_fd_sc_hd__a22o_1
X_3495_ u_pe_array.g_pe_row\[1\].g_pe_col\[0\].u_pe.act_val\[0\] u_pe_array.g_pe_row\[1\].g_pe_col\[0\].u_pe.psum_out\[0\]
+ _0756_ VGND VGND VPWR VPWR _0757_ sky130_fd_sc_hd__mux2_1
XANTENNA__3489__C1 _0728_ VGND VGND VPWR VPWR sky130_fd_sc_hd__diode_2
X_5234_ _2182_ _2184_ VGND VGND VPWR VPWR _2186_ sky130_fd_sc_hd__nand2_1
XFILLER_0_11_288 VGND VGND VPWR VPWR sky130_fd_sc_hd__decap_3
X_5165_ u_pe_array.g_pe_row\[1\].g_pe_col\[3\].u_pe.psum_out\[12\] _2127_ VGND VGND
+ VPWR VPWR _2136_ sky130_fd_sc_hd__xor2_1
X_4116_ u_pe_array.g_pe_row\[3\].g_pe_col\[3\].u_pe.psum_out\[4\] u_pe_array.g_pe_row\[3\].g_pe_col\[3\].u_pe.act_val\[4\]
+ _0769_ VGND VGND VPWR VPWR _1261_ sky130_fd_sc_hd__mux2_1
X_5096_ u_pe_array.g_pe_row\[1\].g_pe_col\[3\].u_pe.psum_out\[5\] _2073_ VGND VGND
+ VPWR VPWR _2074_ sky130_fd_sc_hd__xnor2_1
X_4047_ _1188_ _1190_ _1204_ VGND VGND VPWR VPWR _1205_ sky130_fd_sc_hd__o21ai_2
XFILLER_0_39_609 VGND VGND VPWR VPWR sky130_fd_sc_hd__fill_2
XPHY_206 VGND VGND VPWR VPWR sky130_fd_sc_hd__decap_3
XPHY_228 VGND VGND VPWR VPWR sky130_fd_sc_hd__decap_3
XPHY_217 VGND VGND VPWR VPWR sky130_fd_sc_hd__decap_3
XFILLER_0_93_225 VGND VGND VPWR VPWR sky130_fd_sc_hd__fill_2
X_5998_ u_pe_array.g_pe_row\[0\].g_pe_col\[2\].u_pe.psum_out\[8\] u_pe_array.g_pe_row\[0\].g_pe_col\[2\].u_pe.psum_out\[9\]
+ _2743_ VGND VGND VPWR VPWR _2832_ sky130_fd_sc_hd__and3_1
XFILLER_0_47_631 VGND VGND VPWR VPWR sky130_fd_sc_hd__fill_2
XFILLER_0_19_322 VGND VGND VPWR VPWR sky130_fd_sc_hd__fill_2
XFILLER_0_19_333 VGND VGND VPWR VPWR sky130_fd_sc_hd__decap_3
X_4949_ u_pe_array.g_pe_row\[2\].g_pe_col\[0\].u_pe.psum_out\[11\] _1948_ _1939_ VGND
+ VGND VPWR VPWR _1949_ sky130_fd_sc_hd__mux2_1
XFILLER_0_46_141 VGND VGND VPWR VPWR sky130_fd_sc_hd__fill_1
XFILLER_0_61_111 VGND VGND VPWR VPWR sky130_fd_sc_hd__fill_1
X_6619_ net310 _1814_ _3269_ VGND VGND VPWR VPWR _3279_ sky130_fd_sc_hd__mux2_1
XFILLER_0_104_246 VGND VGND VPWR VPWR sky130_fd_sc_hd__decap_4
XFILLER_0_104_235 VGND VGND VPWR VPWR sky130_fd_sc_hd__fill_2
X_7599_ clknet_leaf_25_clk _0648_ VGND VGND VPWR VPWR u_pe_array.u_fifo1.buffer\[2\]\[9\]
+ sky130_fd_sc_hd__dfxtp_1
XFILLER_0_15_550 VGND VGND VPWR VPWR sky130_fd_sc_hd__fill_1
XANTENNA__6130__A1 _2740_ VGND VGND VPWR VPWR sky130_fd_sc_hd__diode_2
XANTENNA__4444__B2 _1399_ VGND VGND VPWR VPWR sky130_fd_sc_hd__diode_2
XFILLER_0_97_575 VGND VGND VPWR VPWR sky130_fd_sc_hd__decap_8
XANTENNA__3827__B_N _1009_ VGND VGND VPWR VPWR sky130_fd_sc_hd__diode_2
XANTENNA__7260__RESET_B net812 VGND VGND VPWR VPWR sky130_fd_sc_hd__diode_2
XFILLER_0_84_247 VGND VGND VPWR VPWR sky130_fd_sc_hd__fill_2
XANTENNA__4747__A2 _1714_ VGND VGND VPWR VPWR sky130_fd_sc_hd__diode_2
XANTENNA__3955__A0 net18 VGND VGND VPWR VPWR sky130_fd_sc_hd__diode_2
XFILLER_0_65_472 VGND VGND VPWR VPWR sky130_fd_sc_hd__decap_3
XFILLER_0_53_612 VGND VGND VPWR VPWR sky130_fd_sc_hd__fill_2
XFILLER_0_37_163 VGND VGND VPWR VPWR sky130_fd_sc_hd__fill_2
XFILLER_0_111_15 VPWR VGND VPWR VGND sky130_ef_sc_hd__decap_12
XFILLER_0_37_196 VGND VGND VPWR VPWR sky130_fd_sc_hd__decap_8
XFILLER_0_80_475 VGND VGND VPWR VPWR sky130_fd_sc_hd__fill_1
XFILLER_0_20_46 VGND VGND VPWR VPWR sky130_fd_sc_hd__fill_2
XFILLER_0_20_68 VGND VGND VPWR VPWR sky130_fd_sc_hd__fill_2
XFILLER_0_20_79 VGND VGND VPWR VPWR sky130_fd_sc_hd__fill_2
XFILLER_0_21_531 VGND VGND VPWR VPWR sky130_fd_sc_hd__fill_2
XFILLER_0_33_391 VGND VGND VPWR VPWR sky130_fd_sc_hd__fill_1
XFILLER_0_110_249 VGND VGND VPWR VPWR sky130_fd_sc_hd__decap_3
XFILLER_0_21_586 VGND VGND VPWR VPWR sky130_fd_sc_hd__fill_2
XTAP_704 VGND VPWR sky130_fd_sc_hd__tapvpwrvgnd_1
XTAP_715 VGND VPWR sky130_fd_sc_hd__tapvpwrvgnd_1
XTAP_759 VGND VPWR sky130_fd_sc_hd__tapvpwrvgnd_1
XFILLER_0_29_55 VGND VGND VPWR VPWR sky130_fd_sc_hd__fill_1
XTAP_726 VGND VPWR sky130_fd_sc_hd__tapvpwrvgnd_1
XTAP_737 VGND VPWR sky130_fd_sc_hd__tapvpwrvgnd_1
XTAP_748 VGND VPWR sky130_fd_sc_hd__tapvpwrvgnd_1
XANTENNA__6791__S _3366_ VGND VGND VPWR VPWR sky130_fd_sc_hd__diode_2
X_6970_ clknet_leaf_82_clk _0051_ net818 VGND VGND VPWR VPWR u_pe_array.g_pe_row\[3\].g_pe_col\[1\].u_pe.move_reg\[12\]
+ sky130_fd_sc_hd__dfrtp_1
XFILLER_0_88_531 VGND VGND VPWR VPWR sky130_fd_sc_hd__fill_1
XANTENNA__7348__RESET_B net818 VGND VGND VPWR VPWR sky130_fd_sc_hd__diode_2
X_5921_ u_pe_array.g_pe_row\[0\].g_pe_col\[2\].u_pe.act_val\[1\] u_pe_array.g_pe_row\[0\].g_pe_col\[2\].u_pe.psum_out\[2\]
+ _2743_ VGND VGND VPWR VPWR _2761_ sky130_fd_sc_hd__and3b_1
XFILLER_0_0_34 VGND VGND VPWR VPWR sky130_fd_sc_hd__fill_2
XFILLER_0_0_23 VGND VGND VPWR VPWR sky130_fd_sc_hd__decap_4
XFILLER_0_88_597 VGND VGND VPWR VPWR sky130_fd_sc_hd__fill_2
XFILLER_0_75_225 VGND VGND VPWR VPWR sky130_fd_sc_hd__fill_2
XANTENNA__4605__A _0729_ VGND VGND VPWR VPWR sky130_fd_sc_hd__diode_2
X_5852_ _0914_ _2711_ _2712_ _0861_ _2708_ VGND VGND VPWR VPWR _0383_ sky130_fd_sc_hd__o32ai_1
X_4803_ u_pe_array.g_pe_row\[1\].g_pe_col\[2\].u_pe.act_val\[1\] u_pe_array.g_pe_row\[1\].g_pe_col\[2\].u_pe.psum_out\[1\]
+ _0756_ VGND VGND VPWR VPWR _1826_ sky130_fd_sc_hd__mux2_1
XFILLER_0_8_525 VGND VGND VPWR VPWR sky130_fd_sc_hd__decap_6
X_5783_ _2648_ _2649_ VGND VGND VPWR VPWR _2650_ sky130_fd_sc_hd__or2_1
XANTENNA__3946__A0 net15 VGND VGND VPWR VPWR sky130_fd_sc_hd__diode_2
X_4734_ _0914_ _1774_ _1775_ _0861_ _1771_ VGND VGND VPWR VPWR _0202_ sky130_fd_sc_hd__o32ai_1
XFILLER_0_56_483 VGND VGND VPWR VPWR sky130_fd_sc_hd__decap_4
XFILLER_0_8_569 VPWR VGND VPWR VGND sky130_ef_sc_hd__decap_12
X_7522_ clknet_leaf_93_clk _0571_ VGND VGND VPWR VPWR u_pe_array.u_fifo2.buffer\[6\]\[9\]
+ sky130_fd_sc_hd__dfxtp_1
XFILLER_0_114_511 VGND VGND VPWR VPWR sky130_fd_sc_hd__fill_1
XFILLER_0_44_645 VGND VGND VPWR VPWR sky130_fd_sc_hd__fill_1
XANTENNA__6983__RESET_B net74 VGND VGND VPWR VPWR sky130_fd_sc_hd__diode_2
XFILLER_0_114_533 VPWR VGND VPWR VGND sky130_ef_sc_hd__decap_12
XANTENNA__5699__B1 _2478_ VGND VGND VPWR VPWR sky130_fd_sc_hd__diode_2
X_4665_ _1702_ _1711_ _0914_ VGND VGND VPWR VPWR _1713_ sky130_fd_sc_hd__a21o_1
XFILLER_0_43_177 VGND VGND VPWR VPWR sky130_fd_sc_hd__fill_2
X_7453_ clknet_leaf_4_clk _0502_ VGND VGND VPWR VPWR u_pe_array.u_fifo2.buffer\[1\]\[5\]
+ sky130_fd_sc_hd__dfxtp_1
X_7384_ clknet_leaf_47_clk _0437_ net13 VGND VGND VPWR VPWR u_pe_array.g_pe_row\[0\].g_pe_col\[1\].u_pe.psum_out\[8\]
+ sky130_fd_sc_hd__dfrtp_2
X_4596_ net789 _1524_ _1655_ _1656_ VGND VGND VPWR VPWR _0183_ sky130_fd_sc_hd__a22o_1
X_6404_ u_pe_array.u_fifo2.wr_ptr\[2\] u_pe_array.u_fifo2.wr_ptr\[3\] _1789_ _1791_
+ VGND VGND VPWR VPWR _3164_ sky130_fd_sc_hd__or4_1
X_3616_ net820 _0834_ _0837_ _0845_ VGND VGND VPWR VPWR _0014_ sky130_fd_sc_hd__a22o_1
X_6335_ _3116_ net495 _3110_ VGND VGND VPWR VPWR _3117_ sky130_fd_sc_hd__mux2_1
X_3547_ _0725_ _0780_ _0792_ _0724_ VGND VGND VPWR VPWR _0793_ sky130_fd_sc_hd__a2bb2o_1
XANTENNA__5155__B _2029_ VGND VGND VPWR VPWR sky130_fd_sc_hd__diode_2
XANTENNA__5870__S _0770_ VGND VGND VPWR VPWR sky130_fd_sc_hd__diode_2
X_6266_ _3056_ _3054_ _3051_ VGND VGND VPWR VPWR _3057_ sky130_fd_sc_hd__a21oi_1
X_3478_ _0728_ VGND VGND VPWR VPWR _0747_ sky130_fd_sc_hd__buf_12
X_6197_ u_pe_array.g_pe_row\[0\].g_pe_col\[0\].u_pe.act_val\[0\] u_pe_array.g_pe_row\[0\].g_pe_col\[0\].u_pe.psum_out\[1\]
+ _2992_ VGND VGND VPWR VPWR _2994_ sky130_fd_sc_hd__and3_1
X_5217_ u_pe_array.g_pe_row\[1\].g_pe_col\[2\].u_pe.psum_out\[2\] _2169_ VGND VGND
+ VPWR VPWR _2170_ sky130_fd_sc_hd__xnor2_1
XANTENNA__5871__B1 _2592_ VGND VGND VPWR VPWR sky130_fd_sc_hd__diode_2
X_5148_ _2029_ u_pe_array.g_pe_row\[1\].g_pe_col\[3\].u_pe.psum_out\[10\] VGND VGND
+ VPWR VPWR _2121_ sky130_fd_sc_hd__or2_1
XFILLER_0_98_339 VPWR VGND VPWR VGND sky130_ef_sc_hd__decap_12
X_5079_ u_pe_array.g_pe_row\[1\].g_pe_col\[3\].u_pe.act_val\[3\] VGND VGND VPWR VPWR
+ _2058_ sky130_fd_sc_hd__inv_2
XFILLER_0_79_553 VGND VGND VPWR VPWR sky130_fd_sc_hd__fill_2
XANTENNA__7089__RESET_B net818 VGND VGND VPWR VPWR sky130_fd_sc_hd__diode_2
XFILLER_0_94_501 VGND VGND VPWR VPWR sky130_fd_sc_hd__fill_2
XANTENNA__7018__RESET_B net819 VGND VGND VPWR VPWR sky130_fd_sc_hd__diode_2
XFILLER_0_109_305 VPWR VGND VPWR VGND sky130_ef_sc_hd__decap_12
XFILLER_0_109_349 VGND VGND VPWR VPWR sky130_fd_sc_hd__fill_2
XANTENNA__5346__A _2273_ VGND VGND VPWR VPWR sky130_fd_sc_hd__diode_2
XFILLER_0_22_317 VGND VGND VPWR VPWR sky130_fd_sc_hd__fill_2
XFILLER_0_34_166 VGND VGND VPWR VPWR sky130_fd_sc_hd__fill_1
XANTENNA__6876__S _3412_ VGND VGND VPWR VPWR sky130_fd_sc_hd__diode_2
XANTENNA__5081__A _2029_ VGND VGND VPWR VPWR sky130_fd_sc_hd__diode_2
XFILLER_0_106_15 VPWR VGND VPWR VGND sky130_ef_sc_hd__decap_12
XFILLER_0_97_350 VGND VGND VPWR VPWR sky130_fd_sc_hd__decap_3
XFILLER_0_85_501 VGND VGND VPWR VPWR sky130_fd_sc_hd__decap_3
XFILLER_0_85_534 VGND VGND VPWR VPWR sky130_fd_sc_hd__fill_1
XFILLER_0_57_214 VGND VGND VPWR VPWR sky130_fd_sc_hd__fill_2
XANTENNA__5213__B1_N _2158_ VGND VGND VPWR VPWR sky130_fd_sc_hd__diode_2
XFILLER_0_57_269 VGND VGND VPWR VPWR sky130_fd_sc_hd__fill_2
XANTENNA__3928__B1 _0867_ VGND VGND VPWR VPWR sky130_fd_sc_hd__diode_2
XFILLER_0_53_442 VGND VGND VPWR VPWR sky130_fd_sc_hd__fill_1
XFILLER_0_5_517 VPWR VGND VPWR VGND sky130_ef_sc_hd__decap_12
XFILLER_0_111_503 VGND VGND VPWR VPWR sky130_fd_sc_hd__fill_1
Xhold207 u_pe_array.u_fifo1.buffer\[3\]\[6\] VGND VGND VPWR VPWR net283 sky130_fd_sc_hd__dlygate4sd3_1
X_4450_ net387 _1524_ _1530_ _1399_ VGND VGND VPWR VPWR _0163_ sky130_fd_sc_hd__a22o_1
X_4381_ _1454_ _1478_ _1479_ _1480_ VGND VGND VPWR VPWR _1481_ sky130_fd_sc_hd__o31a_1
Xhold229 u_pe_array.u_fifo2.buffer\[1\]\[6\] VGND VGND VPWR VPWR net305 sky130_fd_sc_hd__dlygate4sd3_1
Xhold218 _0343_ VGND VGND VPWR VPWR net294 sky130_fd_sc_hd__dlygate4sd3_1
X_6120_ _2873_ _2927_ u_pe_array.g_pe_row\[0\].g_pe_col\[1\].u_pe.psum_out\[6\] VGND
+ VGND VPWR VPWR _2929_ sky130_fd_sc_hd__a21oi_1
XTAP_501 VGND VPWR sky130_fd_sc_hd__tapvpwrvgnd_1
XTAP_512 VGND VPWR sky130_fd_sc_hd__tapvpwrvgnd_1
XTAP_523 VGND VPWR sky130_fd_sc_hd__tapvpwrvgnd_1
XTAP_534 VGND VPWR sky130_fd_sc_hd__tapvpwrvgnd_1
X_6051_ net236 _2738_ _2867_ _0722_ VGND VGND VPWR VPWR _0427_ sky130_fd_sc_hd__a22o_1
XANTENNA__4656__A1 _1672_ VGND VGND VPWR VPWR sky130_fd_sc_hd__diode_2
XTAP_545 VGND VPWR sky130_fd_sc_hd__tapvpwrvgnd_1
XTAP_567 VGND VPWR sky130_fd_sc_hd__tapvpwrvgnd_1
XTAP_556 VGND VPWR sky130_fd_sc_hd__tapvpwrvgnd_1
XFILLER_0_56_53 VPWR VGND VPWR VGND sky130_ef_sc_hd__decap_12
X_5002_ _0836_ _1993_ _1995_ _0833_ net554 VGND VGND VPWR VPWR _0250_ sky130_fd_sc_hd__a32o_1
XTAP_578 VGND VPWR sky130_fd_sc_hd__tapvpwrvgnd_1
XTAP_589 VGND VPWR sky130_fd_sc_hd__tapvpwrvgnd_1
XANTENNA__7182__RESET_B net73 VGND VGND VPWR VPWR sky130_fd_sc_hd__diode_2
XANTENNA__7111__RESET_B net76 VGND VGND VPWR VPWR sky130_fd_sc_hd__diode_2
XFILLER_0_72_41 VGND VGND VPWR VPWR sky130_fd_sc_hd__fill_1
X_6953_ clknet_leaf_79_clk _0034_ net815 VGND VGND VPWR VPWR u_pe_array.g_pe_row\[3\].g_pe_col\[3\].u_pe.psum_out\[10\]
+ sky130_fd_sc_hd__dfrtp_1
XANTENNA__6026__S _0827_ VGND VGND VPWR VPWR sky130_fd_sc_hd__diode_2
X_6884_ net270 _3134_ _3412_ VGND VGND VPWR VPWR _3425_ sky130_fd_sc_hd__mux2_1
Xclkbuf_3_5__f_clk clknet_0_clk VGND VGND VPWR VPWR clknet_3_5__leaf_clk sky130_fd_sc_hd__clkbuf_16
X_5904_ _2742_ _2744_ _2745_ VGND VGND VPWR VPWR _2746_ sky130_fd_sc_hd__or3_1
X_5835_ _2695_ _2696_ VGND VGND VPWR VPWR _2697_ sky130_fd_sc_hd__nor2_1
XANTENNA__5908__A1 _2740_ VGND VGND VPWR VPWR sky130_fd_sc_hd__diode_2
XFILLER_0_76_589 VGND VGND VPWR VPWR sky130_fd_sc_hd__fill_2
XFILLER_0_17_612 VGND VGND VPWR VPWR sky130_fd_sc_hd__fill_2
XFILLER_0_17_623 VGND VGND VPWR VPWR sky130_fd_sc_hd__fill_2
XFILLER_0_29_472 VGND VGND VPWR VPWR sky130_fd_sc_hd__fill_2
XANTENNA__3919__B1 _0867_ VGND VGND VPWR VPWR sky130_fd_sc_hd__diode_2
XFILLER_0_91_559 VGND VGND VPWR VPWR sky130_fd_sc_hd__fill_1
XFILLER_0_29_494 VGND VGND VPWR VPWR sky130_fd_sc_hd__fill_2
X_5766_ u_pe_array.g_pe_row\[0\].g_pe_col\[3\].u_pe.psum_out\[3\] _2633_ VGND VGND
+ VPWR VPWR _2634_ sky130_fd_sc_hd__xor2_1
X_5697_ _2580_ _2584_ VGND VGND VPWR VPWR _2585_ sky130_fd_sc_hd__xor2_1
X_4717_ _1758_ _1759_ VGND VGND VPWR VPWR _1760_ sky130_fd_sc_hd__nor2_1
XFILLER_0_16_144 VGND VGND VPWR VPWR sky130_fd_sc_hd__decap_4
X_7505_ clknet_leaf_4_clk _0554_ VGND VGND VPWR VPWR u_pe_array.u_fifo2.buffer\[5\]\[5\]
+ sky130_fd_sc_hd__dfxtp_1
XFILLER_0_114_341 VPWR VGND VPWR VGND sky130_ef_sc_hd__decap_12
X_4648_ u_pe_array.g_pe_row\[2\].g_pe_col\[1\].u_pe.psum_out\[2\] _1683_ _1696_ VGND
+ VGND VPWR VPWR _1697_ sky130_fd_sc_hd__a21oi_1
XFILLER_0_44_497 VGND VGND VPWR VPWR sky130_fd_sc_hd__fill_2
X_7436_ clknet_leaf_2_clk _0485_ VGND VGND VPWR VPWR u_pe_array.u_fifo2.buffer\[0\]\[1\]
+ sky130_fd_sc_hd__dfxtp_1
XFILLER_0_32_648 VGND VGND VPWR VPWR sky130_fd_sc_hd__fill_2
Xhold730 u_pe_array.g_pe_row\[2\].g_pe_col\[1\].u_pe.w_buffer\[0\] VGND VGND VPWR
+ VPWR net806 sky130_fd_sc_hd__dlygate4sd3_1
XFILLER_0_31_147 VGND VGND VPWR VPWR sky130_fd_sc_hd__fill_2
XFILLER_0_31_158 VGND VGND VPWR VPWR sky130_fd_sc_hd__decap_4
X_7367_ clknet_leaf_48_clk _0422_ net812 VGND VGND VPWR VPWR u_pe_array.g_pe_row\[0\].g_pe_col\[0\].u_pe.move_reg\[6\]
+ sky130_fd_sc_hd__dfrtp_1
Xhold741 u_pe_array.g_pe_row\[3\].g_pe_col\[1\].u_pe.act_val\[2\] VGND VGND VPWR VPWR
+ net825 sky130_fd_sc_hd__dlygate4sd3_1
XFILLER_0_12_361 VGND VGND VPWR VPWR sky130_fd_sc_hd__decap_3
X_4579_ u_pe_array.g_pe_row\[2\].g_pe_col\[2\].u_pe.psum_out\[12\] _1638_ VGND VGND
+ VPWR VPWR _1647_ sky130_fd_sc_hd__xor2_1
X_7298_ clknet_leaf_40_clk _0357_ net813 VGND VGND VPWR VPWR u_pe_array.g_pe_row\[1\].g_pe_col\[0\].u_pe.psum_out\[12\]
+ sky130_fd_sc_hd__dfrtp_1
X_6318_ _1787_ _1122_ net49 VGND VGND VPWR VPWR _3103_ sky130_fd_sc_hd__a21o_2
X_6249_ _3040_ _3041_ VGND VGND VPWR VPWR _3042_ sky130_fd_sc_hd__nor2_1
XANTENNA__6636__A2 _0833_ VGND VGND VPWR VPWR sky130_fd_sc_hd__diode_2
XFILLER_0_99_637 VPWR VGND VPWR VGND sky130_ef_sc_hd__decap_12
XFILLER_0_67_501 VGND VGND VPWR VPWR sky130_fd_sc_hd__decap_3
XFILLER_0_79_383 VGND VGND VPWR VPWR sky130_fd_sc_hd__fill_1
XFILLER_0_94_353 VGND VGND VPWR VPWR sky130_fd_sc_hd__decap_8
XANTENNA__3622__A2 _0834_ VGND VGND VPWR VPWR sky130_fd_sc_hd__diode_2
XFILLER_0_39_247 VGND VGND VPWR VPWR sky130_fd_sc_hd__fill_2
XFILLER_0_39_258 VGND VGND VPWR VPWR sky130_fd_sc_hd__fill_2
XFILLER_0_39_269 VGND VGND VPWR VPWR sky130_fd_sc_hd__fill_1
XFILLER_0_23_615 VGND VGND VPWR VPWR sky130_fd_sc_hd__fill_1
XFILLER_0_35_453 VGND VGND VPWR VPWR sky130_fd_sc_hd__decap_6
XFILLER_0_105_330 VGND VGND VPWR VPWR sky130_fd_sc_hd__decap_4
XFILLER_0_90_581 VGND VGND VPWR VPWR sky130_fd_sc_hd__fill_2
XFILLER_0_62_283 VGND VGND VPWR VPWR sky130_fd_sc_hd__fill_2
XFILLER_0_22_125 VGND VGND VPWR VPWR sky130_fd_sc_hd__fill_2
XFILLER_0_77_19 VGND VGND VPWR VPWR sky130_fd_sc_hd__fill_1
XFILLER_0_10_309 VGND VGND VPWR VPWR sky130_fd_sc_hd__decap_8
XFILLER_0_89_136 VGND VGND VPWR VPWR sky130_fd_sc_hd__fill_1
Xhold90 u_pe_array.g_pe_row\[1\].g_pe_col\[2\].u_pe.move_reg\[11\] VGND VGND VPWR
+ VPWR net166 sky130_fd_sc_hd__dlygate4sd3_1
XFILLER_0_89_169 VGND VGND VPWR VPWR sky130_fd_sc_hd__decap_4
XFILLER_0_58_501 VGND VGND VPWR VPWR sky130_fd_sc_hd__fill_2
X_3950_ net626 _0996_ _0837_ _1125_ VGND VGND VPWR VPWR _0068_ sky130_fd_sc_hd__a22o_1
XANTENNA__3613__A2 _0834_ VGND VGND VPWR VPWR sky130_fd_sc_hd__diode_2
XFILLER_0_45_206 VGND VGND VPWR VPWR sky130_fd_sc_hd__fill_2
X_3881_ u_pe_array.g_pe_row\[3\].g_pe_col\[2\].u_pe.act_val\[4\] _1066_ _1055_ _1053_
+ VGND VGND VPWR VPWR _1067_ sky130_fd_sc_hd__o22ai_1
XFILLER_0_85_397 VGND VGND VPWR VPWR sky130_fd_sc_hd__fill_2
XFILLER_0_73_548 VGND VGND VPWR VPWR sky130_fd_sc_hd__decap_4
X_5620_ u_pe_array.g_pe_row\[1\].g_pe_col\[0\].u_pe.act_val\[3\] u_pe_array.g_pe_row\[1\].g_pe_col\[0\].u_pe.w_reg\[0\]
+ _2502_ _2501_ VGND VGND VPWR VPWR _2515_ sky130_fd_sc_hd__a31o_1
XANTENNA__6563__A1 _1814_ VGND VGND VPWR VPWR sky130_fd_sc_hd__diode_2
X_5551_ u_pe_array.g_pe_row\[1\].g_pe_col\[3\].u_pe.act_val\[1\] u_pe_array.g_pe_row\[1\].g_pe_col\[3\].u_pe.psum_out\[1\]
+ _0770_ VGND VGND VPWR VPWR _2462_ sky130_fd_sc_hd__mux2_1
XFILLER_0_26_442 VGND VGND VPWR VPWR sky130_fd_sc_hd__fill_2
XFILLER_0_53_294 VGND VGND VPWR VPWR sky130_fd_sc_hd__decap_3
XFILLER_0_13_125 VGND VGND VPWR VPWR sky130_fd_sc_hd__fill_2
X_4502_ _1576_ _1577_ net758 _0916_ VGND VGND VPWR VPWR _0168_ sky130_fd_sc_hd__a2bb2o_1
XFILLER_0_41_412 VGND VGND VPWR VPWR sky130_fd_sc_hd__fill_2
XFILLER_0_41_434 VGND VGND VPWR VPWR sky130_fd_sc_hd__decap_3
X_5482_ _2401_ _2402_ VGND VGND VPWR VPWR _2403_ sky130_fd_sc_hd__or2_1
X_7221_ clknet_leaf_52_clk net204 net812 VGND VGND VPWR VPWR u_pe_array.g_pe_row\[1\].g_pe_col\[1\].u_pe.move_reg\[10\]
+ sky130_fd_sc_hd__dfrtp_1
X_4433_ net609 _1392_ _1258_ _1521_ VGND VGND VPWR VPWR _0155_ sky130_fd_sc_hd__a22o_1
XFILLER_0_13_169 VGND VGND VPWR VPWR sky130_fd_sc_hd__decap_8
XFILLER_0_111_366 VGND VGND VPWR VPWR sky130_fd_sc_hd__decap_4
X_4364_ _1449_ _1451_ _1465_ VGND VGND VPWR VPWR _1466_ sky130_fd_sc_hd__o21ai_1
X_7152_ clknet_leaf_74_clk _0221_ net814 VGND VGND VPWR VPWR u_pe_array.g_pe_row\[1\].g_pe_col\[3\].u_pe.act_val\[1\]
+ sky130_fd_sc_hd__dfrtp_2
X_6103_ _2903_ _2912_ net71 VGND VGND VPWR VPWR _2914_ sky130_fd_sc_hd__a21o_1
X_7083_ clknet_leaf_11_clk _0156_ net818 VGND VGND VPWR VPWR u_pe_array.g_pe_row\[2\].g_pe_col\[1\].u_pe.act_val\[5\]
+ sky130_fd_sc_hd__dfrtp_2
XTAP_342 VGND VPWR sky130_fd_sc_hd__tapvpwrvgnd_1
XTAP_320 VGND VPWR sky130_fd_sc_hd__tapvpwrvgnd_1
XTAP_331 VGND VPWR sky130_fd_sc_hd__tapvpwrvgnd_1
XFILLER_0_6_77 VGND VGND VPWR VPWR sky130_fd_sc_hd__decap_6
X_4295_ net805 net142 _0855_ VGND VGND VPWR VPWR _1404_ sky130_fd_sc_hd__mux2_1
X_6034_ u_pe_array.g_pe_row\[0\].g_pe_col\[1\].u_pe.act_val\[3\] u_pe_array.g_pe_row\[0\].g_pe_col\[1\].u_pe.psum_out\[3\]
+ _0756_ VGND VGND VPWR VPWR _2859_ sky130_fd_sc_hd__mux2_1
XANTENNA__7363__RESET_B net75 VGND VGND VPWR VPWR sky130_fd_sc_hd__diode_2
XTAP_375 VGND VPWR sky130_fd_sc_hd__tapvpwrvgnd_1
XTAP_364 VGND VPWR sky130_fd_sc_hd__tapvpwrvgnd_1
XTAP_353 VGND VPWR sky130_fd_sc_hd__tapvpwrvgnd_1
XTAP_386 VGND VPWR sky130_fd_sc_hd__tapvpwrvgnd_1
XTAP_397 VGND VPWR sky130_fd_sc_hd__tapvpwrvgnd_1
XFILLER_0_20_3 VGND VGND VPWR VPWR sky130_fd_sc_hd__fill_1
XANTENNA__4764__S _1796_ VGND VGND VPWR VPWR sky130_fd_sc_hd__diode_2
XFILLER_0_83_95 VGND VGND VPWR VPWR sky130_fd_sc_hd__fill_2
XFILLER_0_107_91 VGND VGND VPWR VPWR sky130_fd_sc_hd__fill_1
XTAP_1508 VGND VPWR sky130_fd_sc_hd__tapvpwrvgnd_1
XTAP_1519 VGND VPWR sky130_fd_sc_hd__tapvpwrvgnd_1
XANTENNA__4065__A _1145_ VGND VGND VPWR VPWR sky130_fd_sc_hd__diode_2
XPHY_15 VGND VGND VPWR VPWR sky130_fd_sc_hd__decap_3
XPHY_26 VGND VGND VPWR VPWR sky130_fd_sc_hd__decap_3
XANTENNA__5054__A1 _1725_ VGND VGND VPWR VPWR sky130_fd_sc_hd__diode_2
XPHY_37 VGND VGND VPWR VPWR sky130_fd_sc_hd__decap_3
X_6936_ clknet_leaf_86_clk _0019_ net819 VGND VGND VPWR VPWR u_pe_array.g_pe_row\[3\].g_pe_col\[2\].u_pe.move_reg\[8\]
+ sky130_fd_sc_hd__dfrtp_1
XFILLER_0_76_353 VGND VGND VPWR VPWR sky130_fd_sc_hd__fill_2
XANTENNA__4801__A1 net1 VGND VGND VPWR VPWR sky130_fd_sc_hd__diode_2
XFILLER_0_49_567 VPWR VGND VPWR VGND sky130_ef_sc_hd__decap_12
XFILLER_0_49_545 VPWR VGND VPWR VGND sky130_ef_sc_hd__decap_12
XPHY_48 VGND VGND VPWR VPWR sky130_fd_sc_hd__decap_3
XPHY_59 VGND VGND VPWR VPWR sky130_fd_sc_hd__decap_3
X_6867_ _3416_ VGND VGND VPWR VPWR _0694_ sky130_fd_sc_hd__clkbuf_1
XANTENNA__6003__B1 _2743_ VGND VGND VPWR VPWR sky130_fd_sc_hd__diode_2
XFILLER_0_9_653 VPWR VGND VPWR VGND sky130_ef_sc_hd__decap_12
XFILLER_0_107_617 VPWR VGND VPWR VGND sky130_ef_sc_hd__decap_12
X_6798_ _3378_ VGND VGND VPWR VPWR _0663_ sky130_fd_sc_hd__clkbuf_1
XFILLER_0_8_141 VPWR VGND VPWR VGND sky130_ef_sc_hd__decap_12
XFILLER_0_17_431 VGND VGND VPWR VPWR sky130_fd_sc_hd__decap_8
X_5818_ _2660_ VGND VGND VPWR VPWR _2681_ sky130_fd_sc_hd__inv_2
XFILLER_0_44_250 VGND VGND VPWR VPWR sky130_fd_sc_hd__fill_2
XFILLER_0_17_442 VGND VGND VPWR VPWR sky130_fd_sc_hd__decap_3
X_5749_ u_pe_array.g_pe_row\[0\].g_pe_col\[3\].u_pe.psum_out\[1\] _2614_ _2617_ VGND
+ VGND VPWR VPWR _2618_ sky130_fd_sc_hd__a21o_1
XANTENNA__4317__B1 _0887_ VGND VGND VPWR VPWR sky130_fd_sc_hd__diode_2
X_7419_ clknet_leaf_30_clk _0468_ VGND VGND VPWR VPWR u_pe_array.u_fifo1.buffer\[8\]\[9\]
+ sky130_fd_sc_hd__dfxtp_1
XFILLER_0_32_489 VPWR VGND VPWR VGND sky130_ef_sc_hd__decap_12
XFILLER_0_102_377 VGND VGND VPWR VPWR sky130_fd_sc_hd__fill_2
XFILLER_0_102_355 VGND VGND VPWR VPWR sky130_fd_sc_hd__fill_2
Xhold571 u_pe_array.g_pe_row\[3\].g_pe_col\[1\].u_pe.act_val\[4\] VGND VGND VPWR VPWR
+ net647 sky130_fd_sc_hd__dlygate4sd3_1
Xhold560 u_pe_array.g_pe_row\[3\].g_pe_col\[3\].u_pe.move_reg\[11\] VGND VGND VPWR
+ VPWR net636 sky130_fd_sc_hd__dlygate4sd3_1
Xhold582 u_pe_array.g_pe_row\[0\].g_pe_col\[1\].u_pe.act_val\[3\] VGND VGND VPWR VPWR
+ net658 sky130_fd_sc_hd__dlygate4sd3_1
Xhold593 u_pe_array.u_fifo2.count\[2\] VGND VGND VPWR VPWR net669 sky130_fd_sc_hd__dlygate4sd3_1
XANTENNA__5817__B1 _2571_ VGND VGND VPWR VPWR sky130_fd_sc_hd__diode_2
XANTENNA__7033__RESET_B net816 VGND VGND VPWR VPWR sky130_fd_sc_hd__diode_2
XANTENNA__6242__B1 _0866_ VGND VGND VPWR VPWR sky130_fd_sc_hd__diode_2
XFILLER_0_86_139 VGND VGND VPWR VPWR sky130_fd_sc_hd__fill_1
XFILLER_0_86_128 VGND VGND VPWR VPWR sky130_fd_sc_hd__fill_2
XANTENNA__6793__A1 _3128_ VGND VGND VPWR VPWR sky130_fd_sc_hd__diode_2
XFILLER_0_95_673 VGND VGND VPWR VPWR sky130_fd_sc_hd__decap_4
XFILLER_0_103_27 VPWR VGND VPWR VGND sky130_ef_sc_hd__decap_12
XFILLER_0_113_609 VGND VGND VPWR VPWR sky130_fd_sc_hd__decap_6
XFILLER_0_50_231 VGND VGND VPWR VPWR sky130_fd_sc_hd__fill_2
XFILLER_0_50_275 VGND VGND VPWR VPWR sky130_fd_sc_hd__decap_3
XFILLER_0_11_629 VPWR VGND VPWR VGND sky130_ef_sc_hd__decap_12
XFILLER_0_50_297 VGND VGND VPWR VPWR sky130_fd_sc_hd__fill_2
X_4080_ u_pe_array.g_pe_row\[3\].g_pe_col\[1\].u_pe.psum_out\[7\] u_pe_array.g_pe_row\[3\].g_pe_col\[1\].u_pe.psum_out\[8\]
+ _1145_ VGND VGND VPWR VPWR _1234_ sky130_fd_sc_hd__o21a_1
XANTENNA__4584__S _0828_ VGND VGND VPWR VPWR sky130_fd_sc_hd__diode_2
XFILLER_0_78_629 VGND VGND VPWR VPWR sky130_fd_sc_hd__fill_2
X_4982_ u_pe_array.g_pe_row\[0\].g_pe_col\[2\].u_pe.act_val\[0\] u_pe_array.g_pe_row\[0\].g_pe_col\[2\].u_pe.psum_out\[0\]
+ _0756_ VGND VGND VPWR VPWR _1978_ sky130_fd_sc_hd__mux2_1
X_6721_ net483 _3103_ net65 VGND VGND VPWR VPWR _3339_ sky130_fd_sc_hd__mux2_1
XFILLER_0_46_526 VGND VGND VPWR VPWR sky130_fd_sc_hd__fill_2
XFILLER_0_46_504 VGND VGND VPWR VPWR sky130_fd_sc_hd__fill_2
X_3933_ u_pe_array.g_pe_row\[3\].g_pe_col\[2\].u_pe.psum_out\[11\] _1113_ _1104_ VGND
+ VGND VPWR VPWR _1114_ sky130_fd_sc_hd__mux2_1
XFILLER_0_58_397 VGND VGND VPWR VPWR sky130_fd_sc_hd__fill_2
XANTENNA__4613__A _0832_ VGND VGND VPWR VPWR sky130_fd_sc_hd__diode_2
XFILLER_0_46_559 VGND VGND VPWR VPWR sky130_fd_sc_hd__fill_2
XFILLER_0_46_548 VGND VGND VPWR VPWR sky130_fd_sc_hd__fill_2
XFILLER_0_46_537 VGND VGND VPWR VPWR sky130_fd_sc_hd__fill_2
X_3864_ _1049_ _1050_ VGND VGND VPWR VPWR _1052_ sky130_fd_sc_hd__or2_1
XFILLER_0_6_601 VPWR VGND VPWR VGND sky130_ef_sc_hd__decap_12
X_6652_ _3295_ VGND VGND VPWR VPWR _0600_ sky130_fd_sc_hd__clkbuf_1
X_5603_ u_pe_array.g_pe_row\[1\].g_pe_col\[0\].u_pe.act_val\[2\] VGND VGND VPWR VPWR
+ _2499_ sky130_fd_sc_hd__inv_2
XFILLER_0_6_645 VPWR VGND VPWR VGND sky130_ef_sc_hd__decap_12
XFILLER_0_5_111 VGND VGND VPWR VPWR sky130_fd_sc_hd__fill_1
X_3795_ net647 _0834_ _0837_ _0995_ VGND VGND VPWR VPWR _0043_ sky130_fd_sc_hd__a22o_1
XFILLER_0_26_272 VGND VGND VPWR VPWR sky130_fd_sc_hd__fill_2
X_6583_ net553 _1806_ _3254_ VGND VGND VPWR VPWR _3260_ sky130_fd_sc_hd__mux2_1
X_5534_ _2448_ _2449_ VGND VGND VPWR VPWR _2450_ sky130_fd_sc_hd__or2_1
XFILLER_0_41_231 VGND VGND VPWR VPWR sky130_fd_sc_hd__fill_2
X_5465_ _0866_ VGND VGND VPWR VPWR _2387_ sky130_fd_sc_hd__buf_8
XFILLER_0_41_253 VGND VGND VPWR VPWR sky130_fd_sc_hd__decap_4
XFILLER_0_41_264 VGND VGND VPWR VPWR sky130_fd_sc_hd__fill_2
XFILLER_0_111_163 VGND VGND VPWR VPWR sky130_fd_sc_hd__decap_3
XFILLER_0_68_3 VPWR VGND VPWR VGND sky130_ef_sc_hd__decap_12
XANTENNA__7544__RESET_B net818 VGND VGND VPWR VPWR sky130_fd_sc_hd__diode_2
XFILLER_0_1_361 VPWR VGND VPWR VGND sky130_ef_sc_hd__decap_12
X_7204_ clknet_leaf_72_clk _0269_ net815 VGND VGND VPWR VPWR u_pe_array.g_pe_row\[1\].g_pe_col\[3\].u_pe.psum_out\[8\]
+ sky130_fd_sc_hd__dfrtp_2
X_4416_ _1502_ _1508_ _1511_ _1506_ VGND VGND VPWR VPWR _1512_ sky130_fd_sc_hd__a22oi_2
X_5396_ u_pe_array.g_pe_row\[0\].g_pe_col\[0\].u_pe.act_val\[5\] u_pe_array.g_pe_row\[0\].g_pe_col\[0\].u_pe.psum_out\[5\]
+ _0755_ VGND VGND VPWR VPWR _2331_ sky130_fd_sc_hd__mux2_1
X_7135_ clknet_leaf_38_clk _0204_ net813 VGND VGND VPWR VPWR u_pe_array.g_pe_row\[2\].g_pe_col\[1\].u_pe.psum_out\[12\]
+ sky130_fd_sc_hd__dfrtp_1
X_4347_ u_pe_array.g_pe_row\[2\].g_pe_col\[3\].u_pe.act_val\[4\] _1407_ VGND VGND
+ VPWR VPWR _1450_ sky130_fd_sc_hd__and2b_1
X_4278_ u_pe_array.g_pe_row\[2\].g_pe_col\[3\].u_pe.psum_out\[4\] u_pe_array.g_pe_row\[2\].g_pe_col\[3\].u_pe.act_val\[4\]
+ _0769_ VGND VGND VPWR VPWR _1395_ sky130_fd_sc_hd__mux2_1
X_7066_ clknet_leaf_90_clk _0139_ net819 VGND VGND VPWR VPWR u_pe_array.g_pe_row\[2\].g_pe_col\[3\].u_pe.psum_out\[3\]
+ sky130_fd_sc_hd__dfrtp_1
X_6017_ _2844_ _2848_ VGND VGND VPWR VPWR _2849_ sky130_fd_sc_hd__xor2_1
XTAP_1305 VGND VPWR sky130_fd_sc_hd__tapvpwrvgnd_1
XANTENNA__4226__C _1275_ VGND VGND VPWR VPWR sky130_fd_sc_hd__diode_2
XTAP_1338 VGND VPWR sky130_fd_sc_hd__tapvpwrvgnd_1
XTAP_1327 VGND VPWR sky130_fd_sc_hd__tapvpwrvgnd_1
XTAP_1316 VGND VPWR sky130_fd_sc_hd__tapvpwrvgnd_1
XTAP_1349 VGND VPWR sky130_fd_sc_hd__tapvpwrvgnd_1
XFILLER_0_83_109 VGND VGND VPWR VPWR sky130_fd_sc_hd__decap_3
XFILLER_0_77_673 VGND VGND VPWR VPWR sky130_fd_sc_hd__fill_2
XFILLER_0_76_161 VGND VGND VPWR VPWR sky130_fd_sc_hd__fill_2
XFILLER_0_76_150 VGND VGND VPWR VPWR sky130_fd_sc_hd__decap_3
X_6919_ clknet_leaf_60_clk _0005_ net73 VGND VGND VPWR VPWR u_fsm.h_cnt\[1\] sky130_fd_sc_hd__dfrtp_1
XFILLER_0_92_643 VGND VGND VPWR VPWR sky130_fd_sc_hd__fill_1
XANTENNA__6527__A1 _1806_ VGND VGND VPWR VPWR sky130_fd_sc_hd__diode_2
XFILLER_0_92_676 VGND VGND VPWR VPWR sky130_fd_sc_hd__fill_1
XFILLER_0_64_378 VGND VGND VPWR VPWR sky130_fd_sc_hd__decap_6
XFILLER_0_107_469 VGND VGND VPWR VPWR sky130_fd_sc_hd__fill_1
XFILLER_0_107_458 VGND VGND VPWR VPWR sky130_fd_sc_hd__fill_1
XFILLER_0_45_581 VGND VGND VPWR VPWR sky130_fd_sc_hd__decap_4
XFILLER_0_60_573 VGND VGND VPWR VPWR sky130_fd_sc_hd__decap_4
XFILLER_0_32_253 VGND VGND VPWR VPWR sky130_fd_sc_hd__decap_4
XANTENNA__7285__RESET_B net75 VGND VGND VPWR VPWR sky130_fd_sc_hd__diode_2
XFILLER_0_103_653 VPWR VGND VPWR VGND sky130_ef_sc_hd__decap_12
XFILLER_0_102_141 VGND VGND VPWR VPWR sky130_fd_sc_hd__decap_4
Xhold390 u_pe_array.u_fifo1.buffer\[5\]\[4\] VGND VGND VPWR VPWR net466 sky130_fd_sc_hd__dlygate4sd3_1
XANTENNA__7214__RESET_B net75 VGND VGND VPWR VPWR sky130_fd_sc_hd__diode_2
XFILLER_0_20_459 VGND VGND VPWR VPWR sky130_fd_sc_hd__fill_2
XANTENNA__6884__S _3412_ VGND VGND VPWR VPWR sky130_fd_sc_hd__diode_2
XANTENNA_clkbuf_leaf_82_clk_A clknet_3_4__leaf_clk VGND VGND VPWR VPWR sky130_fd_sc_hd__diode_2
XFILLER_0_99_297 VGND VGND VPWR VPWR sky130_fd_sc_hd__decap_3
XANTENNA__6766__A1 _3128_ VGND VGND VPWR VPWR sky130_fd_sc_hd__diode_2
XFILLER_0_95_470 VGND VGND VPWR VPWR sky130_fd_sc_hd__fill_2
XFILLER_0_55_301 VGND VGND VPWR VPWR sky130_fd_sc_hd__decap_3
XFILLER_0_83_621 VGND VGND VPWR VPWR sky130_fd_sc_hd__decap_4
XFILLER_0_7_409 VGND VGND VPWR VPWR sky130_fd_sc_hd__fill_1
XFILLER_0_23_57 VPWR VGND VPWR VGND sky130_ef_sc_hd__decap_12
XFILLER_0_83_665 VGND VGND VPWR VPWR sky130_fd_sc_hd__fill_2
XFILLER_0_70_315 VPWR VGND VPWR VGND sky130_ef_sc_hd__decap_12
XFILLER_0_36_581 VGND VGND VPWR VPWR sky130_fd_sc_hd__fill_2
XFILLER_0_113_417 VPWR VGND VPWR VGND sky130_ef_sc_hd__decap_12
XANTENNA_clkbuf_leaf_20_clk_A clknet_3_2__leaf_clk VGND VGND VPWR VPWR sky130_fd_sc_hd__diode_2
X_3580_ _0717_ _0786_ VGND VGND VPWR VPWR _0818_ sky130_fd_sc_hd__nand2_1
XFILLER_0_51_540 VGND VGND VPWR VPWR sky130_fd_sc_hd__fill_2
XFILLER_0_3_615 VGND VGND VPWR VPWR sky130_fd_sc_hd__fill_1
X_5250_ _2199_ _2200_ net706 _0916_ VGND VGND VPWR VPWR _0293_ sky130_fd_sc_hd__a2bb2o_1
X_4201_ _1275_ _1329_ u_pe_array.g_pe_row\[3\].g_pe_col\[0\].u_pe.psum_out\[6\] VGND
+ VGND VPWR VPWR _1331_ sky130_fd_sc_hd__a21oi_1
XANTENNA_clkbuf_leaf_35_clk_A clknet_3_3__leaf_clk VGND VGND VPWR VPWR sky130_fd_sc_hd__diode_2
X_5181_ _0765_ _1832_ _0747_ VGND VGND VPWR VPWR _2145_ sky130_fd_sc_hd__mux2_1
X_4132_ u_pe_array.g_pe_row\[3\].g_pe_col\[3\].u_pe.psum_out\[12\] u_pe_array.g_pe_row\[3\].g_pe_col\[3\].u_pe.move_reg\[12\]
+ _0855_ VGND VGND VPWR VPWR _1269_ sky130_fd_sc_hd__mux2_1
X_4063_ _1210_ _1211_ u_pe_array.g_pe_row\[3\].g_pe_col\[1\].u_pe.psum_out\[7\] _1201_
+ VGND VGND VPWR VPWR _1219_ sky130_fd_sc_hd__o2bb2a_1
XANTENNA__6937__RESET_B net74 VGND VGND VPWR VPWR sky130_fd_sc_hd__diode_2
XFILLER_0_64_53 VPWR VGND VPWR VGND sky130_ef_sc_hd__decap_12
XANTENNA__3807__A2 _0996_ VGND VGND VPWR VPWR sky130_fd_sc_hd__diode_2
XANTENNA__3512__A _0768_ VGND VGND VPWR VPWR sky130_fd_sc_hd__diode_2
XFILLER_0_64_97 VGND VGND VPWR VPWR sky130_fd_sc_hd__decap_3
XFILLER_0_78_448 VGND VGND VPWR VPWR sky130_fd_sc_hd__fill_2
XFILLER_0_59_651 VGND VGND VPWR VPWR sky130_fd_sc_hd__fill_2
XFILLER_0_59_673 VGND VGND VPWR VPWR sky130_fd_sc_hd__fill_2
XFILLER_0_58_150 VGND VGND VPWR VPWR sky130_fd_sc_hd__fill_2
XFILLER_0_46_301 VGND VGND VPWR VPWR sky130_fd_sc_hd__decap_4
XFILLER_0_19_515 VGND VGND VPWR VPWR sky130_fd_sc_hd__fill_2
X_4965_ _1958_ _1959_ VGND VGND VPWR VPWR _1961_ sky130_fd_sc_hd__and2_1
XANTENNA__6034__S _0756_ VGND VGND VPWR VPWR sky130_fd_sc_hd__diode_2
X_6704_ net375 _3120_ _3324_ VGND VGND VPWR VPWR _3330_ sky130_fd_sc_hd__mux2_1
XFILLER_0_74_643 VGND VGND VPWR VPWR sky130_fd_sc_hd__fill_1
XFILLER_0_58_161 VGND VGND VPWR VPWR sky130_fd_sc_hd__fill_1
X_3916_ _1088_ _1096_ _1097_ _1098_ VGND VGND VPWR VPWR _1099_ sky130_fd_sc_hd__a31o_1
XFILLER_0_104_81 VGND VGND VPWR VPWR sky130_fd_sc_hd__fill_1
X_4896_ _1899_ _1847_ u_pe_array.g_pe_row\[2\].g_pe_col\[0\].u_pe.psum_out\[6\] VGND
+ VGND VPWR VPWR _1901_ sky130_fd_sc_hd__a21oi_1
XFILLER_0_80_85 VGND VGND VPWR VPWR sky130_fd_sc_hd__decap_6
XFILLER_0_74_676 VGND VGND VPWR VPWR sky130_fd_sc_hd__fill_1
XFILLER_0_74_654 VGND VGND VPWR VPWR sky130_fd_sc_hd__fill_2
XFILLER_0_6_431 VGND VGND VPWR VPWR sky130_fd_sc_hd__fill_2
XFILLER_0_13_90 VGND VGND VPWR VPWR sky130_fd_sc_hd__decap_3
X_6635_ _0994_ net11 _0747_ VGND VGND VPWR VPWR _3287_ sky130_fd_sc_hd__mux2_1
XFILLER_0_27_570 VGND VGND VPWR VPWR sky130_fd_sc_hd__fill_2
X_3847_ _1027_ _1028_ _1034_ VGND VGND VPWR VPWR _1036_ sky130_fd_sc_hd__o21ai_1
XFILLER_0_61_337 VGND VGND VPWR VPWR sky130_fd_sc_hd__decap_3
X_6566_ _3250_ VGND VGND VPWR VPWR _0559_ sky130_fd_sc_hd__clkbuf_1
X_3778_ _0984_ VGND VGND VPWR VPWR _0037_ sky130_fd_sc_hd__clkbuf_1
X_5517_ _2425_ _2428_ _2433_ VGND VGND VPWR VPWR _2435_ sky130_fd_sc_hd__or3_1
XFILLER_0_42_551 VGND VGND VPWR VPWR sky130_fd_sc_hd__fill_2
XANTENNA_load_slew7_A net74 VGND VGND VPWR VPWR sky130_fd_sc_hd__diode_2
X_6497_ _3213_ VGND VGND VPWR VPWR _0527_ sky130_fd_sc_hd__clkbuf_1
XFILLER_0_42_584 VGND VGND VPWR VPWR sky130_fd_sc_hd__fill_2
XANTENNA__5496__A1 _2258_ VGND VGND VPWR VPWR sky130_fd_sc_hd__diode_2
X_5448_ _2368_ _2370_ VGND VGND VPWR VPWR _2372_ sky130_fd_sc_hd__nand2_1
XANTENNA__5605__C _2478_ VGND VGND VPWR VPWR sky130_fd_sc_hd__diode_2
XFILLER_0_100_645 VPWR VGND VPWR VGND sky130_ef_sc_hd__decap_12
X_5379_ _1787_ _2315_ VGND VGND VPWR VPWR _2316_ sky130_fd_sc_hd__or2_1
X_7118_ clknet_leaf_37_clk _0189_ net816 VGND VGND VPWR VPWR u_pe_array.g_pe_row\[2\].g_pe_col\[0\].u_pe.move_reg\[10\]
+ sky130_fd_sc_hd__dfrtp_1
X_7049_ clknet_leaf_91_clk _0124_ net819 VGND VGND VPWR VPWR u_pe_array.g_pe_row\[2\].g_pe_col\[2\].u_pe.act_val\[1\]
+ sky130_fd_sc_hd__dfrtp_1
XTAP_1113 VGND VPWR sky130_fd_sc_hd__tapvpwrvgnd_1
XTAP_1102 VGND VPWR sky130_fd_sc_hd__tapvpwrvgnd_1
XTAP_1146 VGND VPWR sky130_fd_sc_hd__tapvpwrvgnd_1
XTAP_1135 VGND VPWR sky130_fd_sc_hd__tapvpwrvgnd_1
XTAP_1124 VGND VPWR sky130_fd_sc_hd__tapvpwrvgnd_1
XTAP_1179 VGND VPWR sky130_fd_sc_hd__tapvpwrvgnd_1
XTAP_1168 VGND VPWR sky130_fd_sc_hd__tapvpwrvgnd_1
XTAP_1157 VGND VPWR sky130_fd_sc_hd__tapvpwrvgnd_1
XFILLER_0_92_451 VGND VGND VPWR VPWR sky130_fd_sc_hd__fill_1
XFILLER_0_37_367 VGND VGND VPWR VPWR sky130_fd_sc_hd__fill_2
XFILLER_0_80_624 VGND VGND VPWR VPWR sky130_fd_sc_hd__decap_3
XFILLER_0_64_175 VGND VGND VPWR VPWR sky130_fd_sc_hd__fill_1
XFILLER_0_52_326 VGND VGND VPWR VPWR sky130_fd_sc_hd__fill_2
XFILLER_0_107_277 VGND VGND VPWR VPWR sky130_fd_sc_hd__decap_3
XANTENNA__5184__B1 _1655_ VGND VGND VPWR VPWR sky130_fd_sc_hd__diode_2
XFILLER_0_64_197 VGND VGND VPWR VPWR sky130_fd_sc_hd__fill_2
XFILLER_0_103_483 VPWR VGND VPWR VGND sky130_ef_sc_hd__decap_12
XTAP_908 VGND VPWR sky130_fd_sc_hd__tapvpwrvgnd_1
XTAP_919 VGND VPWR sky130_fd_sc_hd__tapvpwrvgnd_1
XFILLER_0_109_37 VPWR VGND VPWR VGND sky130_ef_sc_hd__decap_12
XANTENNA__3689__D _0869_ VGND VGND VPWR VPWR sky130_fd_sc_hd__diode_2
XANTENNA__6739__A1 _3128_ VGND VGND VPWR VPWR sky130_fd_sc_hd__diode_2
XANTENNA_output35_A net35 VGND VGND VPWR VPWR sky130_fd_sc_hd__diode_2
XANTENNA__5411__B2 _2336_ VGND VGND VPWR VPWR sky130_fd_sc_hd__diode_2
XFILLER_0_56_610 VGND VGND VPWR VPWR sky130_fd_sc_hd__decap_3
X_4750_ net816 VGND VGND VPWR VPWR _1789_ sky130_fd_sc_hd__inv_2
XFILLER_0_50_33 VGND VGND VPWR VPWR sky130_fd_sc_hd__decap_4
XANTENNA__5962__A2 _2743_ VGND VGND VPWR VPWR sky130_fd_sc_hd__diode_2
XFILLER_0_7_206 VGND VGND VPWR VPWR sky130_fd_sc_hd__fill_1
XFILLER_0_28_334 VGND VGND VPWR VPWR sky130_fd_sc_hd__fill_2
XFILLER_0_28_356 VGND VGND VPWR VPWR sky130_fd_sc_hd__fill_1
XANTENNA__6789__S _3366_ VGND VGND VPWR VPWR sky130_fd_sc_hd__diode_2
XANTENNA__3973__B2 _1004_ VGND VGND VPWR VPWR sky130_fd_sc_hd__diode_2
XFILLER_0_70_112 VGND VGND VPWR VPWR sky130_fd_sc_hd__fill_1
X_4681_ u_pe_array.g_pe_row\[2\].g_pe_col\[1\].u_pe.psum_out\[5\] _1717_ _1726_ VGND
+ VGND VPWR VPWR _1727_ sky130_fd_sc_hd__a21o_1
XFILLER_0_50_66 VGND VGND VPWR VPWR sky130_fd_sc_hd__decap_3
XFILLER_0_43_326 VGND VGND VPWR VPWR sky130_fd_sc_hd__decap_4
X_3701_ _0912_ _0915_ net720 _0916_ VGND VGND VPWR VPWR _0028_ sky130_fd_sc_hd__a2bb2o_1
XFILLER_0_28_389 VGND VGND VPWR VPWR sky130_fd_sc_hd__fill_1
XANTENNA__5175__B1 _1655_ VGND VGND VPWR VPWR sky130_fd_sc_hd__diode_2
XFILLER_0_55_197 VGND VGND VPWR VPWR sky130_fd_sc_hd__fill_1
XFILLER_0_43_337 VGND VGND VPWR VPWR sky130_fd_sc_hd__fill_2
X_6420_ _3173_ VGND VGND VPWR VPWR _0490_ sky130_fd_sc_hd__clkbuf_1
X_3632_ net146 _0834_ _0854_ u_fsm.psum_shift_en VGND VGND VPWR VPWR _0021_ sky130_fd_sc_hd__a22o_1
XANTENNA__5714__A2 _2463_ VGND VGND VPWR VPWR sky130_fd_sc_hd__diode_2
XFILLER_0_113_225 VPWR VGND VPWR VGND sky130_ef_sc_hd__decap_12
X_6351_ _3127_ VGND VGND VPWR VPWR _0467_ sky130_fd_sc_hd__clkbuf_1
XFILLER_0_70_156 VGND VGND VPWR VPWR sky130_fd_sc_hd__decap_3
XFILLER_0_3_434 VGND VGND VPWR VPWR sky130_fd_sc_hd__decap_8
XANTENNA__3725__A1 _0864_ VGND VGND VPWR VPWR sky130_fd_sc_hd__diode_2
XFILLER_0_70_189 VGND VGND VPWR VPWR sky130_fd_sc_hd__decap_3
X_5302_ _2238_ _2240_ _2246_ _0885_ VGND VGND VPWR VPWR _2248_ sky130_fd_sc_hd__o31a_1
X_3563_ _0718_ u_fsm.next_state\[0\] VGND VGND VPWR VPWR _0807_ sky130_fd_sc_hd__xor2_1
X_6282_ u_pe_array.g_pe_row\[0\].g_pe_col\[0\].u_pe.psum_out\[8\] _2992_ VGND VGND
+ VPWR VPWR _3072_ sky130_fd_sc_hd__or2_1
X_3494_ _0755_ VGND VGND VPWR VPWR _0756_ sky130_fd_sc_hd__clkbuf_16
XANTENNA__3941__S _0828_ VGND VGND VPWR VPWR sky130_fd_sc_hd__diode_2
X_5233_ _2182_ _2184_ VGND VGND VPWR VPWR _2185_ sky130_fd_sc_hd__nor2_1
X_5164_ _2125_ _2131_ _2134_ _2129_ VGND VGND VPWR VPWR _2135_ sky130_fd_sc_hd__a22oi_1
X_4115_ net634 _1138_ _1258_ _1260_ VGND VGND VPWR VPWR _0098_ sky130_fd_sc_hd__a22o_1
XFILLER_0_75_85 VGND VGND VPWR VPWR sky130_fd_sc_hd__decap_8
X_5095_ u_pe_array.g_pe_row\[1\].g_pe_col\[3\].u_pe.act_val\[4\] _2029_ VGND VGND
+ VPWR VPWR _2073_ sky130_fd_sc_hd__and2b_1
X_4046_ u_pe_array.g_pe_row\[3\].g_pe_col\[1\].u_pe.psum_out\[5\] _1189_ VGND VGND
+ VPWR VPWR _1204_ sky130_fd_sc_hd__nand2_1
XANTENNA__5868__S _0827_ VGND VGND VPWR VPWR sky130_fd_sc_hd__diode_2
XPHY_207 VGND VGND VPWR VPWR sky130_fd_sc_hd__decap_3
XPHY_229 VGND VGND VPWR VPWR sky130_fd_sc_hd__decap_3
XPHY_218 VGND VGND VPWR VPWR sky130_fd_sc_hd__decap_3
XANTENNA__5402__B2 _1665_ VGND VGND VPWR VPWR sky130_fd_sc_hd__diode_2
X_5997_ u_pe_array.g_pe_row\[0\].g_pe_col\[2\].u_pe.psum_out\[9\] _2743_ VGND VGND
+ VPWR VPWR _2831_ sky130_fd_sc_hd__or2_1
X_4948_ _1946_ _1947_ VGND VGND VPWR VPWR _1948_ sky130_fd_sc_hd__or2_1
XANTENNA__4073__A _1145_ VGND VGND VPWR VPWR sky130_fd_sc_hd__diode_2
XFILLER_0_47_643 VGND VGND VPWR VPWR sky130_fd_sc_hd__fill_1
X_7667_ clknet_leaf_26_clk _0716_ VGND VGND VPWR VPWR u_pe_array.u_fifo1.buffer\[7\]\[12\]
+ sky130_fd_sc_hd__dfxtp_1
XANTENNA__3964__B2 _1004_ VGND VGND VPWR VPWR sky130_fd_sc_hd__diode_2
X_4879_ _1884_ _1885_ VGND VGND VPWR VPWR _1886_ sky130_fd_sc_hd__or2_1
XFILLER_0_62_624 VGND VGND VPWR VPWR sky130_fd_sc_hd__fill_2
XFILLER_0_61_101 VGND VGND VPWR VPWR sky130_fd_sc_hd__fill_2
XFILLER_0_46_197 VGND VGND VPWR VPWR sky130_fd_sc_hd__decap_4
X_6618_ _3278_ VGND VGND VPWR VPWR _0583_ sky130_fd_sc_hd__clkbuf_1
X_7598_ clknet_leaf_25_clk _0647_ VGND VGND VPWR VPWR u_pe_array.u_fifo1.buffer\[2\]\[8\]
+ sky130_fd_sc_hd__dfxtp_1
XFILLER_0_61_167 VGND VGND VPWR VPWR sky130_fd_sc_hd__fill_1
XFILLER_0_6_283 VGND VGND VPWR VPWR sky130_fd_sc_hd__fill_2
XFILLER_0_61_189 VGND VGND VPWR VPWR sky130_fd_sc_hd__decap_4
X_6549_ net499 _1800_ _3239_ VGND VGND VPWR VPWR _3242_ sky130_fd_sc_hd__mux2_1
XFILLER_0_100_486 VGND VGND VPWR VPWR sky130_fd_sc_hd__fill_2
XFILLER_0_97_532 VGND VGND VPWR VPWR sky130_fd_sc_hd__fill_2
XANTENNA__4444__A2 _1524_ VGND VGND VPWR VPWR sky130_fd_sc_hd__diode_2
XFILLER_0_69_267 VGND VGND VPWR VPWR sky130_fd_sc_hd__decap_6
XFILLER_0_65_484 VGND VGND VPWR VPWR sky130_fd_sc_hd__fill_2
XFILLER_0_111_27 VPWR VGND VPWR VGND sky130_ef_sc_hd__decap_12
XFILLER_0_92_292 VGND VGND VPWR VPWR sky130_fd_sc_hd__fill_2
XFILLER_0_80_421 VGND VGND VPWR VPWR sky130_fd_sc_hd__fill_1
XFILLER_0_53_635 VGND VGND VPWR VPWR sky130_fd_sc_hd__fill_1
XFILLER_0_25_337 VGND VGND VPWR VPWR sky130_fd_sc_hd__decap_4
XFILLER_0_25_348 VGND VGND VPWR VPWR sky130_fd_sc_hd__decap_8
XFILLER_0_25_359 VGND VGND VPWR VPWR sky130_fd_sc_hd__fill_2
XFILLER_0_40_318 VGND VGND VPWR VPWR sky130_fd_sc_hd__fill_1
XANTENNA__5018__S _0756_ VGND VGND VPWR VPWR sky130_fd_sc_hd__diode_2
XFILLER_0_96_29 VGND VGND VPWR VPWR sky130_fd_sc_hd__decap_4
XFILLER_0_21_565 VGND VGND VPWR VPWR sky130_fd_sc_hd__decap_3
XFILLER_0_21_598 VGND VGND VPWR VPWR sky130_fd_sc_hd__fill_2
XTAP_705 VGND VPWR sky130_fd_sc_hd__tapvpwrvgnd_1
XTAP_716 VGND VPWR sky130_fd_sc_hd__tapvpwrvgnd_1
XTAP_727 VGND VPWR sky130_fd_sc_hd__tapvpwrvgnd_1
XTAP_738 VGND VPWR sky130_fd_sc_hd__tapvpwrvgnd_1
XTAP_749 VGND VPWR sky130_fd_sc_hd__tapvpwrvgnd_1
XFILLER_0_45_55 VGND VGND VPWR VPWR sky130_fd_sc_hd__fill_1
XFILLER_0_88_521 VGND VGND VPWR VPWR sky130_fd_sc_hd__decap_3
XANTENNA__4592__S _0770_ VGND VGND VPWR VPWR sky130_fd_sc_hd__diode_2
XANTENNA__4435__A2 _1392_ VGND VGND VPWR VPWR sky130_fd_sc_hd__diode_2
X_5920_ _2756_ _2757_ _2759_ VGND VGND VPWR VPWR _2760_ sky130_fd_sc_hd__o21a_1
XFILLER_0_48_418 VGND VGND VPWR VPWR sky130_fd_sc_hd__fill_2
XANTENNA__7388__RESET_B net817 VGND VGND VPWR VPWR sky130_fd_sc_hd__diode_2
XFILLER_0_0_57 VPWR VGND VPWR VGND sky130_ef_sc_hd__decap_12
X_5851_ _2702_ _2704_ _2710_ VGND VGND VPWR VPWR _2712_ sky130_fd_sc_hd__a21oi_2
XFILLER_0_56_451 VPWR VGND VPWR VGND sky130_ef_sc_hd__decap_12
X_4802_ net752 _1666_ _1655_ _1825_ VGND VGND VPWR VPWR _0220_ sky130_fd_sc_hd__a22o_1
X_5782_ _2645_ _2646_ _2647_ VGND VGND VPWR VPWR _2649_ sky130_fd_sc_hd__a21oi_1
XFILLER_0_90_218 VGND VGND VPWR VPWR sky130_fd_sc_hd__fill_2
X_4733_ _1765_ _1767_ _1773_ VGND VGND VPWR VPWR _1775_ sky130_fd_sc_hd__a21oi_2
XFILLER_0_44_613 VGND VGND VPWR VPWR sky130_fd_sc_hd__fill_2
X_7521_ clknet_leaf_93_clk _0570_ VGND VGND VPWR VPWR u_pe_array.u_fifo2.buffer\[6\]\[8\]
+ sky130_fd_sc_hd__dfxtp_1
XANTENNA__7317__RESET_B net814 VGND VGND VPWR VPWR sky130_fd_sc_hd__diode_2
XFILLER_0_114_501 VGND VGND VPWR VPWR sky130_fd_sc_hd__decap_3
XFILLER_0_71_432 VGND VGND VPWR VPWR sky130_fd_sc_hd__fill_2
XFILLER_0_43_134 VGND VGND VPWR VPWR sky130_fd_sc_hd__decap_6
X_7452_ clknet_leaf_1_clk _0501_ VGND VGND VPWR VPWR u_pe_array.u_fifo2.buffer\[1\]\[4\]
+ sky130_fd_sc_hd__dfxtp_1
XFILLER_0_114_545 VPWR VGND VPWR VGND sky130_ef_sc_hd__decap_12
X_4664_ _1702_ _1711_ VGND VGND VPWR VPWR _1712_ sky130_fd_sc_hd__nor2_1
X_6403_ net744 _3160_ _3153_ _3163_ VGND VGND VPWR VPWR _0483_ sky130_fd_sc_hd__a211o_1
XFILLER_0_114_567 VPWR VGND VPWR VGND sky130_ef_sc_hd__decap_12
X_7383_ clknet_leaf_47_clk _0436_ net812 VGND VGND VPWR VPWR u_pe_array.g_pe_row\[0\].g_pe_col\[1\].u_pe.psum_out\[7\]
+ sky130_fd_sc_hd__dfrtp_4
X_4595_ u_pe_array.g_pe_row\[2\].g_pe_col\[1\].u_pe.act_val\[4\] u_pe_array.g_pe_row\[2\].g_pe_col\[1\].u_pe.psum_out\[4\]
+ _0770_ VGND VGND VPWR VPWR _1656_ sky130_fd_sc_hd__mux2_1
X_3615_ net24 _0844_ _0819_ VGND VGND VPWR VPWR _0845_ sky130_fd_sc_hd__mux2_1
XFILLER_0_114_589 VPWR VGND VPWR VGND sky130_ef_sc_hd__decap_12
X_6334_ _1787_ _1128_ net55 VGND VGND VPWR VPWR _3116_ sky130_fd_sc_hd__a21o_2
X_3546_ u_fsm.cnt\[1\] u_fsm.cnt\[0\] _0791_ VGND VGND VPWR VPWR _0792_ sky130_fd_sc_hd__nand3_2
XFILLER_0_3_275 VGND VGND VPWR VPWR sky130_fd_sc_hd__fill_2
X_6265_ _3053_ VGND VGND VPWR VPWR _3056_ sky130_fd_sc_hd__inv_2
XANTENNA__4767__S _1796_ VGND VGND VPWR VPWR sky130_fd_sc_hd__diode_2
XANTENNA__6952__RESET_B net815 VGND VGND VPWR VPWR sky130_fd_sc_hd__diode_2
X_3477_ u_pe_array.g_pe_row\[3\].g_pe_col\[0\].u_pe.move_reg\[6\] _0730_ VGND VGND
+ VPWR VPWR _0746_ sky130_fd_sc_hd__or2_1
X_5216_ _2167_ _2168_ VGND VGND VPWR VPWR _2169_ sky130_fd_sc_hd__xnor2_1
XFILLER_0_50_3 VGND VGND VPWR VPWR sky130_fd_sc_hd__fill_2
X_6196_ u_pe_array.g_pe_row\[0\].g_pe_col\[0\].u_pe.act_val\[0\] _2992_ u_pe_array.g_pe_row\[0\].g_pe_col\[0\].u_pe.psum_out\[1\]
+ VGND VGND VPWR VPWR _2993_ sky130_fd_sc_hd__a21oi_1
XFILLER_0_86_95 VGND VGND VPWR VPWR sky130_fd_sc_hd__decap_3
XANTENNA__4123__B2 _1004_ VGND VGND VPWR VPWR sky130_fd_sc_hd__diode_2
X_5147_ _2029_ u_pe_array.g_pe_row\[1\].g_pe_col\[3\].u_pe.psum_out\[10\] VGND VGND
+ VPWR VPWR _2120_ sky130_fd_sc_hd__nand2_1
X_5078_ _1725_ _2056_ _2057_ _1534_ net515 VGND VGND VPWR VPWR _0264_ sky130_fd_sc_hd__a32o_1
X_4029_ u_pe_array.g_pe_row\[3\].g_pe_col\[1\].u_pe.w_reg\[0\] u_pe_array.g_pe_row\[3\].g_pe_col\[1\].u_pe.act_val\[5\]
+ VGND VGND VPWR VPWR _1188_ sky130_fd_sc_hd__nand2_1
XANTENNA__3700__A _0866_ VGND VGND VPWR VPWR sky130_fd_sc_hd__diode_2
XFILLER_0_109_317 VPWR VGND VPWR VGND sky130_ef_sc_hd__decap_12
XANTENNA__7058__RESET_B net74 VGND VGND VPWR VPWR sky130_fd_sc_hd__diode_2
XFILLER_0_74_292 VGND VGND VPWR VPWR sky130_fd_sc_hd__fill_1
XFILLER_0_62_421 VGND VGND VPWR VPWR sky130_fd_sc_hd__decap_3
XFILLER_0_19_197 VGND VGND VPWR VPWR sky130_fd_sc_hd__fill_2
XFILLER_0_50_616 VGND VGND VPWR VPWR sky130_fd_sc_hd__fill_2
XFILLER_0_50_649 VGND VGND VPWR VPWR sky130_fd_sc_hd__fill_2
XFILLER_0_30_362 VGND VGND VPWR VPWR sky130_fd_sc_hd__fill_2
XFILLER_0_30_373 VGND VGND VPWR VPWR sky130_fd_sc_hd__decap_3
XFILLER_0_100_261 VGND VGND VPWR VPWR sky130_fd_sc_hd__fill_2
XANTENNA__4114__A1 u_pe_array.g_pe_row\[3\].g_pe_col\[3\].u_pe.act_val\[3\] VGND VGND
+ VPWR VPWR sky130_fd_sc_hd__diode_2
XANTENNA__6892__S _3427_ VGND VGND VPWR VPWR sky130_fd_sc_hd__diode_2
XANTENNA_input34_A w_in_flat[7] VGND VGND VPWR VPWR sky130_fd_sc_hd__diode_2
XFILLER_0_106_27 VGND VGND VPWR VPWR sky130_fd_sc_hd__fill_1
XANTENNA__4706__A _1672_ VGND VGND VPWR VPWR sky130_fd_sc_hd__diode_2
XFILLER_0_85_513 VGND VGND VPWR VPWR sky130_fd_sc_hd__fill_2
XFILLER_0_57_259 VGND VGND VPWR VPWR sky130_fd_sc_hd__decap_4
XFILLER_0_72_229 VGND VGND VPWR VPWR sky130_fd_sc_hd__fill_2
XANTENNA__3928__A1 _0864_ VGND VGND VPWR VPWR sky130_fd_sc_hd__diode_2
XFILLER_0_5_529 VPWR VGND VPWR VGND sky130_ef_sc_hd__decap_12
XFILLER_0_53_476 VGND VGND VPWR VPWR sky130_fd_sc_hd__fill_2
XFILLER_0_25_167 VGND VGND VPWR VPWR sky130_fd_sc_hd__fill_1
Xhold208 u_pe_array.g_pe_row\[1\].g_pe_col\[1\].u_pe.move_reg\[7\] VGND VGND VPWR
+ VPWR net284 sky130_fd_sc_hd__dlygate4sd3_1
XFILLER_0_53_498 VGND VGND VPWR VPWR sky130_fd_sc_hd__decap_4
Xhold219 u_pe_array.u_fifo2.buffer\[4\]\[6\] VGND VGND VPWR VPWR net295 sky130_fd_sc_hd__dlygate4sd3_1
X_4380_ _1471_ _1472_ u_pe_array.g_pe_row\[2\].g_pe_col\[3\].u_pe.psum_out\[7\] _1462_
+ VGND VGND VPWR VPWR _1480_ sky130_fd_sc_hd__o2bb2a_1
XANTENNA__5550__B1 _1655_ VGND VGND VPWR VPWR sky130_fd_sc_hd__diode_2
XFILLER_0_111_559 VGND VGND VPWR VPWR sky130_fd_sc_hd__fill_1
XFILLER_0_21_373 VGND VGND VPWR VPWR sky130_fd_sc_hd__fill_1
XTAP_502 VGND VPWR sky130_fd_sc_hd__tapvpwrvgnd_1
XTAP_513 VGND VPWR sky130_fd_sc_hd__tapvpwrvgnd_1
XTAP_524 VGND VPWR sky130_fd_sc_hd__tapvpwrvgnd_1
X_6050_ u_pe_array.g_pe_row\[0\].g_pe_col\[1\].u_pe.psum_out\[11\] u_pe_array.g_pe_row\[0\].g_pe_col\[1\].u_pe.move_reg\[11\]
+ _2469_ VGND VGND VPWR VPWR _2867_ sky130_fd_sc_hd__mux2_1
XANTENNA__5302__B1 _0885_ VGND VGND VPWR VPWR sky130_fd_sc_hd__diode_2
XTAP_535 VGND VPWR sky130_fd_sc_hd__tapvpwrvgnd_1
XTAP_546 VGND VPWR sky130_fd_sc_hd__tapvpwrvgnd_1
XTAP_557 VGND VPWR sky130_fd_sc_hd__tapvpwrvgnd_1
XFILLER_0_56_65 VGND VGND VPWR VPWR sky130_fd_sc_hd__decap_8
X_5001_ _1787_ _1994_ VGND VGND VPWR VPWR _1995_ sky130_fd_sc_hd__or2_1
XTAP_568 VGND VPWR sky130_fd_sc_hd__tapvpwrvgnd_1
XTAP_579 VGND VPWR sky130_fd_sc_hd__tapvpwrvgnd_1
XANTENNA__3616__B1 _0837_ VGND VGND VPWR VPWR sky130_fd_sc_hd__diode_2
X_6952_ clknet_leaf_79_clk _0033_ net815 VGND VGND VPWR VPWR u_pe_array.g_pe_row\[3\].g_pe_col\[3\].u_pe.psum_out\[9\]
+ sky130_fd_sc_hd__dfrtp_2
X_6883_ _3424_ VGND VGND VPWR VPWR _0702_ sky130_fd_sc_hd__clkbuf_1
XFILLER_0_88_384 VGND VGND VPWR VPWR sky130_fd_sc_hd__fill_2
X_5903_ u_pe_array.g_pe_row\[0\].g_pe_col\[2\].u_pe.act_val\[0\] u_pe_array.g_pe_row\[0\].g_pe_col\[2\].u_pe.psum_out\[1\]
+ _2743_ VGND VGND VPWR VPWR _2745_ sky130_fd_sc_hd__and3_1
XFILLER_0_76_546 VGND VGND VPWR VPWR sky130_fd_sc_hd__fill_2
XFILLER_0_29_440 VGND VGND VPWR VPWR sky130_fd_sc_hd__fill_2
X_5834_ _2611_ u_pe_array.g_pe_row\[0\].g_pe_col\[3\].u_pe.psum_out\[9\] VGND VGND
+ VPWR VPWR _2696_ sky130_fd_sc_hd__nor2_1
XFILLER_0_63_229 VGND VGND VPWR VPWR sky130_fd_sc_hd__decap_3
XFILLER_0_8_345 VPWR VGND VPWR VGND sky130_ef_sc_hd__decap_12
XANTENNA__7151__RESET_B net814 VGND VGND VPWR VPWR sky130_fd_sc_hd__diode_2
XANTENNA__3919__A1 _0864_ VGND VGND VPWR VPWR sky130_fd_sc_hd__diode_2
X_5765_ _2630_ _2632_ VGND VGND VPWR VPWR _2633_ sky130_fd_sc_hd__nand2_1
XFILLER_0_98_3 VPWR VGND VPWR VGND sky130_ef_sc_hd__decap_12
XANTENNA__6042__S _2469_ VGND VGND VPWR VPWR sky130_fd_sc_hd__diode_2
X_5696_ u_pe_array.g_pe_row\[1\].g_pe_col\[0\].u_pe.psum_out\[11\] _2583_ _2574_ VGND
+ VGND VPWR VPWR _2584_ sky130_fd_sc_hd__mux2_1
X_4716_ _1672_ u_pe_array.g_pe_row\[2\].g_pe_col\[1\].u_pe.psum_out\[9\] VGND VGND
+ VPWR VPWR _1759_ sky130_fd_sc_hd__nor2_1
X_7504_ clknet_leaf_1_clk _0553_ VGND VGND VPWR VPWR u_pe_array.u_fifo2.buffer\[5\]\[4\]
+ sky130_fd_sc_hd__dfxtp_1
XFILLER_0_32_616 VGND VGND VPWR VPWR sky130_fd_sc_hd__fill_2
XFILLER_0_114_353 VGND VGND VPWR VPWR sky130_fd_sc_hd__decap_8
X_4647_ u_pe_array.g_pe_row\[2\].g_pe_col\[1\].u_pe.w_reg\[0\] u_pe_array.g_pe_row\[2\].g_pe_col\[1\].u_pe.act_val\[2\]
+ _1681_ VGND VGND VPWR VPWR _1696_ sky130_fd_sc_hd__and3_1
X_7435_ clknet_leaf_9_clk _0484_ VGND VGND VPWR VPWR u_pe_array.u_fifo2.buffer\[0\]\[0\]
+ sky130_fd_sc_hd__dfxtp_1
Xhold720 u_pe_array.g_pe_row\[2\].g_pe_col\[0\].u_pe.w_buffer\[1\] VGND VGND VPWR
+ VPWR net796 sky130_fd_sc_hd__dlygate4sd3_1
X_7366_ clknet_leaf_45_clk _0421_ net812 VGND VGND VPWR VPWR u_pe_array.g_pe_row\[0\].g_pe_col\[0\].u_pe.act_val\[5\]
+ sky130_fd_sc_hd__dfrtp_1
XFILLER_0_102_548 VGND VGND VPWR VPWR sky130_fd_sc_hd__fill_1
XFILLER_0_102_537 VGND VGND VPWR VPWR sky130_fd_sc_hd__fill_1
X_6317_ net456 _0867_ _2174_ _3102_ VGND VGND VPWR VPWR _0458_ sky130_fd_sc_hd__a22o_1
Xhold742 u_pe_array.g_pe_row\[3\].g_pe_col\[1\].u_pe.act_val\[1\] VGND VGND VPWR VPWR
+ net826 sky130_fd_sc_hd__dlygate4sd3_1
XFILLER_0_12_373 VGND VGND VPWR VPWR sky130_fd_sc_hd__fill_2
X_4578_ _1637_ _1642_ _1645_ _1640_ VGND VGND VPWR VPWR _1646_ sky130_fd_sc_hd__a22oi_2
Xhold731 u_pe_array.g_pe_row\[0\].g_pe_col\[3\].u_pe.move_reg\[11\] VGND VGND VPWR
+ VPWR net807 sky130_fd_sc_hd__dlygate4sd3_1
X_7297_ clknet_leaf_40_clk _0356_ net75 VGND VGND VPWR VPWR u_pe_array.g_pe_row\[1\].g_pe_col\[0\].u_pe.psum_out\[11\]
+ sky130_fd_sc_hd__dfrtp_1
X_3529_ _0717_ _0718_ VGND VGND VPWR VPWR _0778_ sky130_fd_sc_hd__xnor2_1
XFILLER_0_110_581 VGND VGND VPWR VPWR sky130_fd_sc_hd__decap_6
X_6248_ _3025_ _3026_ _3039_ VGND VGND VPWR VPWR _3041_ sky130_fd_sc_hd__nor3_1
X_6179_ u_pe_array.g_pe_row\[0\].g_pe_col\[1\].u_pe.psum_out\[9\] u_pe_array.g_pe_row\[0\].g_pe_col\[1\].u_pe.psum_out\[10\]
+ _2873_ VGND VGND VPWR VPWR _2982_ sky130_fd_sc_hd__o21a_1
XFILLER_0_99_649 VPWR VGND VPWR VGND sky130_ef_sc_hd__decap_12
XANTENNA__7239__RESET_B net813 VGND VGND VPWR VPWR sky130_fd_sc_hd__diode_2
XANTENNA__3607__B1 _0837_ VGND VGND VPWR VPWR sky130_fd_sc_hd__diode_2
XFILLER_0_67_568 VGND VGND VPWR VPWR sky130_fd_sc_hd__fill_2
XANTENNA__4960__S _0828_ VGND VGND VPWR VPWR sky130_fd_sc_hd__diode_2
XFILLER_0_109_147 VGND VGND VPWR VPWR sky130_fd_sc_hd__fill_1
XFILLER_0_90_593 VGND VGND VPWR VPWR sky130_fd_sc_hd__decap_4
XFILLER_0_62_295 VGND VGND VPWR VPWR sky130_fd_sc_hd__fill_2
XFILLER_0_30_192 VGND VGND VPWR VPWR sky130_fd_sc_hd__fill_2
XANTENNA__4638__A2 _1152_ VGND VGND VPWR VPWR sky130_fd_sc_hd__diode_2
Xhold91 _0259_ VGND VGND VPWR VPWR net167 sky130_fd_sc_hd__dlygate4sd3_1
Xhold80 u_pe_array.g_pe_row\[0\].g_pe_col\[3\].u_pe.move_reg\[10\] VGND VGND VPWR
+ VPWR net156 sky130_fd_sc_hd__dlygate4sd3_1
XFILLER_0_58_524 VGND VGND VPWR VPWR sky130_fd_sc_hd__decap_3
XFILLER_0_9_109 VGND VGND VPWR VPWR sky130_fd_sc_hd__decap_3
XFILLER_0_85_387 VGND VGND VPWR VPWR sky130_fd_sc_hd__decap_4
XFILLER_0_73_505 VGND VGND VPWR VPWR sky130_fd_sc_hd__fill_2
XFILLER_0_45_218 VGND VGND VPWR VPWR sky130_fd_sc_hd__decap_4
Xclkbuf_leaf_70_clk clknet_3_5__leaf_clk VGND VGND VPWR VPWR clknet_leaf_70_clk sky130_fd_sc_hd__clkbuf_16
X_3880_ u_pe_array.g_pe_row\[3\].g_pe_col\[2\].u_pe.psum_out\[5\] _1009_ VGND VGND
+ VPWR VPWR _1066_ sky130_fd_sc_hd__nand2_1
XFILLER_0_42_45 VGND VGND VPWR VPWR sky130_fd_sc_hd__fill_2
XFILLER_0_26_421 VGND VGND VPWR VPWR sky130_fd_sc_hd__fill_2
XFILLER_0_38_292 VGND VGND VPWR VPWR sky130_fd_sc_hd__decap_6
XFILLER_0_26_454 VGND VGND VPWR VPWR sky130_fd_sc_hd__fill_1
X_5550_ net794 _2144_ _1655_ _2461_ VGND VGND VPWR VPWR _0332_ sky130_fd_sc_hd__a22o_1
XANTENNA__6797__S _3366_ VGND VGND VPWR VPWR sky130_fd_sc_hd__diode_2
XFILLER_0_84_9 VGND VGND VPWR VPWR sky130_fd_sc_hd__decap_6
X_5481_ _2345_ _2400_ u_pe_array.g_pe_row\[1\].g_pe_col\[1\].u_pe.psum_out\[6\] VGND
+ VGND VPWR VPWR _2402_ sky130_fd_sc_hd__a21oi_1
XFILLER_0_14_638 VGND VGND VPWR VPWR sky130_fd_sc_hd__fill_2
X_4501_ _1566_ _1575_ _0914_ VGND VGND VPWR VPWR _1577_ sky130_fd_sc_hd__a21o_1
X_7220_ clknet_leaf_51_clk net177 net812 VGND VGND VPWR VPWR u_pe_array.g_pe_row\[1\].g_pe_col\[1\].u_pe.move_reg\[9\]
+ sky130_fd_sc_hd__dfrtp_1
X_4432_ u_pe_array.g_pe_row\[3\].g_pe_col\[1\].u_pe.psum_out\[4\] u_pe_array.g_pe_row\[3\].g_pe_col\[1\].u_pe.act_val\[4\]
+ _0769_ VGND VGND VPWR VPWR _1521_ sky130_fd_sc_hd__mux2_1
XFILLER_0_22_671 VGND VGND VPWR VPWR sky130_fd_sc_hd__fill_2
XFILLER_0_41_479 VGND VGND VPWR VPWR sky130_fd_sc_hd__fill_1
X_4363_ u_pe_array.g_pe_row\[2\].g_pe_col\[3\].u_pe.psum_out\[5\] _1450_ VGND VGND
+ VPWR VPWR _1465_ sky130_fd_sc_hd__nand2_1
XFILLER_0_1_565 VGND VGND VPWR VPWR sky130_fd_sc_hd__fill_2
X_7151_ clknet_leaf_79_clk _0220_ net814 VGND VGND VPWR VPWR u_pe_array.g_pe_row\[1\].g_pe_col\[3\].u_pe.act_val\[0\]
+ sky130_fd_sc_hd__dfrtp_2
XFILLER_0_111_389 VGND VGND VPWR VPWR sky130_fd_sc_hd__decap_3
X_6102_ _2903_ _2912_ VGND VGND VPWR VPWR _2913_ sky130_fd_sc_hd__nor2_1
X_7082_ clknet_leaf_14_clk _0155_ net816 VGND VGND VPWR VPWR u_pe_array.g_pe_row\[2\].g_pe_col\[1\].u_pe.act_val\[4\]
+ sky130_fd_sc_hd__dfrtp_2
XTAP_321 VGND VPWR sky130_fd_sc_hd__tapvpwrvgnd_1
XTAP_332 VGND VPWR sky130_fd_sc_hd__tapvpwrvgnd_1
XTAP_310 VGND VPWR sky130_fd_sc_hd__tapvpwrvgnd_1
X_4294_ net342 _1392_ _1403_ _1399_ VGND VGND VPWR VPWR _0134_ sky130_fd_sc_hd__a22o_1
X_6033_ net780 _2738_ _2592_ _2858_ VGND VGND VPWR VPWR _0418_ sky130_fd_sc_hd__a22o_1
XTAP_376 VGND VPWR sky130_fd_sc_hd__tapvpwrvgnd_1
XTAP_365 VGND VPWR sky130_fd_sc_hd__tapvpwrvgnd_1
XTAP_354 VGND VPWR sky130_fd_sc_hd__tapvpwrvgnd_1
XTAP_343 VGND VPWR sky130_fd_sc_hd__tapvpwrvgnd_1
XANTENNA__5826__A1 _2611_ VGND VGND VPWR VPWR sky130_fd_sc_hd__diode_2
XTAP_387 VGND VPWR sky130_fd_sc_hd__tapvpwrvgnd_1
XTAP_398 VGND VPWR sky130_fd_sc_hd__tapvpwrvgnd_1
XFILLER_0_83_41 VGND VGND VPWR VPWR sky130_fd_sc_hd__fill_2
XFILLER_0_13_3 VGND VGND VPWR VPWR sky130_fd_sc_hd__decap_3
XTAP_1509 VGND VPWR sky130_fd_sc_hd__tapvpwrvgnd_1
XFILLER_0_95_107 VGND VGND VPWR VPWR sky130_fd_sc_hd__fill_2
XANTENNA__7332__RESET_B net812 VGND VGND VPWR VPWR sky130_fd_sc_hd__diode_2
XFILLER_0_88_170 VGND VGND VPWR VPWR sky130_fd_sc_hd__fill_2
XFILLER_0_49_524 VGND VGND VPWR VPWR sky130_fd_sc_hd__fill_2
XFILLER_0_49_502 VGND VGND VPWR VPWR sky130_fd_sc_hd__fill_2
X_6935_ clknet_leaf_83_clk _0018_ net74 VGND VGND VPWR VPWR u_pe_array.g_pe_row\[3\].g_pe_col\[2\].u_pe.move_reg\[7\]
+ sky130_fd_sc_hd__dfrtp_1
XPHY_16 VGND VGND VPWR VPWR sky130_fd_sc_hd__decap_3
XPHY_27 VGND VGND VPWR VPWR sky130_fd_sc_hd__decap_3
XPHY_38 VGND VGND VPWR VPWR sky130_fd_sc_hd__decap_3
XANTENNA__5876__S _0770_ VGND VGND VPWR VPWR sky130_fd_sc_hd__diode_2
XFILLER_0_76_321 VGND VGND VPWR VPWR sky130_fd_sc_hd__decap_8
XFILLER_0_49_557 VGND VGND VPWR VPWR sky130_fd_sc_hd__decap_3
XFILLER_0_49_535 VGND VGND VPWR VPWR sky130_fd_sc_hd__fill_2
XPHY_49 VGND VGND VPWR VPWR sky130_fd_sc_hd__decap_3
XFILLER_0_91_302 VGND VGND VPWR VPWR sky130_fd_sc_hd__decap_4
X_6866_ net468 _3116_ _3412_ VGND VGND VPWR VPWR _3416_ sky130_fd_sc_hd__mux2_1
XFILLER_0_76_365 VGND VGND VPWR VPWR sky130_fd_sc_hd__decap_4
XFILLER_0_64_527 VGND VGND VPWR VPWR sky130_fd_sc_hd__decap_4
Xclkbuf_leaf_61_clk clknet_3_4__leaf_clk VGND VGND VPWR VPWR clknet_leaf_61_clk sky130_fd_sc_hd__clkbuf_16
X_6797_ net212 _3132_ _3366_ VGND VGND VPWR VPWR _3378_ sky130_fd_sc_hd__mux2_1
XFILLER_0_76_398 VGND VGND VPWR VPWR sky130_fd_sc_hd__fill_2
XANTENNA__4014__B1 _1144_ VGND VGND VPWR VPWR sky130_fd_sc_hd__diode_2
XFILLER_0_9_665 VGND VGND VPWR VPWR sky130_fd_sc_hd__decap_6
XFILLER_0_8_153 VGND VGND VPWR VPWR sky130_fd_sc_hd__decap_8
XFILLER_0_29_270 VGND VGND VPWR VPWR sky130_fd_sc_hd__decap_3
XFILLER_0_29_281 VGND VGND VPWR VPWR sky130_fd_sc_hd__fill_2
X_5817_ _2258_ _2679_ _2680_ _2571_ u_pe_array.g_pe_row\[0\].g_pe_col\[3\].u_pe.psum_out\[7\]
+ VGND VGND VPWR VPWR _0380_ sky130_fd_sc_hd__a32o_1
XFILLER_0_107_629 VPWR VGND VPWR VGND sky130_ef_sc_hd__decap_12
XFILLER_0_8_197 VGND VGND VPWR VPWR sky130_fd_sc_hd__decap_8
X_5748_ _2608_ _2613_ VGND VGND VPWR VPWR _2617_ sky130_fd_sc_hd__and2_1
X_5679_ _2560_ _2563_ _2568_ VGND VGND VPWR VPWR _2569_ sky130_fd_sc_hd__o21ai_1
XANTENNA__6500__S _3208_ VGND VGND VPWR VPWR sky130_fd_sc_hd__diode_2
XANTENNA_clkbuf_3_5__f_clk_A clknet_0_clk VGND VGND VPWR VPWR sky130_fd_sc_hd__diode_2
XFILLER_0_32_435 VGND VGND VPWR VPWR sky130_fd_sc_hd__fill_2
X_7418_ clknet_leaf_30_clk _0467_ VGND VGND VPWR VPWR u_pe_array.u_fifo1.buffer\[8\]\[8\]
+ sky130_fd_sc_hd__dfxtp_1
XFILLER_0_4_392 VGND VGND VPWR VPWR sky130_fd_sc_hd__fill_2
Xhold550 u_pe_array.g_pe_row\[3\].g_pe_col\[0\].u_pe.act_val\[1\] VGND VGND VPWR VPWR
+ net626 sky130_fd_sc_hd__dlygate4sd3_1
Xhold572 u_pe_array.g_pe_row\[1\].g_pe_col\[2\].u_pe.psum_out\[3\] VGND VGND VPWR
+ VPWR net648 sky130_fd_sc_hd__dlygate4sd3_1
X_7349_ clknet_leaf_62_clk _0404_ net818 VGND VGND VPWR VPWR u_pe_array.g_pe_row\[0\].g_pe_col\[2\].u_pe.psum_out\[3\]
+ sky130_fd_sc_hd__dfrtp_1
Xhold561 u_pe_array.g_pe_row\[3\].g_pe_col\[2\].u_pe.psum_out\[2\] VGND VGND VPWR
+ VPWR net637 sky130_fd_sc_hd__dlygate4sd3_1
Xhold583 u_pe_array.g_pe_row\[3\].g_pe_col\[0\].u_pe.psum_out\[5\] VGND VGND VPWR
+ VPWR net659 sky130_fd_sc_hd__dlygate4sd3_1
XFILLER_0_4_6 VGND VGND VPWR VPWR sky130_fd_sc_hd__fill_2
Xhold594 u_pe_array.g_pe_row\[2\].g_pe_col\[2\].u_pe.psum_out\[10\] VGND VGND VPWR
+ VPWR net670 sky130_fd_sc_hd__dlygate4sd3_1
XANTENNA__5817__A1 _2258_ VGND VGND VPWR VPWR sky130_fd_sc_hd__diode_2
XANTENNA__6242__A1 _2740_ VGND VGND VPWR VPWR sky130_fd_sc_hd__diode_2
XANTENNA__7073__RESET_B net74 VGND VGND VPWR VPWR sky130_fd_sc_hd__diode_2
XFILLER_0_95_652 VGND VGND VPWR VPWR sky130_fd_sc_hd__fill_2
XANTENNA__7002__RESET_B net813 VGND VGND VPWR VPWR sky130_fd_sc_hd__diode_2
Xclkbuf_leaf_52_clk clknet_3_7__leaf_clk VGND VGND VPWR VPWR clknet_leaf_52_clk sky130_fd_sc_hd__clkbuf_16
XFILLER_0_55_505 VGND VGND VPWR VPWR sky130_fd_sc_hd__fill_1
XFILLER_0_103_39 VPWR VGND VPWR VGND sky130_ef_sc_hd__decap_12
XFILLER_0_55_538 VGND VGND VPWR VPWR sky130_fd_sc_hd__decap_3
XFILLER_0_12_15 VGND VGND VPWR VPWR sky130_fd_sc_hd__decap_8
XFILLER_0_82_379 VGND VGND VPWR VPWR sky130_fd_sc_hd__decap_6
XFILLER_0_23_446 VGND VGND VPWR VPWR sky130_fd_sc_hd__fill_2
XFILLER_0_23_457 VGND VGND VPWR VPWR sky130_fd_sc_hd__fill_2
XFILLER_0_105_172 VGND VGND VPWR VPWR sky130_fd_sc_hd__decap_4
XANTENNA__3516__C1 _0754_ VGND VGND VPWR VPWR sky130_fd_sc_hd__diode_2
XANTENNA__6481__A1 _1816_ VGND VGND VPWR VPWR sky130_fd_sc_hd__diode_2
XANTENNA__4166__A u_pe_array.g_pe_row\[3\].g_pe_col\[0\].u_pe.w_reg\[0\] VGND VGND
+ VPWR VPWR sky130_fd_sc_hd__diode_2
XANTENNA__5070__B_N _2029_ VGND VGND VPWR VPWR sky130_fd_sc_hd__diode_2
XFILLER_0_77_129 VGND VGND VPWR VPWR sky130_fd_sc_hd__fill_2
XFILLER_0_53_55 VGND VGND VPWR VPWR sky130_fd_sc_hd__fill_1
X_4981_ u_pe_array.u_fifo2.buffer\[8\]\[0\] _1960_ _1963_ _1976_ _0819_ VGND VGND
+ VPWR VPWR _1977_ sky130_fd_sc_hd__a221o_1
Xclkbuf_leaf_43_clk clknet_3_6__leaf_clk VGND VGND VPWR VPWR clknet_leaf_43_clk sky130_fd_sc_hd__clkbuf_16
XFILLER_0_86_674 VGND VGND VPWR VPWR sky130_fd_sc_hd__decap_3
X_6720_ u_pe_array.u_fifo1.wr_ptr\[1\] _3323_ _3106_ VGND VGND VPWR VPWR _3338_ sky130_fd_sc_hd__nor3b_1
X_3932_ _1111_ _1112_ VGND VGND VPWR VPWR _1113_ sky130_fd_sc_hd__or2_1
XFILLER_0_85_173 VGND VGND VPWR VPWR sky130_fd_sc_hd__decap_3
X_3863_ _1049_ _1050_ VGND VGND VPWR VPWR _1051_ sky130_fd_sc_hd__nand2_1
XANTENNA_clkbuf_leaf_9_clk_A clknet_3_0__leaf_clk VGND VGND VPWR VPWR sky130_fd_sc_hd__diode_2
X_6651_ net624 _0833_ VGND VGND VPWR VPWR _3295_ sky130_fd_sc_hd__and2_1
XANTENNA__4105__S _0828_ VGND VGND VPWR VPWR sky130_fd_sc_hd__diode_2
X_5602_ u_pe_array.g_pe_row\[1\].g_pe_col\[0\].u_pe.act_val\[3\] u_pe_array.g_pe_row\[1\].g_pe_col\[0\].u_pe.w_reg\[0\]
+ VGND VGND VPWR VPWR _2498_ sky130_fd_sc_hd__nand2_1
XFILLER_0_6_613 VPWR VGND VPWR VGND sky130_ef_sc_hd__decap_12
X_6582_ _3259_ VGND VGND VPWR VPWR _0566_ sky130_fd_sc_hd__clkbuf_1
X_5533_ _2345_ u_pe_array.g_pe_row\[1\].g_pe_col\[1\].u_pe.psum_out\[11\] VGND VGND
+ VPWR VPWR _2449_ sky130_fd_sc_hd__and2b_1
X_3794_ _0741_ _0994_ _0754_ VGND VGND VPWR VPWR _0995_ sky130_fd_sc_hd__mux2_1
XFILLER_0_6_657 VPWR VGND VPWR VGND sky130_ef_sc_hd__decap_12
XFILLER_0_14_413 VGND VGND VPWR VPWR sky130_fd_sc_hd__fill_1
XFILLER_0_26_251 VGND VGND VPWR VPWR sky130_fd_sc_hd__fill_1
XFILLER_0_103_109 VGND VGND VPWR VPWR sky130_fd_sc_hd__decap_3
XFILLER_0_5_167 VGND VGND VPWR VPWR sky130_fd_sc_hd__fill_1
XFILLER_0_112_643 VGND VGND VPWR VPWR sky130_fd_sc_hd__fill_1
X_5464_ _2385_ _2386_ net751 _0875_ VGND VGND VPWR VPWR _0321_ sky130_fd_sc_hd__a2bb2o_1
X_5395_ u_pe_array.u_fifo1.buffer\[8\]\[5\] _2273_ _2325_ _2329_ _0819_ VGND VGND
+ VPWR VPWR _2330_ sky130_fd_sc_hd__a221o_2
XFILLER_0_78_85 VGND VGND VPWR VPWR sky130_fd_sc_hd__fill_2
X_7203_ clknet_leaf_73_clk _0268_ net815 VGND VGND VPWR VPWR u_pe_array.g_pe_row\[1\].g_pe_col\[3\].u_pe.psum_out\[7\]
+ sky130_fd_sc_hd__dfrtp_4
X_4415_ u_pe_array.g_pe_row\[2\].g_pe_col\[3\].u_pe.psum_out\[9\] u_pe_array.g_pe_row\[2\].g_pe_col\[3\].u_pe.psum_out\[10\]
+ _1407_ VGND VGND VPWR VPWR _1511_ sky130_fd_sc_hd__o21a_1
XANTENNA__3522__A2 _0769_ VGND VGND VPWR VPWR sky130_fd_sc_hd__diode_2
X_7134_ clknet_leaf_37_clk _0203_ net76 VGND VGND VPWR VPWR u_pe_array.g_pe_row\[2\].g_pe_col\[1\].u_pe.psum_out\[11\]
+ sky130_fd_sc_hd__dfrtp_1
X_4346_ u_pe_array.g_pe_row\[2\].g_pe_col\[3\].u_pe.w_reg\[0\] u_pe_array.g_pe_row\[2\].g_pe_col\[3\].u_pe.act_val\[5\]
+ VGND VGND VPWR VPWR _1449_ sky130_fd_sc_hd__nand2_1
XFILLER_0_1_373 VGND VGND VPWR VPWR sky130_fd_sc_hd__decap_8
X_7065_ clknet_leaf_91_clk _0138_ net819 VGND VGND VPWR VPWR u_pe_array.g_pe_row\[2\].g_pe_col\[3\].u_pe.psum_out\[2\]
+ sky130_fd_sc_hd__dfrtp_2
X_4277_ net765 _1392_ _1258_ _1394_ VGND VGND VPWR VPWR _0126_ sky130_fd_sc_hd__a22o_1
X_6016_ u_pe_array.g_pe_row\[0\].g_pe_col\[2\].u_pe.psum_out\[11\] _2847_ _2838_ VGND
+ VGND VPWR VPWR _2848_ sky130_fd_sc_hd__mux2_1
XFILLER_0_96_449 VGND VGND VPWR VPWR sky130_fd_sc_hd__fill_1
XTAP_1339 VGND VPWR sky130_fd_sc_hd__tapvpwrvgnd_1
XTAP_1328 VGND VPWR sky130_fd_sc_hd__tapvpwrvgnd_1
XTAP_1317 VGND VPWR sky130_fd_sc_hd__tapvpwrvgnd_1
XTAP_1306 VGND VPWR sky130_fd_sc_hd__tapvpwrvgnd_1
Xclkbuf_leaf_34_clk clknet_3_3__leaf_clk VGND VGND VPWR VPWR clknet_leaf_34_clk sky130_fd_sc_hd__clkbuf_16
X_6918_ clknet_leaf_61_clk _0004_ net73 VGND VGND VPWR VPWR u_fsm.h_cnt\[0\] sky130_fd_sc_hd__dfrtp_1
XFILLER_0_49_376 VGND VGND VPWR VPWR sky130_fd_sc_hd__fill_2
X_6849_ _3406_ VGND VGND VPWR VPWR _0686_ sky130_fd_sc_hd__clkbuf_1
XFILLER_0_64_324 VGND VGND VPWR VPWR sky130_fd_sc_hd__decap_4
XFILLER_0_60_530 VGND VGND VPWR VPWR sky130_fd_sc_hd__fill_2
XFILLER_0_20_416 VGND VGND VPWR VPWR sky130_fd_sc_hd__fill_2
XFILLER_0_103_665 VGND VGND VPWR VPWR sky130_fd_sc_hd__decap_6
Xhold380 u_pe_array.g_pe_row\[0\].g_pe_col\[0\].u_pe.psum_out\[12\] VGND VGND VPWR
+ VPWR net456 sky130_fd_sc_hd__dlygate4sd3_1
XFILLER_0_2_3 VPWR VGND VPWR VGND sky130_ef_sc_hd__decap_12
Xhold391 u_pe_array.u_fifo2.buffer\[1\]\[3\] VGND VGND VPWR VPWR net467 sky130_fd_sc_hd__dlygate4sd3_1
XANTENNA__5370__A _1787_ VGND VGND VPWR VPWR sky130_fd_sc_hd__diode_2
XANTENNA__7254__RESET_B net813 VGND VGND VPWR VPWR sky130_fd_sc_hd__diode_2
Xclkbuf_leaf_25_clk clknet_3_2__leaf_clk VGND VGND VPWR VPWR clknet_leaf_25_clk sky130_fd_sc_hd__clkbuf_16
XFILLER_0_55_324 VGND VGND VPWR VPWR sky130_fd_sc_hd__fill_2
XFILLER_0_70_327 VGND VGND VPWR VPWR sky130_fd_sc_hd__decap_8
XFILLER_0_113_429 VPWR VGND VPWR VGND sky130_ef_sc_hd__decap_12
XFILLER_0_11_449 VGND VGND VPWR VPWR sky130_fd_sc_hd__fill_2
X_4200_ _1275_ _1329_ u_pe_array.g_pe_row\[3\].g_pe_col\[0\].u_pe.psum_out\[6\] VGND
+ VGND VPWR VPWR _1330_ sky130_fd_sc_hd__and3_1
X_5180_ _0832_ VGND VGND VPWR VPWR _2144_ sky130_fd_sc_hd__clkbuf_8
XANTENNA__4595__S _0770_ VGND VGND VPWR VPWR sky130_fd_sc_hd__diode_2
XFILLER_0_47_9 VGND VGND VPWR VPWR sky130_fd_sc_hd__decap_3
X_4131_ net170 _1138_ _1268_ _1004_ VGND VGND VPWR VPWR _0106_ sky130_fd_sc_hd__a22o_1
XANTENNA__6095__B _2873_ VGND VGND VPWR VPWR sky130_fd_sc_hd__diode_2
X_4062_ _1180_ _1182_ _1192_ VGND VGND VPWR VPWR _1218_ sky130_fd_sc_hd__a21oi_1
XANTENNA__6454__A1 _1816_ VGND VGND VPWR VPWR sky130_fd_sc_hd__diode_2
XFILLER_0_3_57 VPWR VGND VPWR VGND sky130_ef_sc_hd__decap_12
XFILLER_0_78_416 VGND VGND VPWR VPWR sky130_fd_sc_hd__fill_2
XFILLER_0_78_405 VGND VGND VPWR VPWR sky130_fd_sc_hd__decap_3
XFILLER_0_64_65 VPWR VGND VPWR VGND sky130_ef_sc_hd__decap_12
Xwire69 _3180_ VGND VGND VPWR VPWR net69 sky130_fd_sc_hd__buf_2
XANTENNA__6977__RESET_B net819 VGND VGND VPWR VPWR sky130_fd_sc_hd__diode_2
Xclkbuf_leaf_16_clk clknet_3_2__leaf_clk VGND VGND VPWR VPWR clknet_leaf_16_clk sky130_fd_sc_hd__clkbuf_16
XFILLER_0_19_505 VGND VGND VPWR VPWR sky130_fd_sc_hd__decap_4
X_4964_ _1958_ _1959_ VGND VGND VPWR VPWR _1960_ sky130_fd_sc_hd__nor2_4
X_6703_ _3329_ VGND VGND VPWR VPWR _0617_ sky130_fd_sc_hd__clkbuf_1
XFILLER_0_46_313 VGND VGND VPWR VPWR sky130_fd_sc_hd__fill_1
X_3915_ u_pe_array.g_pe_row\[3\].g_pe_col\[2\].u_pe.psum_out\[8\] u_pe_array.g_pe_row\[3\].g_pe_col\[2\].u_pe.psum_out\[9\]
+ _1009_ VGND VGND VPWR VPWR _1098_ sky130_fd_sc_hd__and3_1
X_4895_ _1899_ u_pe_array.g_pe_row\[2\].g_pe_col\[0\].u_pe.psum_out\[6\] _1847_ VGND
+ VGND VPWR VPWR _1900_ sky130_fd_sc_hd__and3_1
XFILLER_0_6_443 VGND VGND VPWR VPWR sky130_fd_sc_hd__decap_3
X_3846_ _1027_ _1028_ _1034_ VGND VGND VPWR VPWR _1035_ sky130_fd_sc_hd__nor3_1
X_6634_ net770 _2738_ _0836_ _3286_ VGND VGND VPWR VPWR _0591_ sky130_fd_sc_hd__a22o_1
XFILLER_0_80_3 VPWR VGND VPWR VGND sky130_ef_sc_hd__decap_12
XFILLER_0_14_210 VGND VGND VPWR VPWR sky130_fd_sc_hd__fill_1
X_6565_ net346 _1816_ _3239_ VGND VGND VPWR VPWR _3250_ sky130_fd_sc_hd__mux2_1
X_3777_ u_pe_array.g_pe_row\[2\].g_pe_col\[2\].u_pe.w_buffer\[0\] net83 _0828_ VGND
+ VGND VPWR VPWR _0984_ sky130_fd_sc_hd__mux2_1
X_5516_ _2425_ _2428_ _2433_ VGND VGND VPWR VPWR _2434_ sky130_fd_sc_hd__o21ai_1
XANTENNA__5455__A u_pe_array.g_pe_row\[1\].g_pe_col\[1\].u_pe.w_reg\[0\] VGND VGND
+ VPWR VPWR sky130_fd_sc_hd__diode_2
XANTENNA__6050__S _2469_ VGND VGND VPWR VPWR sky130_fd_sc_hd__diode_2
X_6496_ net528 _1804_ _3208_ VGND VGND VPWR VPWR _3213_ sky130_fd_sc_hd__mux2_1
X_5447_ _2368_ _2370_ VGND VGND VPWR VPWR _2371_ sky130_fd_sc_hd__nor2_1
XFILLER_0_100_657 VPWR VGND VPWR VGND sky130_ef_sc_hd__decap_12
X_5378_ u_pe_array.g_pe_row\[0\].g_pe_col\[0\].u_pe.act_val\[3\] u_pe_array.g_pe_row\[0\].g_pe_col\[0\].u_pe.psum_out\[3\]
+ _0755_ VGND VGND VPWR VPWR _2315_ sky130_fd_sc_hd__mux2_1
XFILLER_0_1_181 VPWR VGND VPWR VGND sky130_ef_sc_hd__decap_12
X_7117_ clknet_leaf_37_clk _0188_ net816 VGND VGND VPWR VPWR u_pe_array.g_pe_row\[2\].g_pe_col\[0\].u_pe.move_reg\[9\]
+ sky130_fd_sc_hd__dfrtp_1
X_4329_ _1424_ _1431_ _1433_ VGND VGND VPWR VPWR _1434_ sky130_fd_sc_hd__or3_1
X_7048_ clknet_leaf_90_clk _0123_ net819 VGND VGND VPWR VPWR u_pe_array.g_pe_row\[2\].g_pe_col\[2\].u_pe.act_val\[0\]
+ sky130_fd_sc_hd__dfrtp_2
XTAP_1114 VGND VPWR sky130_fd_sc_hd__tapvpwrvgnd_1
XTAP_1103 VGND VPWR sky130_fd_sc_hd__tapvpwrvgnd_1
XTAP_1147 VGND VPWR sky130_fd_sc_hd__tapvpwrvgnd_1
XTAP_1136 VGND VPWR sky130_fd_sc_hd__tapvpwrvgnd_1
XTAP_1125 VGND VPWR sky130_fd_sc_hd__tapvpwrvgnd_1
XFILLER_0_77_482 VPWR VGND VPWR VGND sky130_ef_sc_hd__decap_12
XTAP_1169 VGND VPWR sky130_fd_sc_hd__tapvpwrvgnd_1
XTAP_1158 VGND VPWR sky130_fd_sc_hd__tapvpwrvgnd_1
XFILLER_0_45_390 VGND VGND VPWR VPWR sky130_fd_sc_hd__fill_2
XFILLER_0_107_289 VGND VGND VPWR VPWR sky130_fd_sc_hd__decap_3
XFILLER_0_100_29 VGND VGND VPWR VPWR sky130_fd_sc_hd__decap_6
XFILLER_0_60_371 VGND VGND VPWR VPWR sky130_fd_sc_hd__fill_2
XFILLER_0_20_246 VGND VGND VPWR VPWR sky130_fd_sc_hd__decap_4
XFILLER_0_103_495 VGND VGND VPWR VPWR sky130_fd_sc_hd__decap_6
XTAP_909 VGND VPWR sky130_fd_sc_hd__tapvpwrvgnd_1
XFILLER_0_109_49 VGND VGND VPWR VPWR sky130_fd_sc_hd__decap_6
XFILLER_0_87_213 VGND VGND VPWR VPWR sky130_fd_sc_hd__fill_2
XANTENNA__6643__B _0833_ VGND VGND VPWR VPWR sky130_fd_sc_hd__diode_2
XANTENNA__5411__A2 _2144_ VGND VGND VPWR VPWR sky130_fd_sc_hd__diode_2
XFILLER_0_68_493 VGND VGND VPWR VPWR sky130_fd_sc_hd__decap_3
XFILLER_0_56_622 VGND VGND VPWR VPWR sky130_fd_sc_hd__fill_2
XFILLER_0_28_324 VGND VGND VPWR VPWR sky130_fd_sc_hd__decap_8
XANTENNA__6081__D _2873_ VGND VGND VPWR VPWR sky130_fd_sc_hd__diode_2
X_3700_ _0866_ VGND VGND VPWR VPWR _0916_ sky130_fd_sc_hd__buf_8
XFILLER_0_83_441 VGND VGND VPWR VPWR sky130_fd_sc_hd__fill_2
XFILLER_0_55_121 VGND VGND VPWR VPWR sky130_fd_sc_hd__decap_3
XANTENNA__3973__A2 _1138_ VGND VGND VPWR VPWR sky130_fd_sc_hd__diode_2
XFILLER_0_71_625 VGND VGND VPWR VPWR sky130_fd_sc_hd__fill_2
X_4680_ u_pe_array.g_pe_row\[2\].g_pe_col\[1\].u_pe.w_reg\[0\] u_pe_array.g_pe_row\[2\].g_pe_col\[1\].u_pe.act_val\[5\]
+ _1715_ VGND VGND VPWR VPWR _1726_ sky130_fd_sc_hd__and3_1
X_3631_ u_pe_array.g_pe_row\[2\].g_pe_col\[2\].u_pe.psum_out\[10\] u_pe_array.g_pe_row\[2\].g_pe_col\[2\].u_pe.move_reg\[10\]
+ _0734_ VGND VGND VPWR VPWR _0854_ sky130_fd_sc_hd__mux2_1
XFILLER_0_113_237 VPWR VGND VPWR VGND sky130_ef_sc_hd__decap_12
X_6350_ _3126_ net318 _3110_ VGND VGND VPWR VPWR _3127_ sky130_fd_sc_hd__mux2_1
XFILLER_0_70_168 VGND VGND VPWR VPWR sky130_fd_sc_hd__fill_2
X_3562_ _0806_ VGND VGND VPWR VPWR u_fsm.next_state\[1\] sky130_fd_sc_hd__buf_1
X_5301_ _2238_ _2240_ _2246_ VGND VGND VPWR VPWR _2247_ sky130_fd_sc_hd__o21ai_1
XFILLER_0_51_360 VGND VGND VPWR VPWR sky130_fd_sc_hd__decap_3
X_6281_ u_pe_array.g_pe_row\[0\].g_pe_col\[0\].u_pe.psum_out\[8\] _2992_ VGND VGND
+ VPWR VPWR _3071_ sky130_fd_sc_hd__nand2_1
XANTENNA__7176__RESET_B net813 VGND VGND VPWR VPWR sky130_fd_sc_hd__diode_2
X_3493_ _0730_ VGND VGND VPWR VPWR _0755_ sky130_fd_sc_hd__buf_12
XANTENNA__6675__B2 _2273_ VGND VGND VPWR VPWR sky130_fd_sc_hd__diode_2
X_5232_ u_pe_array.g_pe_row\[1\].g_pe_col\[2\].u_pe.psum_out\[2\] _2169_ _2183_ VGND
+ VGND VPWR VPWR _2184_ sky130_fd_sc_hd__a21oi_1
Xclkbuf_leaf_5_clk clknet_3_0__leaf_clk VGND VGND VPWR VPWR clknet_leaf_5_clk sky130_fd_sc_hd__clkbuf_16
XFILLER_0_11_268 VGND VGND VPWR VPWR sky130_fd_sc_hd__decap_4
X_5163_ u_pe_array.g_pe_row\[1\].g_pe_col\[3\].u_pe.psum_out\[9\] u_pe_array.g_pe_row\[1\].g_pe_col\[3\].u_pe.psum_out\[10\]
+ _2029_ VGND VGND VPWR VPWR _2134_ sky130_fd_sc_hd__o21a_1
XANTENNA__7105__RESET_B net74 VGND VGND VPWR VPWR sky130_fd_sc_hd__diode_2
XANTENNA__5441__C u_pe_array.g_pe_row\[1\].g_pe_col\[1\].u_pe.w_reg\[0\] VGND VGND
+ VPWR VPWR sky130_fd_sc_hd__diode_2
XFILLER_0_75_31 VGND VGND VPWR VPWR sky130_fd_sc_hd__decap_4
X_4114_ u_pe_array.g_pe_row\[3\].g_pe_col\[3\].u_pe.psum_out\[3\] u_pe_array.g_pe_row\[3\].g_pe_col\[3\].u_pe.act_val\[3\]
+ _0769_ VGND VGND VPWR VPWR _1260_ sky130_fd_sc_hd__mux2_1
XANTENNA__6427__A1 _1816_ VGND VGND VPWR VPWR sky130_fd_sc_hd__diode_2
X_5094_ u_pe_array.g_pe_row\[1\].g_pe_col\[3\].u_pe.w_reg\[0\] u_pe_array.g_pe_row\[1\].g_pe_col\[3\].u_pe.act_val\[5\]
+ VGND VGND VPWR VPWR _2072_ sky130_fd_sc_hd__nand2_1
X_4045_ _1201_ _1202_ VGND VGND VPWR VPWR _1203_ sky130_fd_sc_hd__nand2_1
XFILLER_0_78_213 VGND VGND VPWR VPWR sky130_fd_sc_hd__fill_2
XPHY_219 VGND VGND VPWR VPWR sky130_fd_sc_hd__decap_3
XPHY_208 VGND VGND VPWR VPWR sky130_fd_sc_hd__decap_3
XANTENNA__5402__A2 _2144_ VGND VGND VPWR VPWR sky130_fd_sc_hd__diode_2
X_5996_ u_pe_array.g_pe_row\[0\].g_pe_col\[2\].u_pe.psum_out\[9\] _2743_ VGND VGND
+ VPWR VPWR _2830_ sky130_fd_sc_hd__nand2_1
XFILLER_0_47_611 VGND VGND VPWR VPWR sky130_fd_sc_hd__fill_2
X_4947_ _1847_ u_pe_array.g_pe_row\[2\].g_pe_col\[0\].u_pe.psum_out\[11\] VGND VGND
+ VPWR VPWR _1947_ sky130_fd_sc_hd__and2b_1
XANTENNA__5884__S _2469_ VGND VGND VPWR VPWR sky130_fd_sc_hd__diode_2
XANTENNA__3964__A2 _0996_ VGND VGND VPWR VPWR sky130_fd_sc_hd__diode_2
X_4878_ _1881_ _1882_ _1883_ VGND VGND VPWR VPWR _1885_ sky130_fd_sc_hd__a21oi_1
X_7666_ clknet_leaf_19_clk _0715_ VGND VGND VPWR VPWR u_pe_array.u_fifo1.buffer\[7\]\[11\]
+ sky130_fd_sc_hd__dfxtp_1
XFILLER_0_19_368 VGND VGND VPWR VPWR sky130_fd_sc_hd__fill_2
XFILLER_0_61_113 VGND VGND VPWR VPWR sky130_fd_sc_hd__decap_8
X_6617_ net309 _1812_ _3269_ VGND VGND VPWR VPWR _3278_ sky130_fd_sc_hd__mux2_1
XFILLER_0_6_251 VGND VGND VPWR VPWR sky130_fd_sc_hd__fill_1
X_3829_ _1016_ _1018_ VGND VGND VPWR VPWR _1019_ sky130_fd_sc_hd__xnor2_1
X_7597_ clknet_leaf_24_clk _0646_ VGND VGND VPWR VPWR u_pe_array.u_fifo1.buffer\[2\]\[7\]
+ sky130_fd_sc_hd__dfxtp_1
XANTENNA__5616__C _2478_ VGND VGND VPWR VPWR sky130_fd_sc_hd__diode_2
X_6548_ _3241_ VGND VGND VPWR VPWR _0550_ sky130_fd_sc_hd__clkbuf_1
XANTENNA_clkbuf_leaf_81_clk_A clknet_3_4__leaf_clk VGND VGND VPWR VPWR sky130_fd_sc_hd__diode_2
X_6479_ net353 _1814_ net67 VGND VGND VPWR VPWR _3204_ sky130_fd_sc_hd__mux2_1
XFILLER_0_30_533 VGND VGND VPWR VPWR sky130_fd_sc_hd__fill_2
XANTENNA__4677__B1 _0885_ VGND VGND VPWR VPWR sky130_fd_sc_hd__diode_2
XANTENNA__4529__A _1536_ VGND VGND VPWR VPWR sky130_fd_sc_hd__diode_2
XANTENNA__4429__B1 _1258_ VGND VGND VPWR VPWR sky130_fd_sc_hd__diode_2
XANTENNA__5641__A2 _2478_ VGND VGND VPWR VPWR sky130_fd_sc_hd__diode_2
XFILLER_0_97_555 VGND VGND VPWR VPWR sky130_fd_sc_hd__decap_3
XANTENNA_clkbuf_leaf_34_clk_A clknet_3_3__leaf_clk VGND VGND VPWR VPWR sky130_fd_sc_hd__diode_2
XFILLER_0_38_633 VGND VGND VPWR VPWR sky130_fd_sc_hd__fill_2
XFILLER_0_111_39 VPWR VGND VPWR VGND sky130_ef_sc_hd__decap_12
XFILLER_0_108_587 VGND VGND VPWR VPWR sky130_fd_sc_hd__fill_1
XANTENNA_clkbuf_leaf_49_clk_A clknet_3_7__leaf_clk VGND VGND VPWR VPWR sky130_fd_sc_hd__diode_2
XFILLER_0_80_477 VGND VGND VPWR VPWR sky130_fd_sc_hd__fill_2
XFILLER_0_52_168 VGND VGND VPWR VPWR sky130_fd_sc_hd__decap_3
XFILLER_0_60_190 VGND VGND VPWR VPWR sky130_fd_sc_hd__decap_6
XFILLER_0_0_449 VPWR VGND VPWR VGND sky130_ef_sc_hd__decap_12
XTAP_706 VGND VPWR sky130_fd_sc_hd__tapvpwrvgnd_1
XFILLER_0_29_57 VGND VGND VPWR VPWR sky130_fd_sc_hd__decap_6
XTAP_728 VGND VPWR sky130_fd_sc_hd__tapvpwrvgnd_1
XTAP_717 VGND VPWR sky130_fd_sc_hd__tapvpwrvgnd_1
XTAP_739 VGND VPWR sky130_fd_sc_hd__tapvpwrvgnd_1
XANTENNA__5034__S _1661_ VGND VGND VPWR VPWR sky130_fd_sc_hd__diode_2
XANTENNA__5093__B1 _2071_ VGND VGND VPWR VPWR sky130_fd_sc_hd__diode_2
XFILLER_0_88_533 VGND VGND VPWR VPWR sky130_fd_sc_hd__fill_2
XFILLER_0_45_89 VGND VGND VPWR VPWR sky130_fd_sc_hd__fill_1
XFILLER_0_29_611 VGND VGND VPWR VPWR sky130_fd_sc_hd__decap_4
XFILLER_0_29_622 VGND VGND VPWR VPWR sky130_fd_sc_hd__fill_2
X_5850_ _2702_ _2704_ _2710_ VGND VGND VPWR VPWR _2711_ sky130_fd_sc_hd__and3_1
XFILLER_0_61_55 VGND VGND VPWR VPWR sky130_fd_sc_hd__fill_1
X_4801_ _1824_ net1 _0754_ VGND VGND VPWR VPWR _1825_ sky130_fd_sc_hd__mux2_1
XFILLER_0_0_69 VGND VGND VPWR VPWR sky130_fd_sc_hd__fill_2
XFILLER_0_28_121 VGND VGND VPWR VPWR sky130_fd_sc_hd__decap_3
X_5781_ _2645_ _2646_ _2647_ VGND VGND VPWR VPWR _2648_ sky130_fd_sc_hd__and3_1
XFILLER_0_90_208 VGND VGND VPWR VPWR sky130_fd_sc_hd__decap_4
X_4732_ _1765_ _1767_ _1773_ VGND VGND VPWR VPWR _1774_ sky130_fd_sc_hd__and3_1
XFILLER_0_56_474 VGND VGND VPWR VPWR sky130_fd_sc_hd__fill_2
X_7520_ clknet_leaf_7_clk _0569_ VGND VGND VPWR VPWR u_pe_array.u_fifo2.buffer\[6\]\[7\]
+ sky130_fd_sc_hd__dfxtp_1
XFILLER_0_71_411 VGND VGND VPWR VPWR sky130_fd_sc_hd__decap_8
X_4663_ _1709_ _1710_ VGND VGND VPWR VPWR _1711_ sky130_fd_sc_hd__or2_1
XFILLER_0_44_636 VGND VGND VPWR VPWR sky130_fd_sc_hd__fill_2
XFILLER_0_43_113 VGND VGND VPWR VPWR sky130_fd_sc_hd__fill_1
X_7451_ clknet_leaf_4_clk _0500_ VGND VGND VPWR VPWR u_pe_array.u_fifo2.buffer\[1\]\[3\]
+ sky130_fd_sc_hd__dfxtp_1
XFILLER_0_114_524 VGND VGND VPWR VPWR sky130_fd_sc_hd__decap_8
XFILLER_0_71_477 VGND VGND VPWR VPWR sky130_fd_sc_hd__fill_1
X_6402_ _3161_ _3162_ _3160_ VGND VGND VPWR VPWR _3163_ sky130_fd_sc_hd__a21oi_1
XFILLER_0_44_669 VGND VGND VPWR VPWR sky130_fd_sc_hd__fill_2
XANTENNA__7357__RESET_B net818 VGND VGND VPWR VPWR sky130_fd_sc_hd__diode_2
X_3614_ u_pe_array.g_pe_row\[2\].g_pe_col\[2\].u_pe.act_val\[3\] u_pe_array.g_pe_row\[2\].g_pe_col\[2\].u_pe.psum_out\[3\]
+ _0755_ VGND VGND VPWR VPWR _0844_ sky130_fd_sc_hd__mux2_1
XFILLER_0_114_579 VGND VGND VPWR VPWR sky130_fd_sc_hd__decap_8
XFILLER_0_114_557 VGND VGND VPWR VPWR sky130_fd_sc_hd__fill_1
X_7382_ clknet_leaf_47_clk _0435_ net812 VGND VGND VPWR VPWR u_pe_array.g_pe_row\[0\].g_pe_col\[1\].u_pe.psum_out\[6\]
+ sky130_fd_sc_hd__dfrtp_1
XFILLER_0_71_488 VGND VGND VPWR VPWR sky130_fd_sc_hd__fill_2
X_4594_ _0835_ VGND VGND VPWR VPWR _1655_ sky130_fd_sc_hd__buf_6
XFILLER_0_3_232 VGND VGND VPWR VPWR sky130_fd_sc_hd__fill_2
XFILLER_0_12_522 VGND VGND VPWR VPWR sky130_fd_sc_hd__decap_8
XFILLER_0_101_229 VGND VGND VPWR VPWR sky130_fd_sc_hd__decap_4
XFILLER_0_101_72 VGND VGND VPWR VPWR sky130_fd_sc_hd__fill_2
XANTENNA__3952__S _0819_ VGND VGND VPWR VPWR sky130_fd_sc_hd__diode_2
X_6333_ _3115_ VGND VGND VPWR VPWR _0461_ sky130_fd_sc_hd__clkbuf_1
X_3545_ u_fsm.cnt\[3\] u_fsm.cnt\[2\] VGND VGND VPWR VPWR _0791_ sky130_fd_sc_hd__nor2_1
XFILLER_0_12_533 VGND VGND VPWR VPWR sky130_fd_sc_hd__fill_2
X_6264_ net712 _0867_ _2174_ _3055_ VGND VGND VPWR VPWR _0452_ sky130_fd_sc_hd__a22o_1
X_3476_ _0734_ VGND VGND VPWR VPWR _0745_ sky130_fd_sc_hd__buf_12
XFILLER_0_86_63 VGND VGND VPWR VPWR sky130_fd_sc_hd__decap_3
X_5215_ u_pe_array.g_pe_row\[1\].g_pe_col\[2\].u_pe.act_val\[2\] u_pe_array.g_pe_row\[1\].g_pe_col\[2\].u_pe.w_reg\[0\]
+ VGND VGND VPWR VPWR _2168_ sky130_fd_sc_hd__nand2_1
XANTENNA__4123__A2 _1138_ VGND VGND VPWR VPWR sky130_fd_sc_hd__diode_2
X_6195_ u_pe_array.g_pe_row\[0\].g_pe_col\[0\].u_pe.w_reg\[1\] VGND VGND VPWR VPWR
+ _2992_ sky130_fd_sc_hd__clkbuf_8
XFILLER_0_86_85 VGND VGND VPWR VPWR sky130_fd_sc_hd__fill_1
XFILLER_0_43_3 VGND VGND VPWR VPWR sky130_fd_sc_hd__decap_6
XANTENNA__5871__A2 _2600_ VGND VGND VPWR VPWR sky130_fd_sc_hd__diode_2
XANTENNA__6992__RESET_B net76 VGND VGND VPWR VPWR sky130_fd_sc_hd__diode_2
X_5146_ _2110_ _2115_ _2118_ _2114_ VGND VGND VPWR VPWR _2119_ sky130_fd_sc_hd__a22oi_2
XANTENNA__5629__A_N u_pe_array.g_pe_row\[1\].g_pe_col\[0\].u_pe.act_val\[4\] VGND
+ VGND VPWR VPWR sky130_fd_sc_hd__diode_2
XANTENNA__6921__RESET_B net815 VGND VGND VPWR VPWR sky130_fd_sc_hd__diode_2
X_5077_ _2053_ _2055_ _2046_ VGND VGND VPWR VPWR _2057_ sky130_fd_sc_hd__o21ai_1
XANTENNA__6820__A1 _3126_ VGND VGND VPWR VPWR sky130_fd_sc_hd__diode_2
XFILLER_0_79_522 VGND VGND VPWR VPWR sky130_fd_sc_hd__fill_2
X_4028_ _0864_ _1186_ _1187_ _1144_ net397 VGND VGND VPWR VPWR _0084_ sky130_fd_sc_hd__a32o_1
XFILLER_0_94_525 VGND VGND VPWR VPWR sky130_fd_sc_hd__fill_2
XFILLER_0_109_329 VGND VGND VPWR VPWR sky130_fd_sc_hd__decap_6
XFILLER_0_94_569 VGND VGND VPWR VPWR sky130_fd_sc_hd__decap_8
X_5979_ _2808_ _2814_ VGND VGND VPWR VPWR _2815_ sky130_fd_sc_hd__nand2_1
XFILLER_0_35_603 VGND VGND VPWR VPWR sky130_fd_sc_hd__decap_6
XFILLER_0_105_502 VGND VGND VPWR VPWR sky130_fd_sc_hd__fill_2
XFILLER_0_74_282 VGND VGND VPWR VPWR sky130_fd_sc_hd__fill_2
X_7649_ clknet_leaf_25_clk _0698_ VGND VGND VPWR VPWR u_pe_array.u_fifo1.buffer\[6\]\[7\]
+ sky130_fd_sc_hd__dfxtp_1
XFILLER_0_62_477 VGND VGND VPWR VPWR sky130_fd_sc_hd__fill_2
XFILLER_0_62_455 VGND VGND VPWR VPWR sky130_fd_sc_hd__decap_3
XFILLER_0_62_444 VGND VGND VPWR VPWR sky130_fd_sc_hd__fill_2
XFILLER_0_50_606 VGND VGND VPWR VPWR sky130_fd_sc_hd__fill_1
XANTENNA__7098__RESET_B net819 VGND VGND VPWR VPWR sky130_fd_sc_hd__diode_2
XFILLER_0_50_639 VGND VGND VPWR VPWR sky130_fd_sc_hd__fill_2
XANTENNA__7027__RESET_B net815 VGND VGND VPWR VPWR sky130_fd_sc_hd__diode_2
XFILLER_0_15_382 VGND VGND VPWR VPWR sky130_fd_sc_hd__decap_8
XFILLER_0_15_393 VGND VGND VPWR VPWR sky130_fd_sc_hd__fill_2
XANTENNA__4958__S _0828_ VGND VGND VPWR VPWR sky130_fd_sc_hd__diode_2
XANTENNA_input27_A w_in_flat[0] VGND VGND VPWR VPWR sky130_fd_sc_hd__diode_2
XFILLER_0_85_525 VGND VGND VPWR VPWR sky130_fd_sc_hd__fill_2
XFILLER_0_85_547 VGND VGND VPWR VPWR sky130_fd_sc_hd__fill_2
XFILLER_0_57_238 VGND VGND VPWR VPWR sky130_fd_sc_hd__fill_1
XFILLER_0_108_351 VGND VGND VPWR VPWR sky130_fd_sc_hd__decap_4
XFILLER_0_65_271 VGND VGND VPWR VPWR sky130_fd_sc_hd__fill_2
XFILLER_0_53_422 VGND VGND VPWR VPWR sky130_fd_sc_hd__fill_2
XFILLER_0_31_47 VGND VGND VPWR VPWR sky130_fd_sc_hd__decap_6
XANTENNA__6878__A1 _3128_ VGND VGND VPWR VPWR sky130_fd_sc_hd__diode_2
XFILLER_0_80_241 VGND VGND VPWR VPWR sky130_fd_sc_hd__fill_1
XFILLER_0_80_230 VGND VGND VPWR VPWR sky130_fd_sc_hd__decap_3
XFILLER_0_80_263 VGND VGND VPWR VPWR sky130_fd_sc_hd__fill_1
XFILLER_0_53_488 VGND VGND VPWR VPWR sky130_fd_sc_hd__fill_2
XFILLER_0_40_116 VGND VGND VPWR VPWR sky130_fd_sc_hd__fill_1
XFILLER_0_111_505 VPWR VGND VPWR VGND sky130_ef_sc_hd__decap_12
XFILLER_0_80_296 VGND VGND VPWR VPWR sky130_fd_sc_hd__fill_2
Xhold209 _0283_ VGND VGND VPWR VPWR net285 sky130_fd_sc_hd__dlygate4sd3_1
XFILLER_0_40_127 VGND VGND VPWR VPWR sky130_fd_sc_hd__decap_3
XFILLER_0_21_341 VGND VGND VPWR VPWR sky130_fd_sc_hd__decap_3
XANTENNA__5553__A _0832_ VGND VGND VPWR VPWR sky130_fd_sc_hd__diode_2
XFILLER_0_0_279 VGND VGND VPWR VPWR sky130_fd_sc_hd__fill_1
XTAP_503 VGND VPWR sky130_fd_sc_hd__tapvpwrvgnd_1
XTAP_514 VGND VPWR sky130_fd_sc_hd__tapvpwrvgnd_1
XTAP_525 VGND VPWR sky130_fd_sc_hd__tapvpwrvgnd_1
X_5000_ u_pe_array.g_pe_row\[0\].g_pe_col\[2\].u_pe.act_val\[2\] u_pe_array.g_pe_row\[0\].g_pe_col\[2\].u_pe.psum_out\[2\]
+ _0756_ VGND VGND VPWR VPWR _1994_ sky130_fd_sc_hd__mux2_1
XTAP_536 VGND VPWR sky130_fd_sc_hd__tapvpwrvgnd_1
XTAP_547 VGND VPWR sky130_fd_sc_hd__tapvpwrvgnd_1
XTAP_558 VGND VPWR sky130_fd_sc_hd__tapvpwrvgnd_1
XTAP_569 VGND VPWR sky130_fd_sc_hd__tapvpwrvgnd_1
X_6951_ clknet_leaf_79_clk net735 net815 VGND VGND VPWR VPWR u_pe_array.g_pe_row\[3\].g_pe_col\[3\].u_pe.psum_out\[8\]
+ sky130_fd_sc_hd__dfrtp_1
XANTENNA__4813__A0 _1832_ VGND VGND VPWR VPWR sky130_fd_sc_hd__diode_2
X_6882_ net206 _3132_ _3412_ VGND VGND VPWR VPWR _3424_ sky130_fd_sc_hd__mux2_1
XFILLER_0_76_525 VGND VGND VPWR VPWR sky130_fd_sc_hd__fill_2
XFILLER_0_72_76 VGND VGND VPWR VPWR sky130_fd_sc_hd__fill_1
X_5902_ u_pe_array.g_pe_row\[0\].g_pe_col\[2\].u_pe.act_val\[0\] _2743_ u_pe_array.g_pe_row\[0\].g_pe_col\[2\].u_pe.psum_out\[1\]
+ VGND VGND VPWR VPWR _2744_ sky130_fd_sc_hd__a21oi_1
X_5833_ _2611_ u_pe_array.g_pe_row\[0\].g_pe_col\[3\].u_pe.psum_out\[9\] VGND VGND
+ VPWR VPWR _2695_ sky130_fd_sc_hd__and2_1
XFILLER_0_63_219 VGND VGND VPWR VPWR sky130_fd_sc_hd__decap_3
XFILLER_0_8_357 VGND VGND VPWR VPWR sky130_fd_sc_hd__decap_4
XFILLER_0_16_124 VGND VGND VPWR VPWR sky130_fd_sc_hd__decap_3
XFILLER_0_17_647 VPWR VGND VPWR VGND sky130_ef_sc_hd__decap_12
X_5764_ _2631_ VGND VGND VPWR VPWR _2632_ sky130_fd_sc_hd__inv_2
X_7503_ clknet_leaf_4_clk _0552_ VGND VGND VPWR VPWR u_pe_array.u_fifo2.buffer\[5\]\[3\]
+ sky130_fd_sc_hd__dfxtp_1
X_5695_ _2581_ _2582_ VGND VGND VPWR VPWR _2583_ sky130_fd_sc_hd__or2_1
XANTENNA__6318__B1 net49 VGND VGND VPWR VPWR sky130_fd_sc_hd__diode_2
X_4715_ _1672_ u_pe_array.g_pe_row\[2\].g_pe_col\[1\].u_pe.psum_out\[9\] VGND VGND
+ VPWR VPWR _1758_ sky130_fd_sc_hd__and2_1
XANTENNA__7191__RESET_B net73 VGND VGND VPWR VPWR sky130_fd_sc_hd__diode_2
XFILLER_0_114_321 VGND VGND VPWR VPWR sky130_fd_sc_hd__decap_8
X_4646_ u_pe_array.g_pe_row\[2\].g_pe_col\[1\].u_pe.psum_out\[3\] _1694_ VGND VGND
+ VPWR VPWR _1695_ sky130_fd_sc_hd__xor2_1
X_7434_ clknet_leaf_7_clk _0483_ net816 VGND VGND VPWR VPWR u_pe_array.u_fifo2.count\[3\]
+ sky130_fd_sc_hd__dfrtp_1
XFILLER_0_16_168 VGND VGND VPWR VPWR sky130_fd_sc_hd__decap_3
XFILLER_0_114_365 VGND VGND VPWR VPWR sky130_fd_sc_hd__decap_6
Xhold721 _1823_ VGND VGND VPWR VPWR net797 sky130_fd_sc_hd__dlygate4sd3_1
X_7365_ clknet_leaf_45_clk _0420_ net812 VGND VGND VPWR VPWR u_pe_array.g_pe_row\[0\].g_pe_col\[0\].u_pe.act_val\[4\]
+ sky130_fd_sc_hd__dfrtp_2
XANTENNA__7120__RESET_B net813 VGND VGND VPWR VPWR sky130_fd_sc_hd__diode_2
Xhold710 u_pe_array.g_pe_row\[1\].g_pe_col\[1\].u_pe.act_val\[0\] VGND VGND VPWR VPWR
+ net786 sky130_fd_sc_hd__dlygate4sd3_1
X_4577_ u_pe_array.g_pe_row\[2\].g_pe_col\[2\].u_pe.psum_out\[9\] u_pe_array.g_pe_row\[2\].g_pe_col\[2\].u_pe.psum_out\[10\]
+ _1536_ VGND VGND VPWR VPWR _1645_ sky130_fd_sc_hd__o21a_1
X_6316_ _3100_ _3101_ VGND VGND VPWR VPWR _3102_ sky130_fd_sc_hd__xnor2_1
Xhold743 u_pe_array.g_pe_row\[2\].g_pe_col\[0\].u_pe.psum_out\[10\] VGND VGND VPWR
+ VPWR net827 sky130_fd_sc_hd__dlygate4sd3_1
Xhold732 u_pe_array.g_pe_row\[2\].g_pe_col\[3\].u_pe.move_reg\[7\] VGND VGND VPWR
+ VPWR net808 sky130_fd_sc_hd__dlygate4sd3_1
XFILLER_0_40_672 VGND VGND VPWR VPWR sky130_fd_sc_hd__fill_2
X_3528_ u_pe_array.g_pe_row\[1\].g_pe_col\[0\].u_pe.psum_out\[12\] _0769_ _0777_ _0754_
+ VGND VGND VPWR VPWR net39 sky130_fd_sc_hd__o211a_1
X_7296_ clknet_leaf_39_clk _0355_ net813 VGND VGND VPWR VPWR u_pe_array.g_pe_row\[1\].g_pe_col\[0\].u_pe.psum_out\[10\]
+ sky130_fd_sc_hd__dfrtp_2
X_6247_ _3025_ _3026_ _3039_ VGND VGND VPWR VPWR _3040_ sky130_fd_sc_hd__o21a_1
X_3459_ _0729_ _0720_ VGND VGND VPWR VPWR _0733_ sky130_fd_sc_hd__or2_1
X_6178_ _2740_ _2980_ _2981_ _0866_ net514 VGND VGND VPWR VPWR _0440_ sky130_fd_sc_hd__a32o_1
X_5129_ _2077_ _2101_ _2102_ _2103_ VGND VGND VPWR VPWR _2104_ sky130_fd_sc_hd__o31a_1
XANTENNA__4804__A0 _1826_ VGND VGND VPWR VPWR sky130_fd_sc_hd__diode_2
XANTENNA__7279__RESET_B net814 VGND VGND VPWR VPWR sky130_fd_sc_hd__diode_2
XANTENNA__7208__RESET_B net814 VGND VGND VPWR VPWR sky130_fd_sc_hd__diode_2
XFILLER_0_35_466 VGND VGND VPWR VPWR sky130_fd_sc_hd__fill_2
XFILLER_0_62_274 VGND VGND VPWR VPWR sky130_fd_sc_hd__decap_3
XFILLER_0_50_425 VGND VGND VPWR VPWR sky130_fd_sc_hd__fill_2
XFILLER_0_50_414 VGND VGND VPWR VPWR sky130_fd_sc_hd__fill_2
XFILLER_0_50_469 VGND VGND VPWR VPWR sky130_fd_sc_hd__fill_2
XFILLER_0_31_650 VGND VGND VPWR VPWR sky130_fd_sc_hd__fill_2
XFILLER_0_30_171 VGND VGND VPWR VPWR sky130_fd_sc_hd__decap_6
XFILLER_0_101_582 VPWR VGND VPWR VGND sky130_ef_sc_hd__decap_12
XANTENNA__5296__B1 _0861_ VGND VGND VPWR VPWR sky130_fd_sc_hd__diode_2
Xhold92 u_pe_array.g_pe_row\[0\].g_pe_col\[1\].u_pe.move_reg\[11\] VGND VGND VPWR
+ VPWR net168 sky130_fd_sc_hd__dlygate4sd3_1
XFILLER_0_26_47 VGND VGND VPWR VPWR sky130_fd_sc_hd__fill_2
Xhold81 _0342_ VGND VGND VPWR VPWR net157 sky130_fd_sc_hd__dlygate4sd3_1
Xhold70 u_pe_array.g_pe_row\[3\].g_pe_col\[2\].u_pe.move_reg\[10\] VGND VGND VPWR
+ VPWR net146 sky130_fd_sc_hd__dlygate4sd3_1
XFILLER_0_97_193 VGND VGND VPWR VPWR sky130_fd_sc_hd__fill_2
XFILLER_0_42_24 VGND VGND VPWR VPWR sky130_fd_sc_hd__decap_4
XFILLER_0_85_377 VGND VGND VPWR VPWR sky130_fd_sc_hd__fill_2
XANTENNA__6651__B _0833_ VGND VGND VPWR VPWR sky130_fd_sc_hd__diode_2
XANTENNA__5220__B1 _0885_ VGND VGND VPWR VPWR sky130_fd_sc_hd__diode_2
XFILLER_0_109_671 VGND VGND VPWR VPWR sky130_fd_sc_hd__fill_1
X_5480_ _2345_ _2400_ u_pe_array.g_pe_row\[1\].g_pe_col\[1\].u_pe.psum_out\[6\] VGND
+ VGND VPWR VPWR _2401_ sky130_fd_sc_hd__and3_1
XFILLER_0_5_349 VGND VGND VPWR VPWR sky130_fd_sc_hd__fill_2
X_4500_ _1566_ _1575_ VGND VGND VPWR VPWR _1576_ sky130_fd_sc_hd__nor2_1
XFILLER_0_26_477 VGND VGND VPWR VPWR sky130_fd_sc_hd__decap_3
XFILLER_0_101_3 VPWR VGND VPWR VGND sky130_ef_sc_hd__decap_12
X_4431_ net694 _1392_ _1258_ _1520_ VGND VGND VPWR VPWR _0154_ sky130_fd_sc_hd__a22o_1
XFILLER_0_41_447 VGND VGND VPWR VPWR sky130_fd_sc_hd__fill_1
XFILLER_0_41_458 VGND VGND VPWR VPWR sky130_fd_sc_hd__fill_2
XFILLER_0_111_335 VGND VGND VPWR VPWR sky130_fd_sc_hd__fill_1
X_7150_ clknet_leaf_32_clk _0219_ net817 VGND VGND VPWR VPWR u_pe_array.g_pe_row\[2\].g_pe_col\[0\].u_pe.w_buffer\[1\]
+ sky130_fd_sc_hd__dfrtp_1
X_4362_ _1462_ _1463_ VGND VGND VPWR VPWR _1464_ sky130_fd_sc_hd__nand2_1
X_6101_ _2910_ _2911_ VGND VGND VPWR VPWR _2912_ sky130_fd_sc_hd__or2_1
XANTENNA__3515__B _0770_ VGND VGND VPWR VPWR sky130_fd_sc_hd__diode_2
X_7081_ clknet_leaf_14_clk _0154_ net816 VGND VGND VPWR VPWR u_pe_array.g_pe_row\[2\].g_pe_col\[1\].u_pe.act_val\[3\]
+ sky130_fd_sc_hd__dfrtp_2
XTAP_322 VGND VPWR sky130_fd_sc_hd__tapvpwrvgnd_1
XTAP_333 VGND VPWR sky130_fd_sc_hd__tapvpwrvgnd_1
XTAP_311 VGND VPWR sky130_fd_sc_hd__tapvpwrvgnd_1
XTAP_300 VGND VPWR sky130_fd_sc_hd__tapvpwrvgnd_1
X_4293_ u_pe_array.g_pe_row\[2\].g_pe_col\[3\].u_pe.psum_out\[11\] net170 _0855_ VGND
+ VGND VPWR VPWR _1403_ sky130_fd_sc_hd__mux2_1
X_6032_ u_pe_array.g_pe_row\[0\].g_pe_col\[1\].u_pe.act_val\[2\] u_pe_array.g_pe_row\[0\].g_pe_col\[1\].u_pe.psum_out\[2\]
+ _0770_ VGND VGND VPWR VPWR _2858_ sky130_fd_sc_hd__mux2_1
XTAP_366 VGND VPWR sky130_fd_sc_hd__tapvpwrvgnd_1
XTAP_355 VGND VPWR sky130_fd_sc_hd__tapvpwrvgnd_1
XTAP_344 VGND VPWR sky130_fd_sc_hd__tapvpwrvgnd_1
XTAP_388 VGND VPWR sky130_fd_sc_hd__tapvpwrvgnd_1
XTAP_377 VGND VPWR sky130_fd_sc_hd__tapvpwrvgnd_1
XTAP_399 VGND VPWR sky130_fd_sc_hd__tapvpwrvgnd_1
XFILLER_0_83_31 VGND VGND VPWR VPWR sky130_fd_sc_hd__fill_1
XFILLER_0_107_71 VGND VGND VPWR VPWR sky130_fd_sc_hd__fill_2
XFILLER_0_89_661 VGND VGND VPWR VPWR sky130_fd_sc_hd__fill_2
XPHY_17 VGND VGND VPWR VPWR sky130_fd_sc_hd__decap_3
XPHY_28 VGND VGND VPWR VPWR sky130_fd_sc_hd__decap_3
X_6934_ clknet_leaf_86_clk _0017_ net819 VGND VGND VPWR VPWR u_pe_array.g_pe_row\[3\].g_pe_col\[2\].u_pe.move_reg\[6\]
+ sky130_fd_sc_hd__dfrtp_1
XPHY_39 VGND VGND VPWR VPWR sky130_fd_sc_hd__decap_3
X_6865_ _3415_ VGND VGND VPWR VPWR _0693_ sky130_fd_sc_hd__clkbuf_1
XANTENNA__7372__RESET_B net812 VGND VGND VPWR VPWR sky130_fd_sc_hd__diode_2
XFILLER_0_8_121 VGND VGND VPWR VPWR sky130_fd_sc_hd__decap_8
XFILLER_0_8_110 VGND VGND VPWR VPWR sky130_fd_sc_hd__fill_1
X_6796_ _3377_ VGND VGND VPWR VPWR _0662_ sky130_fd_sc_hd__clkbuf_1
XANTENNA__4014__A1 _0864_ VGND VGND VPWR VPWR sky130_fd_sc_hd__diode_2
XFILLER_0_8_132 VGND VGND VPWR VPWR sky130_fd_sc_hd__decap_8
X_5816_ _2670_ _2675_ _2678_ VGND VGND VPWR VPWR _2680_ sky130_fd_sc_hd__or3_1
XANTENNA__7301__RESET_B net814 VGND VGND VPWR VPWR sky130_fd_sc_hd__diode_2
XANTENNA__5892__S _2469_ VGND VGND VPWR VPWR sky130_fd_sc_hd__diode_2
XANTENNA__5762__A1 _2611_ VGND VGND VPWR VPWR sky130_fd_sc_hd__diode_2
X_5747_ _2258_ _2615_ _2616_ _2571_ net504 VGND VGND VPWR VPWR _0374_ sky130_fd_sc_hd__a32o_1
XFILLER_0_44_263 VGND VGND VPWR VPWR sky130_fd_sc_hd__fill_2
XFILLER_0_17_499 VGND VGND VPWR VPWR sky130_fd_sc_hd__fill_2
X_7417_ clknet_leaf_29_clk _0466_ VGND VGND VPWR VPWR u_pe_array.u_fifo1.buffer\[8\]\[7\]
+ sky130_fd_sc_hd__dfxtp_1
XFILLER_0_102_302 VGND VGND VPWR VPWR sky130_fd_sc_hd__decap_6
X_5678_ _2557_ _2565_ _2566_ _2567_ VGND VGND VPWR VPWR _2568_ sky130_fd_sc_hd__a31o_1
XANTENNA__4317__A2 _1152_ VGND VGND VPWR VPWR sky130_fd_sc_hd__diode_2
XFILLER_0_114_173 VGND VGND VPWR VPWR sky130_fd_sc_hd__fill_2
X_4629_ u_pe_array.g_pe_row\[2\].g_pe_col\[1\].u_pe.psum_out\[1\] _1675_ _1678_ VGND
+ VGND VPWR VPWR _1679_ sky130_fd_sc_hd__a21o_1
XFILLER_0_13_661 VGND VGND VPWR VPWR sky130_fd_sc_hd__decap_8
XFILLER_0_32_469 VGND VGND VPWR VPWR sky130_fd_sc_hd__fill_2
Xhold562 u_pe_array.g_pe_row\[1\].g_pe_col\[1\].u_pe.psum_out\[10\] VGND VGND VPWR
+ VPWR net638 sky130_fd_sc_hd__dlygate4sd3_1
XANTENNA__4722__C1 _1672_ VGND VGND VPWR VPWR sky130_fd_sc_hd__diode_2
X_7348_ clknet_leaf_62_clk _0403_ net818 VGND VGND VPWR VPWR u_pe_array.g_pe_row\[0\].g_pe_col\[2\].u_pe.psum_out\[2\]
+ sky130_fd_sc_hd__dfrtp_1
XFILLER_0_12_160 VGND VGND VPWR VPWR sky130_fd_sc_hd__fill_2
Xhold551 u_pe_array.g_pe_row\[3\].g_pe_col\[2\].u_pe.psum_out\[9\] VGND VGND VPWR
+ VPWR net627 sky130_fd_sc_hd__dlygate4sd3_1
Xhold540 u_pe_array.g_pe_row\[0\].g_pe_col\[2\].u_pe.act_val\[2\] VGND VGND VPWR VPWR
+ net616 sky130_fd_sc_hd__dlygate4sd3_1
Xhold595 u_pe_array.g_pe_row\[2\].g_pe_col\[0\].u_pe.act_val\[5\] VGND VGND VPWR VPWR
+ net671 sky130_fd_sc_hd__dlygate4sd3_1
Xhold573 u_pe_array.g_pe_row\[1\].g_pe_col\[3\].u_pe.psum_out\[5\] VGND VGND VPWR
+ VPWR net649 sky130_fd_sc_hd__dlygate4sd3_1
Xhold584 u_pe_array.g_pe_row\[3\].g_pe_col\[3\].u_pe.move_reg\[9\] VGND VGND VPWR
+ VPWR net660 sky130_fd_sc_hd__dlygate4sd3_1
X_7279_ clknet_leaf_70_clk net278 net814 VGND VGND VPWR VPWR u_pe_array.g_pe_row\[0\].g_pe_col\[3\].u_pe.move_reg\[8\]
+ sky130_fd_sc_hd__dfrtp_1
XFILLER_0_99_414 VGND VGND VPWR VPWR sky130_fd_sc_hd__decap_6
XFILLER_0_99_447 VGND VGND VPWR VPWR sky130_fd_sc_hd__fill_1
XFILLER_0_95_642 VGND VGND VPWR VPWR sky130_fd_sc_hd__fill_1
XFILLER_0_82_314 VGND VGND VPWR VPWR sky130_fd_sc_hd__fill_2
XANTENNA__5202__B1 _2071_ VGND VGND VPWR VPWR sky130_fd_sc_hd__diode_2
XFILLER_0_12_27 VGND VGND VPWR VPWR sky130_fd_sc_hd__fill_1
XANTENNA__7042__RESET_B net76 VGND VGND VPWR VPWR sky130_fd_sc_hd__diode_2
XANTENNA__6898__S _3427_ VGND VGND VPWR VPWR sky130_fd_sc_hd__diode_2
XFILLER_0_35_274 VGND VGND VPWR VPWR sky130_fd_sc_hd__decap_4
XFILLER_0_90_391 VGND VGND VPWR VPWR sky130_fd_sc_hd__decap_3
XFILLER_0_90_380 VGND VGND VPWR VPWR sky130_fd_sc_hd__fill_2
XFILLER_0_50_211 VGND VGND VPWR VPWR sky130_fd_sc_hd__decap_4
XFILLER_0_23_436 VGND VGND VPWR VPWR sky130_fd_sc_hd__decap_3
XFILLER_0_35_285 VGND VGND VPWR VPWR sky130_fd_sc_hd__fill_1
XFILLER_0_35_296 VGND VGND VPWR VPWR sky130_fd_sc_hd__fill_1
XFILLER_0_105_162 VGND VGND VPWR VPWR sky130_fd_sc_hd__decap_6
XANTENNA__5505__A1 _2345_ VGND VGND VPWR VPWR sky130_fd_sc_hd__diode_2
XFILLER_0_50_266 VGND VGND VPWR VPWR sky130_fd_sc_hd__fill_1
XFILLER_0_50_288 VGND VGND VPWR VPWR sky130_fd_sc_hd__decap_3
XFILLER_0_31_480 VGND VGND VPWR VPWR sky130_fd_sc_hd__decap_4
Xoutput60 net60 VGND VGND VPWR VPWR psum_out1[8] sky130_fd_sc_hd__clkbuf_4
XANTENNA__5831__A _0913_ VGND VGND VPWR VPWR sky130_fd_sc_hd__diode_2
XANTENNA_output58_A net58 VGND VGND VPWR VPWR sky130_fd_sc_hd__diode_2
XFILLER_0_37_57 VGND VGND VPWR VPWR sky130_fd_sc_hd__decap_3
XANTENNA__5042__S _1661_ VGND VGND VPWR VPWR sky130_fd_sc_hd__diode_2
XANTENNA__4492__A1 _1536_ VGND VGND VPWR VPWR sky130_fd_sc_hd__diode_2
XFILLER_0_78_609 VGND VGND VPWR VPWR sky130_fd_sc_hd__fill_1
XFILLER_0_86_642 VGND VGND VPWR VPWR sky130_fd_sc_hd__fill_2
X_4980_ u_pe_array.u_fifo2.buffer\[6\]\[0\] _1964_ _1967_ _1975_ VGND VGND VPWR VPWR
+ _1976_ sky130_fd_sc_hd__a211o_1
XFILLER_0_86_653 VGND VGND VPWR VPWR sky130_fd_sc_hd__fill_1
X_3931_ _1009_ u_pe_array.g_pe_row\[3\].g_pe_col\[2\].u_pe.psum_out\[11\] VGND VGND
+ VPWR VPWR _1112_ sky130_fd_sc_hd__and2b_1
XFILLER_0_73_325 VGND VGND VPWR VPWR sky130_fd_sc_hd__decap_8
X_6650_ _3294_ VGND VGND VPWR VPWR _0599_ sky130_fd_sc_hd__clkbuf_1
X_3862_ _1026_ _1036_ _1035_ VGND VGND VPWR VPWR _1050_ sky130_fd_sc_hd__a21o_1
X_5601_ u_pe_array.g_pe_row\[1\].g_pe_col\[0\].u_pe.act_val\[2\] u_pe_array.g_pe_row\[1\].g_pe_col\[0\].u_pe.w_reg\[0\]
+ _2487_ VGND VGND VPWR VPWR _2497_ sky130_fd_sc_hd__and3_1
XFILLER_0_6_625 VPWR VGND VPWR VGND sky130_ef_sc_hd__decap_12
X_6581_ net580 _1804_ _3254_ VGND VGND VPWR VPWR _3259_ sky130_fd_sc_hd__mux2_1
X_5532_ u_pe_array.g_pe_row\[1\].g_pe_col\[1\].u_pe.psum_out\[11\] _2345_ VGND VGND
+ VPWR VPWR _2448_ sky130_fd_sc_hd__and2b_1
X_3793_ u_pe_array.g_pe_row\[3\].g_pe_col\[2\].u_pe.psum_out\[4\] u_pe_array.g_pe_row\[3\].g_pe_col\[2\].u_pe.act_val\[4\]
+ _0745_ VGND VGND VPWR VPWR _0994_ sky130_fd_sc_hd__mux2_1
XFILLER_0_5_113 VPWR VGND VPWR VGND sky130_ef_sc_hd__decap_12
XANTENNA__3755__B1 _0869_ VGND VGND VPWR VPWR sky130_fd_sc_hd__diode_2
XANTENNA__6601__S _3269_ VGND VGND VPWR VPWR sky130_fd_sc_hd__diode_2
XFILLER_0_81_391 VGND VGND VPWR VPWR sky130_fd_sc_hd__fill_1
X_5463_ _2375_ _2384_ net71 VGND VGND VPWR VPWR _2386_ sky130_fd_sc_hd__a21o_1
XANTENNA__3507__A0 u_pe_array.g_pe_row\[1\].g_pe_col\[0\].u_pe.act_val\[4\] VGND VGND
+ VPWR VPWR sky130_fd_sc_hd__diode_2
XFILLER_0_111_143 VGND VGND VPWR VPWR sky130_fd_sc_hd__fill_1
X_5394_ u_pe_array.u_fifo1.buffer\[1\]\[5\] _2278_ _2326_ _2328_ VGND VGND VPWR VPWR
+ _2329_ sky130_fd_sc_hd__a211o_1
XFILLER_0_78_75 VGND VGND VPWR VPWR sky130_fd_sc_hd__fill_1
X_7202_ clknet_leaf_70_clk _0267_ net814 VGND VGND VPWR VPWR u_pe_array.g_pe_row\[1\].g_pe_col\[3\].u_pe.psum_out\[6\]
+ sky130_fd_sc_hd__dfrtp_2
X_4414_ _1273_ _1509_ _1510_ _1144_ net333 VGND VGND VPWR VPWR _0147_ sky130_fd_sc_hd__a32o_1
X_7133_ clknet_leaf_37_clk net725 net76 VGND VGND VPWR VPWR u_pe_array.g_pe_row\[2\].g_pe_col\[1\].u_pe.psum_out\[10\]
+ sky130_fd_sc_hd__dfrtp_2
X_4345_ _1273_ _1447_ _1448_ _1144_ net337 VGND VGND VPWR VPWR _0140_ sky130_fd_sc_hd__a32o_1
XFILLER_0_1_385 VGND VGND VPWR VPWR sky130_fd_sc_hd__decap_6
XANTENNA__3960__S _0755_ VGND VGND VPWR VPWR sky130_fd_sc_hd__diode_2
X_7064_ clknet_leaf_91_clk _0137_ net819 VGND VGND VPWR VPWR u_pe_array.g_pe_row\[2\].g_pe_col\[3\].u_pe.psum_out\[1\]
+ sky130_fd_sc_hd__dfrtp_1
X_4276_ u_pe_array.g_pe_row\[2\].g_pe_col\[3\].u_pe.psum_out\[3\] u_pe_array.g_pe_row\[2\].g_pe_col\[3\].u_pe.act_val\[3\]
+ _0769_ VGND VGND VPWR VPWR _1394_ sky130_fd_sc_hd__mux2_1
XANTENNA__6048__S _2469_ VGND VGND VPWR VPWR sky130_fd_sc_hd__diode_2
X_6015_ _2845_ _2846_ VGND VGND VPWR VPWR _2847_ sky130_fd_sc_hd__or2_1
XFILLER_0_96_406 VGND VGND VPWR VPWR sky130_fd_sc_hd__fill_2
XANTENNA__7553__RESET_B net816 VGND VGND VPWR VPWR sky130_fd_sc_hd__diode_2
XFILLER_0_68_119 VGND VGND VPWR VPWR sky130_fd_sc_hd__fill_2
XANTENNA__4791__S _1796_ VGND VGND VPWR VPWR sky130_fd_sc_hd__diode_2
XTAP_1329 VGND VPWR sky130_fd_sc_hd__tapvpwrvgnd_1
XTAP_1318 VGND VPWR sky130_fd_sc_hd__tapvpwrvgnd_1
XFILLER_0_89_491 VGND VGND VPWR VPWR sky130_fd_sc_hd__fill_2
XTAP_1307 VGND VPWR sky130_fd_sc_hd__tapvpwrvgnd_1
XANTENNA__6291__B _2992_ VGND VGND VPWR VPWR sky130_fd_sc_hd__diode_2
X_6917_ clknet_leaf_37_clk _0003_ net813 VGND VGND VPWR VPWR u_fsm.cnt\[3\] sky130_fd_sc_hd__dfrtp_1
X_6848_ net257 _3126_ _3397_ VGND VGND VPWR VPWR _3406_ sky130_fd_sc_hd__mux2_1
XFILLER_0_91_111 VGND VGND VPWR VPWR sky130_fd_sc_hd__fill_1
XFILLER_0_64_314 VGND VGND VPWR VPWR sky130_fd_sc_hd__fill_2
XFILLER_0_92_645 VGND VGND VPWR VPWR sky130_fd_sc_hd__fill_2
XFILLER_0_107_449 VGND VGND VPWR VPWR sky130_fd_sc_hd__decap_6
X_6779_ net525 _3114_ _3366_ VGND VGND VPWR VPWR _3369_ sky130_fd_sc_hd__mux2_1
XANTENNA__5735__B2 _0722_ VGND VGND VPWR VPWR sky130_fd_sc_hd__diode_2
XFILLER_0_45_561 VPWR VGND VPWR VGND sky130_ef_sc_hd__decap_12
XFILLER_0_20_406 VGND VGND VPWR VPWR sky130_fd_sc_hd__fill_2
Xhold370 u_pe_array.u_fifo1.buffer\[4\]\[0\] VGND VGND VPWR VPWR net446 sky130_fd_sc_hd__dlygate4sd3_1
Xhold381 u_pe_array.u_fifo2.buffer\[2\]\[1\] VGND VGND VPWR VPWR net457 sky130_fd_sc_hd__dlygate4sd3_1
Xhold392 u_pe_array.u_fifo1.buffer\[6\]\[3\] VGND VGND VPWR VPWR net468 sky130_fd_sc_hd__dlygate4sd3_1
XANTENNA__7294__RESET_B net813 VGND VGND VPWR VPWR sky130_fd_sc_hd__diode_2
XANTENNA__7223__RESET_B net812 VGND VGND VPWR VPWR sky130_fd_sc_hd__diode_2
XFILLER_0_68_642 VGND VGND VPWR VPWR sky130_fd_sc_hd__fill_2
XFILLER_0_83_612 VGND VGND VPWR VPWR sky130_fd_sc_hd__fill_2
XFILLER_0_23_48 VGND VGND VPWR VPWR sky130_fd_sc_hd__fill_2
XFILLER_0_28_528 VGND VGND VPWR VPWR sky130_fd_sc_hd__fill_2
XFILLER_0_99_19 VPWR VGND VPWR VGND sky130_ef_sc_hd__decap_12
XFILLER_0_82_133 VGND VGND VPWR VPWR sky130_fd_sc_hd__decap_6
XFILLER_0_82_166 VGND VGND VPWR VPWR sky130_fd_sc_hd__fill_2
XANTENNA__4730__A _1672_ VGND VGND VPWR VPWR sky130_fd_sc_hd__diode_2
XFILLER_0_3_617 VPWR VGND VPWR VGND sky130_ef_sc_hd__decap_12
XFILLER_0_36_594 VGND VGND VPWR VPWR sky130_fd_sc_hd__fill_2
X_4130_ u_pe_array.g_pe_row\[3\].g_pe_col\[3\].u_pe.psum_out\[11\] u_pe_array.g_pe_row\[3\].g_pe_col\[3\].u_pe.move_reg\[11\]
+ _0855_ VGND VGND VPWR VPWR _1268_ sky130_fd_sc_hd__mux2_1
XFILLER_0_48_89 VGND VGND VPWR VPWR sky130_fd_sc_hd__decap_3
X_4061_ _1206_ _1212_ VGND VGND VPWR VPWR _1217_ sky130_fd_sc_hd__or2b_1
XFILLER_0_3_69 VPWR VGND VPWR VGND sky130_ef_sc_hd__decap_12
XFILLER_0_78_428 VGND VGND VPWR VPWR sky130_fd_sc_hd__fill_2
XFILLER_0_64_77 VGND VGND VPWR VPWR sky130_fd_sc_hd__decap_6
XFILLER_0_74_601 VGND VGND VPWR VPWR sky130_fd_sc_hd__fill_2
XFILLER_0_58_141 VGND VGND VPWR VPWR sky130_fd_sc_hd__decap_3
X_4963_ u_pe_array.u_fifo2.rd_ptr\[1\] u_pe_array.u_fifo2.rd_ptr\[0\] u_pe_array.u_fifo2.rd_ptr\[2\]
+ VGND VGND VPWR VPWR _1959_ sky130_fd_sc_hd__or3_2
X_6702_ net451 _3118_ _3324_ VGND VGND VPWR VPWR _3329_ sky130_fd_sc_hd__mux2_1
XANTENNA__4116__S _0769_ VGND VGND VPWR VPWR sky130_fd_sc_hd__diode_2
X_3914_ u_pe_array.g_pe_row\[3\].g_pe_col\[2\].u_pe.psum_out\[9\] _1009_ VGND VGND
+ VPWR VPWR _1097_ sky130_fd_sc_hd__or2_1
X_4894_ u_pe_array.g_pe_row\[2\].g_pe_col\[0\].u_pe.act_val\[5\] VGND VGND VPWR VPWR
+ _1899_ sky130_fd_sc_hd__inv_2
X_6633_ _0992_ net10 _0747_ VGND VGND VPWR VPWR _3286_ sky130_fd_sc_hd__mux2_1
XANTENNA__3955__S _0819_ VGND VGND VPWR VPWR sky130_fd_sc_hd__diode_2
XFILLER_0_73_177 VGND VGND VPWR VPWR sky130_fd_sc_hd__decap_3
XFILLER_0_73_166 VGND VGND VPWR VPWR sky130_fd_sc_hd__fill_2
XFILLER_0_61_306 VGND VGND VPWR VPWR sky130_fd_sc_hd__decap_4
XANTENNA__6946__RESET_B net815 VGND VGND VPWR VPWR sky130_fd_sc_hd__diode_2
XFILLER_0_27_561 VGND VGND VPWR VPWR sky130_fd_sc_hd__fill_1
X_3845_ _1029_ _1033_ VGND VGND VPWR VPWR _1034_ sky130_fd_sc_hd__xnor2_1
XFILLER_0_104_419 VGND VGND VPWR VPWR sky130_fd_sc_hd__fill_1
X_6564_ _3249_ VGND VGND VPWR VPWR _0558_ sky130_fd_sc_hd__clkbuf_1
XFILLER_0_6_477 VPWR VGND VPWR VGND sky130_ef_sc_hd__decap_12
X_3776_ net474 _0875_ _0887_ _0983_ VGND VGND VPWR VPWR _0036_ sky130_fd_sc_hd__a22o_1
XFILLER_0_42_531 VGND VGND VPWR VPWR sky130_fd_sc_hd__fill_1
X_5515_ u_pe_array.g_pe_row\[1\].g_pe_col\[1\].u_pe.psum_out\[8\] _2430_ _2432_ _2422_
+ VGND VGND VPWR VPWR _2433_ sky130_fd_sc_hd__a22o_1
XANTENNA__5455__B _2345_ VGND VGND VPWR VPWR sky130_fd_sc_hd__diode_2
X_6495_ _3212_ VGND VGND VPWR VPWR _0526_ sky130_fd_sc_hd__clkbuf_1
XFILLER_0_112_430 VPWR VGND VPWR VGND sky130_ef_sc_hd__decap_12
X_5446_ u_pe_array.g_pe_row\[1\].g_pe_col\[1\].u_pe.psum_out\[2\] _2356_ _2369_ VGND
+ VGND VPWR VPWR _2370_ sky130_fd_sc_hd__a21oi_1
XFILLER_0_73_3 VPWR VGND VPWR VGND sky130_ef_sc_hd__decap_12
XFILLER_0_112_474 VGND VGND VPWR VPWR sky130_fd_sc_hd__fill_2
XFILLER_0_100_669 VGND VGND VPWR VPWR sky130_fd_sc_hd__decap_8
XANTENNA__5350__C1 _0819_ VGND VGND VPWR VPWR sky130_fd_sc_hd__diode_2
X_5377_ u_pe_array.u_fifo1.buffer\[8\]\[3\] _2273_ _2309_ _2313_ _0819_ VGND VGND
+ VPWR VPWR _2314_ sky130_fd_sc_hd__a221o_1
XFILLER_0_1_193 VPWR VGND VPWR VGND sky130_ef_sc_hd__decap_12
X_7116_ clknet_leaf_13_clk _0187_ net816 VGND VGND VPWR VPWR u_pe_array.g_pe_row\[2\].g_pe_col\[0\].u_pe.move_reg\[8\]
+ sky130_fd_sc_hd__dfrtp_1
X_4328_ _1432_ VGND VGND VPWR VPWR _1433_ sky130_fd_sc_hd__inv_2
XANTENNA_input1_A h_in0[0] VGND VGND VPWR VPWR sky130_fd_sc_hd__diode_2
X_4259_ _1273_ _1382_ _1383_ _1144_ net380 VGND VGND VPWR VPWR _0119_ sky130_fd_sc_hd__a32o_1
X_7047_ clknet_leaf_76_clk _0122_ net815 VGND VGND VPWR VPWR u_pe_array.g_pe_row\[2\].g_pe_col\[3\].u_pe.w_buffer\[1\]
+ sky130_fd_sc_hd__dfrtp_1
XANTENNA__3703__B _0869_ VGND VGND VPWR VPWR sky130_fd_sc_hd__diode_2
XANTENNA__5410__S _1661_ VGND VGND VPWR VPWR sky130_fd_sc_hd__diode_2
XTAP_1104 VGND VPWR sky130_fd_sc_hd__tapvpwrvgnd_1
XANTENNA__6506__S _3208_ VGND VGND VPWR VPWR sky130_fd_sc_hd__diode_2
XFILLER_0_96_247 VGND VGND VPWR VPWR sky130_fd_sc_hd__decap_3
XTAP_1137 VGND VPWR sky130_fd_sc_hd__tapvpwrvgnd_1
XTAP_1115 VGND VPWR sky130_fd_sc_hd__tapvpwrvgnd_1
XTAP_1126 VGND VPWR sky130_fd_sc_hd__tapvpwrvgnd_1
XANTENNA__3967__A0 u_pe_array.g_pe_row\[2\].g_pe_col\[0\].u_pe.move_reg\[8\] VGND
+ VGND VPWR VPWR sky130_fd_sc_hd__diode_2
XFILLER_0_77_494 VGND VGND VPWR VPWR sky130_fd_sc_hd__fill_1
XFILLER_0_77_472 VGND VGND VPWR VPWR sky130_fd_sc_hd__fill_1
XTAP_1159 VGND VPWR sky130_fd_sc_hd__tapvpwrvgnd_1
XTAP_1148 VGND VPWR sky130_fd_sc_hd__tapvpwrvgnd_1
XFILLER_0_37_314 VGND VGND VPWR VPWR sky130_fd_sc_hd__fill_2
XFILLER_0_64_111 VGND VGND VPWR VPWR sky130_fd_sc_hd__fill_1
XFILLER_0_80_604 VGND VGND VPWR VPWR sky130_fd_sc_hd__fill_2
XFILLER_0_25_509 VGND VGND VPWR VPWR sky130_fd_sc_hd__fill_1
XANTENNA__5184__A2 _2144_ VGND VGND VPWR VPWR sky130_fd_sc_hd__diode_2
XANTENNA__4550__A _1536_ VGND VGND VPWR VPWR sky130_fd_sc_hd__diode_2
XFILLER_0_60_394 VPWR VGND VPWR VGND sky130_ef_sc_hd__decap_12
XANTENNA_clkbuf_leaf_8_clk_A clknet_3_0__leaf_clk VGND VGND VPWR VPWR sky130_fd_sc_hd__diode_2
XANTENNA__7404__RESET_B net817 VGND VGND VPWR VPWR sky130_fd_sc_hd__diode_2
XFILLER_0_87_225 VGND VGND VPWR VPWR sky130_fd_sc_hd__decap_3
XANTENNA__3958__A0 net19 VGND VGND VPWR VPWR sky130_fd_sc_hd__diode_2
XFILLER_0_68_461 VGND VGND VPWR VPWR sky130_fd_sc_hd__fill_2
XFILLER_0_56_645 VGND VGND VPWR VPWR sky130_fd_sc_hd__fill_2
XFILLER_0_71_615 VGND VGND VPWR VPWR sky130_fd_sc_hd__fill_1
XFILLER_0_55_166 VGND VGND VPWR VPWR sky130_fd_sc_hd__fill_2
XFILLER_0_70_136 VGND VGND VPWR VPWR sky130_fd_sc_hd__fill_2
XANTENNA__5175__A2 _1666_ VGND VGND VPWR VPWR sky130_fd_sc_hd__diode_2
X_3630_ net181 _0834_ _0853_ u_fsm.psum_shift_en VGND VGND VPWR VPWR _0020_ sky130_fd_sc_hd__a22o_1
XFILLER_0_36_380 VGND VGND VPWR VPWR sky130_fd_sc_hd__fill_1
X_3561_ net14 _0802_ _0805_ VGND VGND VPWR VPWR _0806_ sky130_fd_sc_hd__a21o_1
XFILLER_0_24_553 VGND VGND VPWR VPWR sky130_fd_sc_hd__fill_2
XFILLER_0_113_249 VPWR VGND VPWR VGND sky130_ef_sc_hd__decap_12
X_5300_ _2235_ _2243_ _2244_ _2245_ VGND VGND VPWR VPWR _2246_ sky130_fd_sc_hd__a31o_1
XFILLER_0_11_214 VGND VGND VPWR VPWR sky130_fd_sc_hd__decap_8
XFILLER_0_3_458 VGND VGND VPWR VPWR sky130_fd_sc_hd__fill_2
XFILLER_0_3_447 VGND VGND VPWR VPWR sky130_fd_sc_hd__fill_1
X_6280_ _3051_ _3061_ u_pe_array.g_pe_row\[0\].g_pe_col\[0\].u_pe.psum_out\[7\] _3047_
+ VGND VGND VPWR VPWR _3070_ sky130_fd_sc_hd__o2bb2a_1
X_3492_ _0747_ VGND VGND VPWR VPWR _0754_ sky130_fd_sc_hd__clkbuf_16
XFILLER_0_59_55 VGND VGND VPWR VPWR sky130_fd_sc_hd__fill_1
XFILLER_0_11_225 VGND VGND VPWR VPWR sky130_fd_sc_hd__fill_1
XANTENNA__3489__A2 _0745_ VGND VGND VPWR VPWR sky130_fd_sc_hd__diode_2
X_5231_ u_pe_array.g_pe_row\[1\].g_pe_col\[2\].u_pe.act_val\[2\] u_pe_array.g_pe_row\[1\].g_pe_col\[2\].u_pe.w_reg\[0\]
+ _2167_ VGND VGND VPWR VPWR _2183_ sky130_fd_sc_hd__and3_1
X_5162_ _1725_ _2132_ _2133_ _2071_ net286 VGND VGND VPWR VPWR _0272_ sky130_fd_sc_hd__a32o_1
XANTENNA__3523__B _0770_ VGND VGND VPWR VPWR sky130_fd_sc_hd__diode_2
XANTENNA__5441__D _2345_ VGND VGND VPWR VPWR sky130_fd_sc_hd__diode_2
X_4113_ net611 _1138_ _1258_ _1259_ VGND VGND VPWR VPWR _0097_ sky130_fd_sc_hd__a22o_1
X_5093_ _1725_ _2069_ _2070_ _2071_ net449 VGND VGND VPWR VPWR _0265_ sky130_fd_sc_hd__a32o_1
XFILLER_0_75_65 VGND VGND VPWR VPWR sky130_fd_sc_hd__fill_2
XANTENNA__4338__C _1407_ VGND VGND VPWR VPWR sky130_fd_sc_hd__diode_2
X_4044_ _1145_ _1200_ u_pe_array.g_pe_row\[3\].g_pe_col\[1\].u_pe.psum_out\[6\] VGND
+ VGND VPWR VPWR _1202_ sky130_fd_sc_hd__a21o_1
XANTENNA__6326__S _3110_ VGND VGND VPWR VPWR sky130_fd_sc_hd__diode_2
XFILLER_0_78_225 VGND VGND VPWR VPWR sky130_fd_sc_hd__fill_2
XPHY_209 VGND VGND VPWR VPWR sky130_fd_sc_hd__decap_3
XANTENNA__3949__A0 net16 VGND VGND VPWR VPWR sky130_fd_sc_hd__diode_2
XFILLER_0_93_206 VGND VGND VPWR VPWR sky130_fd_sc_hd__fill_2
XFILLER_0_47_623 VGND VGND VPWR VPWR sky130_fd_sc_hd__fill_2
X_5995_ _2828_ _2829_ net824 _0875_ VGND VGND VPWR VPWR _0409_ sky130_fd_sc_hd__a2bb2o_1
XFILLER_0_86_280 VGND VGND VPWR VPWR sky130_fd_sc_hd__fill_2
X_4946_ u_pe_array.g_pe_row\[2\].g_pe_col\[0\].u_pe.psum_out\[11\] _1847_ VGND VGND
+ VPWR VPWR _1946_ sky130_fd_sc_hd__and2b_1
XFILLER_0_24_80 VGND VGND VPWR VPWR sky130_fd_sc_hd__fill_1
X_7665_ clknet_leaf_26_clk _0714_ VGND VGND VPWR VPWR u_pe_array.u_fifo1.buffer\[7\]\[10\]
+ sky130_fd_sc_hd__dfxtp_1
X_4877_ _1881_ _1882_ _1883_ VGND VGND VPWR VPWR _1884_ sky130_fd_sc_hd__and3_1
XFILLER_0_74_475 VGND VGND VPWR VPWR sky130_fd_sc_hd__fill_1
X_7596_ clknet_leaf_27_clk _0645_ VGND VGND VPWR VPWR u_pe_array.u_fifo1.buffer\[2\]\[6\]
+ sky130_fd_sc_hd__dfxtp_1
XFILLER_0_74_497 VGND VGND VPWR VPWR sky130_fd_sc_hd__fill_2
XFILLER_0_61_136 VGND VGND VPWR VPWR sky130_fd_sc_hd__decap_6
X_6616_ _3277_ VGND VGND VPWR VPWR _0582_ sky130_fd_sc_hd__clkbuf_1
X_3828_ u_pe_array.g_pe_row\[3\].g_pe_col\[2\].u_pe.psum_out\[2\] _1017_ VGND VGND
+ VPWR VPWR _1018_ sky130_fd_sc_hd__xnor2_1
X_6547_ net480 _1798_ _3239_ VGND VGND VPWR VPWR _3241_ sky130_fd_sc_hd__mux2_1
XFILLER_0_15_597 VGND VGND VPWR VPWR sky130_fd_sc_hd__decap_6
X_3759_ _0967_ _0968_ VGND VGND VPWR VPWR _0969_ sky130_fd_sc_hd__nand2_1
X_6478_ _3203_ VGND VGND VPWR VPWR _0518_ sky130_fd_sc_hd__clkbuf_1
XFILLER_0_42_394 VGND VGND VPWR VPWR sky130_fd_sc_hd__decap_3
X_5429_ u_pe_array.g_pe_row\[1\].g_pe_col\[1\].u_pe.act_val\[1\] _2345_ VGND VGND
+ VPWR VPWR _2354_ sky130_fd_sc_hd__and2b_1
XFILLER_0_100_477 VGND VGND VPWR VPWR sky130_fd_sc_hd__fill_1
XFILLER_0_97_501 VGND VGND VPWR VPWR sky130_fd_sc_hd__decap_3
XFILLER_0_69_225 VGND VGND VPWR VPWR sky130_fd_sc_hd__fill_1
XFILLER_0_38_645 VGND VGND VPWR VPWR sky130_fd_sc_hd__decap_3
XFILLER_0_38_656 VGND VGND VPWR VPWR sky130_fd_sc_hd__fill_2
XFILLER_0_108_533 VPWR VGND VPWR VGND sky130_ef_sc_hd__decap_12
XFILLER_0_65_453 VGND VGND VPWR VPWR sky130_fd_sc_hd__fill_2
XFILLER_0_25_306 VGND VGND VPWR VPWR sky130_fd_sc_hd__fill_1
XFILLER_0_80_434 VGND VGND VPWR VPWR sky130_fd_sc_hd__fill_2
XFILLER_0_80_467 VGND VGND VPWR VPWR sky130_fd_sc_hd__fill_2
XANTENNA__5095__B _2029_ VGND VGND VPWR VPWR sky130_fd_sc_hd__diode_2
XFILLER_0_21_523 VGND VGND VPWR VPWR sky130_fd_sc_hd__fill_2
XANTENNA__4117__B1 _1258_ VGND VGND VPWR VPWR sky130_fd_sc_hd__diode_2
XTAP_707 VGND VPWR sky130_fd_sc_hd__tapvpwrvgnd_1
XANTENNA__5865__B1 _2174_ VGND VGND VPWR VPWR sky130_fd_sc_hd__diode_2
XTAP_729 VGND VPWR sky130_fd_sc_hd__tapvpwrvgnd_1
XTAP_718 VGND VPWR sky130_fd_sc_hd__tapvpwrvgnd_1
XANTENNA__5093__A1 _1725_ VGND VGND VPWR VPWR sky130_fd_sc_hd__diode_2
XFILLER_0_88_578 VGND VGND VPWR VPWR sky130_fd_sc_hd__fill_1
XFILLER_0_88_589 VGND VGND VPWR VPWR sky130_fd_sc_hd__fill_2
X_4800_ u_pe_array.g_pe_row\[1\].g_pe_col\[2\].u_pe.act_val\[0\] u_pe_array.g_pe_row\[1\].g_pe_col\[2\].u_pe.psum_out\[0\]
+ _0756_ VGND VGND VPWR VPWR _1824_ sky130_fd_sc_hd__mux2_1
XANTENNA__6593__A1 _1816_ VGND VGND VPWR VPWR sky130_fd_sc_hd__diode_2
X_5780_ u_pe_array.g_pe_row\[0\].g_pe_col\[3\].u_pe.psum_out\[3\] _2630_ _2631_ VGND
+ VGND VPWR VPWR _2647_ sky130_fd_sc_hd__a21o_1
XTAP_1490 VGND VPWR sky130_fd_sc_hd__tapvpwrvgnd_1
X_4731_ _1770_ _1772_ VGND VGND VPWR VPWR _1773_ sky130_fd_sc_hd__or2_1
XFILLER_0_83_294 VGND VGND VPWR VPWR sky130_fd_sc_hd__fill_2
X_4662_ _1706_ _1707_ _1708_ VGND VGND VPWR VPWR _1710_ sky130_fd_sc_hd__a21oi_1
XFILLER_0_28_188 VGND VGND VPWR VPWR sky130_fd_sc_hd__fill_1
X_7450_ clknet_leaf_4_clk _0499_ VGND VGND VPWR VPWR u_pe_array.u_fifo2.buffer\[1\]\[2\]
+ sky130_fd_sc_hd__dfxtp_1
X_6401_ u_pe_array.u_fifo2.count\[3\] _3158_ VGND VGND VPWR VPWR _3162_ sky130_fd_sc_hd__or2_1
XANTENNA__4356__B1 _0914_ VGND VGND VPWR VPWR sky130_fd_sc_hd__diode_2
XFILLER_0_9_57 VGND VGND VPWR VPWR sky130_fd_sc_hd__fill_2
XFILLER_0_3_211 VGND VGND VPWR VPWR sky130_fd_sc_hd__fill_2
X_3613_ net680 _0834_ _0837_ _0843_ VGND VGND VPWR VPWR _0013_ sky130_fd_sc_hd__a22o_1
XFILLER_0_101_51 VGND VGND VPWR VPWR sky130_fd_sc_hd__decap_3
X_7381_ clknet_leaf_47_clk _0434_ net812 VGND VGND VPWR VPWR u_pe_array.g_pe_row\[0\].g_pe_col\[1\].u_pe.psum_out\[5\]
+ sky130_fd_sc_hd__dfrtp_1
X_4593_ net625 _1524_ _1258_ _1654_ VGND VGND VPWR VPWR _0182_ sky130_fd_sc_hd__a22o_1
X_6332_ _3114_ net523 _3110_ VGND VGND VPWR VPWR _3115_ sky130_fd_sc_hd__mux2_1
X_3544_ _0717_ _0719_ _0782_ VGND VGND VPWR VPWR _0790_ sky130_fd_sc_hd__and3b_1
XFILLER_0_10_60 VGND VGND VPWR VPWR sky130_fd_sc_hd__decap_4
XFILLER_0_3_255 VPWR VGND VPWR VGND sky130_ef_sc_hd__decap_12
X_6263_ _3053_ _3054_ VGND VGND VPWR VPWR _3055_ sky130_fd_sc_hd__xnor2_1
XANTENNA__7397__RESET_B net817 VGND VGND VPWR VPWR sky130_fd_sc_hd__diode_2
X_3475_ _0744_ VGND VGND VPWR VPWR net57 sky130_fd_sc_hd__buf_2
XANTENNA__4108__B1 _0837_ VGND VGND VPWR VPWR sky130_fd_sc_hd__diode_2
X_5214_ u_pe_array.g_pe_row\[1\].g_pe_col\[2\].u_pe.act_val\[1\] _2158_ VGND VGND
+ VPWR VPWR _2167_ sky130_fd_sc_hd__and2b_1
XANTENNA__7326__RESET_B net13 VGND VGND VPWR VPWR sky130_fd_sc_hd__diode_2
X_6194_ _2740_ _2990_ _2991_ _0866_ net410 VGND VGND VPWR VPWR _0446_ sky130_fd_sc_hd__a32o_1
XANTENNA__4068__C _1145_ VGND VGND VPWR VPWR sky130_fd_sc_hd__diode_2
X_5145_ u_pe_array.g_pe_row\[1\].g_pe_col\[3\].u_pe.psum_out\[7\] u_pe_array.g_pe_row\[1\].g_pe_col\[3\].u_pe.psum_out\[8\]
+ _2029_ VGND VGND VPWR VPWR _2118_ sky130_fd_sc_hd__o21a_1
X_5076_ _2046_ _2053_ _2055_ VGND VGND VPWR VPWR _2056_ sky130_fd_sc_hd__or3_1
X_4027_ _1183_ _1185_ VGND VGND VPWR VPWR _1187_ sky130_fd_sc_hd__or2_1
XANTENNA__4323__B_N _1407_ VGND VGND VPWR VPWR sky130_fd_sc_hd__diode_2
XFILLER_0_79_545 VGND VGND VPWR VPWR sky130_fd_sc_hd__fill_2
XANTENNA__6033__B1 _2592_ VGND VGND VPWR VPWR sky130_fd_sc_hd__diode_2
XANTENNA__5895__S _2469_ VGND VGND VPWR VPWR sky130_fd_sc_hd__diode_2
XANTENNA__6961__RESET_B net816 VGND VGND VPWR VPWR sky130_fd_sc_hd__diode_2
X_5978_ _2809_ _2813_ _2798_ VGND VGND VPWR VPWR _2814_ sky130_fd_sc_hd__mux2_1
XFILLER_0_19_100 VGND VGND VPWR VPWR sky130_fd_sc_hd__fill_2
X_4929_ u_pe_array.g_pe_row\[2\].g_pe_col\[0\].u_pe.psum_out\[9\] _1847_ VGND VGND
+ VPWR VPWR _1931_ sky130_fd_sc_hd__nand2_2
X_7648_ clknet_leaf_26_clk _0697_ VGND VGND VPWR VPWR u_pe_array.u_fifo1.buffer\[6\]\[6\]
+ sky130_fd_sc_hd__dfxtp_1
XFILLER_0_19_188 VGND VGND VPWR VPWR sky130_fd_sc_hd__fill_2
XFILLER_0_105_525 VGND VGND VPWR VPWR sky130_fd_sc_hd__decap_4
XFILLER_0_7_561 VPWR VGND VPWR VGND sky130_ef_sc_hd__decap_12
X_7579_ clknet_leaf_16_clk _0628_ VGND VGND VPWR VPWR u_pe_array.u_fifo1.buffer\[1\]\[2\]
+ sky130_fd_sc_hd__dfxtp_1
XFILLER_0_34_169 VGND VGND VPWR VPWR sky130_fd_sc_hd__decap_4
XFILLER_0_42_191 VGND VGND VPWR VPWR sky130_fd_sc_hd__fill_2
XANTENNA__7067__RESET_B net819 VGND VGND VPWR VPWR sky130_fd_sc_hd__diode_2
XFILLER_0_100_274 VGND VGND VPWR VPWR sky130_fd_sc_hd__fill_2
XFILLER_0_106_29 VPWR VGND VPWR VGND sky130_ef_sc_hd__decap_12
XANTENNA__6024__A0 net29 VGND VGND VPWR VPWR sky130_fd_sc_hd__diode_2
XFILLER_0_15_49 VGND VGND VPWR VPWR sky130_fd_sc_hd__decap_4
XFILLER_0_85_559 VGND VGND VPWR VPWR sky130_fd_sc_hd__fill_1
XFILLER_0_93_592 VGND VGND VPWR VPWR sky130_fd_sc_hd__decap_3
XFILLER_0_53_434 VGND VGND VPWR VPWR sky130_fd_sc_hd__fill_2
XFILLER_0_38_475 VGND VGND VPWR VPWR sky130_fd_sc_hd__fill_1
XFILLER_0_108_396 VGND VGND VPWR VPWR sky130_fd_sc_hd__fill_1
XFILLER_0_80_275 VGND VGND VPWR VPWR sky130_fd_sc_hd__fill_1
XFILLER_0_25_169 VGND VGND VPWR VPWR sky130_fd_sc_hd__fill_2
XANTENNA__5834__A _2611_ VGND VGND VPWR VPWR sky130_fd_sc_hd__diode_2
XFILLER_0_111_517 VPWR VGND VPWR VGND sky130_ef_sc_hd__decap_12
XFILLER_0_21_320 VGND VGND VPWR VPWR sky130_fd_sc_hd__fill_1
XANTENNA__5550__A2 _2144_ VGND VGND VPWR VPWR sky130_fd_sc_hd__diode_2
XFILLER_0_40_139 VGND VGND VPWR VPWR sky130_fd_sc_hd__fill_1
XANTENNA__3561__A1 net14 VGND VGND VPWR VPWR sky130_fd_sc_hd__diode_2
XFILLER_0_0_225 VPWR VGND VPWR VGND sky130_ef_sc_hd__decap_12
XANTENNA__6649__B _0833_ VGND VGND VPWR VPWR sky130_fd_sc_hd__diode_2
XTAP_504 VGND VPWR sky130_fd_sc_hd__tapvpwrvgnd_1
XTAP_515 VGND VPWR sky130_fd_sc_hd__tapvpwrvgnd_1
XTAP_526 VGND VPWR sky130_fd_sc_hd__tapvpwrvgnd_1
XTAP_537 VGND VPWR sky130_fd_sc_hd__tapvpwrvgnd_1
XTAP_548 VGND VPWR sky130_fd_sc_hd__tapvpwrvgnd_1
XTAP_559 VGND VPWR sky130_fd_sc_hd__tapvpwrvgnd_1
XFILLER_0_56_78 VGND VGND VPWR VPWR sky130_fd_sc_hd__decap_4
X_6950_ clknet_leaf_78_clk _0031_ net815 VGND VGND VPWR VPWR u_pe_array.g_pe_row\[3\].g_pe_col\[3\].u_pe.psum_out\[7\]
+ sky130_fd_sc_hd__dfrtp_4
XFILLER_0_22_9 VGND VGND VPWR VPWR sky130_fd_sc_hd__decap_3
X_5901_ u_pe_array.g_pe_row\[0\].g_pe_col\[2\].u_pe.w_reg\[1\] VGND VGND VPWR VPWR
+ _2743_ sky130_fd_sc_hd__clkbuf_8
XANTENNA__3616__A2 _0834_ VGND VGND VPWR VPWR sky130_fd_sc_hd__diode_2
XANTENNA__4813__A1 net5 VGND VGND VPWR VPWR sky130_fd_sc_hd__diode_2
XANTENNA_clkbuf_leaf_80_clk_A clknet_3_4__leaf_clk VGND VGND VPWR VPWR sky130_fd_sc_hd__diode_2
X_6881_ _3423_ VGND VGND VPWR VPWR _0701_ sky130_fd_sc_hd__clkbuf_1
XFILLER_0_72_44 VGND VGND VPWR VPWR sky130_fd_sc_hd__decap_8
X_5832_ _2692_ _2694_ net668 _0875_ VGND VGND VPWR VPWR _0381_ sky130_fd_sc_hd__a2bb2o_1
XFILLER_0_91_518 VGND VGND VPWR VPWR sky130_fd_sc_hd__decap_4
XFILLER_0_8_336 VGND VGND VPWR VPWR sky130_fd_sc_hd__fill_1
XANTENNA__4577__B1 _1536_ VGND VGND VPWR VPWR sky130_fd_sc_hd__diode_2
X_5763_ u_pe_array.g_pe_row\[0\].g_pe_col\[3\].u_pe.act_val\[2\] u_pe_array.g_pe_row\[0\].g_pe_col\[3\].u_pe.act_val\[3\]
+ u_pe_array.g_pe_row\[0\].g_pe_col\[3\].u_pe.w_reg\[0\] _2611_ VGND VGND VPWR VPWR
+ _2631_ sky130_fd_sc_hd__and4b_1
X_4714_ _1755_ _1757_ net723 _0916_ VGND VGND VPWR VPWR _0200_ sky130_fd_sc_hd__a2bb2o_1
XFILLER_0_16_103 VGND VGND VPWR VPWR sky130_fd_sc_hd__fill_2
XANTENNA__4124__S _0855_ VGND VGND VPWR VPWR sky130_fd_sc_hd__diode_2
XFILLER_0_29_486 VGND VGND VPWR VPWR sky130_fd_sc_hd__fill_1
X_7502_ clknet_leaf_4_clk _0551_ VGND VGND VPWR VPWR u_pe_array.u_fifo2.buffer\[5\]\[2\]
+ sky130_fd_sc_hd__dfxtp_1
X_5694_ _2478_ u_pe_array.g_pe_row\[1\].g_pe_col\[0\].u_pe.psum_out\[11\] VGND VGND
+ VPWR VPWR _2582_ sky130_fd_sc_hd__and2b_1
XANTENNA__6318__A1 _1787_ VGND VGND VPWR VPWR sky130_fd_sc_hd__diode_2
XFILLER_0_17_659 VPWR VGND VPWR VGND sky130_ef_sc_hd__decap_12
XFILLER_0_32_607 VGND VGND VPWR VPWR sky130_fd_sc_hd__decap_6
XFILLER_0_112_83 VGND VGND VPWR VPWR sky130_fd_sc_hd__fill_1
XANTENNA__3963__S _0755_ VGND VGND VPWR VPWR sky130_fd_sc_hd__diode_2
X_4645_ _1691_ _1693_ VGND VGND VPWR VPWR _1694_ sky130_fd_sc_hd__nand2_1
XFILLER_0_71_286 VGND VGND VPWR VPWR sky130_fd_sc_hd__fill_1
X_7433_ clknet_leaf_17_clk _0482_ net816 VGND VGND VPWR VPWR u_pe_array.u_fifo2.count\[2\]
+ sky130_fd_sc_hd__dfrtp_2
XFILLER_0_4_531 VGND VGND VPWR VPWR sky130_fd_sc_hd__fill_1
XFILLER_0_31_106 VGND VGND VPWR VPWR sky130_fd_sc_hd__decap_4
X_7364_ clknet_leaf_44_clk _0419_ net75 VGND VGND VPWR VPWR u_pe_array.g_pe_row\[0\].g_pe_col\[0\].u_pe.act_val\[3\]
+ sky130_fd_sc_hd__dfrtp_2
Xhold700 u_pe_array.g_pe_row\[3\].g_pe_col\[1\].u_pe.act_val\[5\] VGND VGND VPWR VPWR
+ net776 sky130_fd_sc_hd__dlygate4sd3_1
Xhold711 u_pe_array.g_pe_row\[2\].g_pe_col\[3\].u_pe.psum_out\[7\] VGND VGND VPWR
+ VPWR net787 sky130_fd_sc_hd__dlygate4sd3_1
X_4576_ _1273_ _1643_ _1644_ _1534_ net390 VGND VGND VPWR VPWR _0175_ sky130_fd_sc_hd__a32o_1
X_6315_ u_pe_array.g_pe_row\[0\].g_pe_col\[0\].u_pe.psum_out\[12\] _3094_ VGND VGND
+ VPWR VPWR _3101_ sky130_fd_sc_hd__xnor2_1
X_3527_ u_pe_array.g_pe_row\[1\].g_pe_col\[0\].u_pe.move_reg\[12\] _0770_ VGND VGND
+ VPWR VPWR _0777_ sky130_fd_sc_hd__or2_1
Xhold722 u_pe_array.g_pe_row\[2\].g_pe_col\[1\].u_pe.w_buffer\[1\] VGND VGND VPWR
+ VPWR net798 sky130_fd_sc_hd__dlygate4sd3_1
Xhold744 u_pe_array.g_pe_row\[3\].g_pe_col\[1\].u_pe.psum_out\[8\] VGND VGND VPWR
+ VPWR net828 sky130_fd_sc_hd__dlygate4sd3_1
Xhold733 u_pe_array.g_pe_row\[3\].g_pe_col\[2\].u_pe.move_reg\[7\] VGND VGND VPWR
+ VPWR net809 sky130_fd_sc_hd__dlygate4sd3_1
XFILLER_0_24_191 VGND VGND VPWR VPWR sky130_fd_sc_hd__fill_2
XFILLER_0_97_96 VGND VGND VPWR VPWR sky130_fd_sc_hd__decap_3
X_7295_ clknet_leaf_40_clk _0354_ net75 VGND VGND VPWR VPWR u_pe_array.g_pe_row\[1\].g_pe_col\[0\].u_pe.psum_out\[9\]
+ sky130_fd_sc_hd__dfrtp_2
XANTENNA__7160__RESET_B net814 VGND VGND VPWR VPWR sky130_fd_sc_hd__diode_2
X_6246_ _3036_ _3038_ VGND VGND VPWR VPWR _3039_ sky130_fd_sc_hd__xor2_1
XANTENNA_clkbuf_leaf_33_clk_A clknet_3_3__leaf_clk VGND VGND VPWR VPWR sky130_fd_sc_hd__diode_2
X_3458_ _0732_ VGND VGND VPWR VPWR net49 sky130_fd_sc_hd__clkbuf_4
X_6177_ _2971_ _2974_ _2979_ VGND VGND VPWR VPWR _2981_ sky130_fd_sc_hd__or3_1
XANTENNA__4794__S _1796_ VGND VGND VPWR VPWR sky130_fd_sc_hd__diode_2
XANTENNA__4501__B1 _0914_ VGND VGND VPWR VPWR sky130_fd_sc_hd__diode_2
X_5128_ _2094_ _2095_ u_pe_array.g_pe_row\[1\].g_pe_col\[3\].u_pe.psum_out\[7\] _2085_
+ VGND VGND VPWR VPWR _2103_ sky130_fd_sc_hd__o2bb2a_1
XANTENNA_clkbuf_leaf_48_clk_A clknet_3_7__leaf_clk VGND VGND VPWR VPWR sky130_fd_sc_hd__diode_2
X_5059_ u_pe_array.g_pe_row\[1\].g_pe_col\[3\].u_pe.act_val\[0\] VGND VGND VPWR VPWR
+ _2040_ sky130_fd_sc_hd__inv_2
XANTENNA__4804__A1 net2 VGND VGND VPWR VPWR sky130_fd_sc_hd__diode_2
XANTENNA__3607__A2 _0834_ VGND VGND VPWR VPWR sky130_fd_sc_hd__diode_2
XFILLER_0_94_301 VGND VGND VPWR VPWR sky130_fd_sc_hd__decap_6
XFILLER_0_79_397 VGND VGND VPWR VPWR sky130_fd_sc_hd__fill_2
XFILLER_0_67_559 VGND VGND VPWR VPWR sky130_fd_sc_hd__fill_1
XANTENNA__6557__A1 _1808_ VGND VGND VPWR VPWR sky130_fd_sc_hd__diode_2
XFILLER_0_109_116 VGND VGND VPWR VPWR sky130_fd_sc_hd__decap_4
XFILLER_0_109_105 VGND VGND VPWR VPWR sky130_fd_sc_hd__fill_2
XANTENNA__4568__B1 _0861_ VGND VGND VPWR VPWR sky130_fd_sc_hd__diode_2
XFILLER_0_82_529 VGND VGND VPWR VPWR sky130_fd_sc_hd__decap_3
XFILLER_0_90_540 VGND VGND VPWR VPWR sky130_fd_sc_hd__fill_2
XANTENNA__3791__A1 _0992_ VGND VGND VPWR VPWR sky130_fd_sc_hd__diode_2
XFILLER_0_7_391 VGND VGND VPWR VPWR sky130_fd_sc_hd__fill_1
XANTENNA__7248__RESET_B net75 VGND VGND VPWR VPWR sky130_fd_sc_hd__diode_2
XFILLER_0_50_437 VGND VGND VPWR VPWR sky130_fd_sc_hd__fill_1
XFILLER_0_22_117 VGND VGND VPWR VPWR sky130_fd_sc_hd__fill_2
XFILLER_0_22_139 VGND VGND VPWR VPWR sky130_fd_sc_hd__fill_1
XANTENNA__3543__A1 _0722_ VGND VGND VPWR VPWR sky130_fd_sc_hd__diode_2
XFILLER_0_15_191 VPWR VGND VPWR VGND sky130_ef_sc_hd__decap_12
XFILLER_0_31_662 VGND VGND VPWR VPWR sky130_fd_sc_hd__fill_2
XFILLER_0_31_673 VGND VGND VPWR VPWR sky130_fd_sc_hd__fill_1
XFILLER_0_30_161 VGND VGND VPWR VPWR sky130_fd_sc_hd__decap_4
XFILLER_0_30_183 VGND VGND VPWR VPWR sky130_fd_sc_hd__fill_2
XANTENNA__5296__A1 _0914_ VGND VGND VPWR VPWR sky130_fd_sc_hd__diode_2
XFILLER_0_101_594 VGND VGND VPWR VPWR sky130_fd_sc_hd__decap_6
XFILLER_0_89_128 VGND VGND VPWR VPWR sky130_fd_sc_hd__decap_8
XFILLER_0_89_106 VGND VGND VPWR VPWR sky130_fd_sc_hd__fill_2
Xhold82 u_pe_array.g_pe_row\[1\].g_pe_col\[2\].u_pe.move_reg\[10\] VGND VGND VPWR
+ VPWR net158 sky130_fd_sc_hd__dlygate4sd3_1
Xhold71 u_pe_array.g_pe_row\[1\].g_pe_col\[2\].u_pe.move_reg\[8\] VGND VGND VPWR VPWR
+ net147 sky130_fd_sc_hd__dlygate4sd3_1
Xhold60 u_pe_array.g_pe_row\[0\].g_pe_col\[3\].u_pe.move_reg\[9\] VGND VGND VPWR VPWR
+ net136 sky130_fd_sc_hd__dlygate4sd3_1
XFILLER_0_89_139 VGND VGND VPWR VPWR sky130_fd_sc_hd__fill_2
Xhold93 _0399_ VGND VGND VPWR VPWR net169 sky130_fd_sc_hd__dlygate4sd3_1
XFILLER_0_26_59 VGND VGND VPWR VPWR sky130_fd_sc_hd__decap_6
XFILLER_0_97_161 VGND VGND VPWR VPWR sky130_fd_sc_hd__fill_2
XFILLER_0_58_548 VGND VGND VPWR VPWR sky130_fd_sc_hd__decap_3
XFILLER_0_85_367 VGND VGND VPWR VPWR sky130_fd_sc_hd__fill_2
XFILLER_0_42_58 VGND VGND VPWR VPWR sky130_fd_sc_hd__fill_2
XANTENNA__3782__A1 _0986_ VGND VGND VPWR VPWR sky130_fd_sc_hd__diode_2
XANTENNA__5564__A _0729_ VGND VGND VPWR VPWR sky130_fd_sc_hd__diode_2
X_4430_ u_pe_array.g_pe_row\[3\].g_pe_col\[1\].u_pe.psum_out\[3\] u_pe_array.g_pe_row\[3\].g_pe_col\[1\].u_pe.act_val\[3\]
+ _0769_ VGND VGND VPWR VPWR _1520_ sky130_fd_sc_hd__mux2_1
XFILLER_0_53_286 VGND VGND VPWR VPWR sky130_fd_sc_hd__fill_2
XFILLER_0_22_640 VGND VGND VPWR VPWR sky130_fd_sc_hd__fill_2
X_6100_ _2907_ _2908_ _2909_ VGND VGND VPWR VPWR _2911_ sky130_fd_sc_hd__a21oi_1
X_4361_ _1407_ _1461_ u_pe_array.g_pe_row\[2\].g_pe_col\[3\].u_pe.psum_out\[6\] VGND
+ VGND VPWR VPWR _1463_ sky130_fd_sc_hd__a21o_1
XFILLER_0_21_150 VGND VGND VPWR VPWR sky130_fd_sc_hd__decap_3
X_7080_ clknet_leaf_14_clk _0153_ net816 VGND VGND VPWR VPWR u_pe_array.g_pe_row\[2\].g_pe_col\[1\].u_pe.act_val\[2\]
+ sky130_fd_sc_hd__dfrtp_2
XFILLER_0_67_55 VGND VGND VPWR VPWR sky130_fd_sc_hd__fill_1
XTAP_323 VGND VPWR sky130_fd_sc_hd__tapvpwrvgnd_1
XTAP_312 VGND VPWR sky130_fd_sc_hd__tapvpwrvgnd_1
XTAP_301 VGND VPWR sky130_fd_sc_hd__tapvpwrvgnd_1
X_4292_ net130 _1392_ _1402_ _1399_ VGND VGND VPWR VPWR _0133_ sky130_fd_sc_hd__a22o_1
X_6031_ net782 _2738_ _2592_ _2857_ VGND VGND VPWR VPWR _0417_ sky130_fd_sc_hd__a22o_1
XTAP_367 VGND VPWR sky130_fd_sc_hd__tapvpwrvgnd_1
XTAP_356 VGND VPWR sky130_fd_sc_hd__tapvpwrvgnd_1
XTAP_345 VGND VPWR sky130_fd_sc_hd__tapvpwrvgnd_1
XTAP_334 VGND VPWR sky130_fd_sc_hd__tapvpwrvgnd_1
XTAP_389 VGND VPWR sky130_fd_sc_hd__tapvpwrvgnd_1
XTAP_378 VGND VPWR sky130_fd_sc_hd__tapvpwrvgnd_1
XANTENNA__5039__B2 _1665_ VGND VGND VPWR VPWR sky130_fd_sc_hd__diode_2
XFILLER_0_89_673 VGND VGND VPWR VPWR sky130_fd_sc_hd__fill_2
XPHY_18 VGND VGND VPWR VPWR sky130_fd_sc_hd__decap_3
XPHY_29 VGND VGND VPWR VPWR sky130_fd_sc_hd__decap_3
X_6933_ clknet_leaf_87_clk _0016_ net819 VGND VGND VPWR VPWR u_pe_array.g_pe_row\[3\].g_pe_col\[2\].u_pe.act_val\[5\]
+ sky130_fd_sc_hd__dfrtp_1
XANTENNA__3958__S _0819_ VGND VGND VPWR VPWR sky130_fd_sc_hd__diode_2
X_6864_ net459 _3114_ _3412_ VGND VGND VPWR VPWR _3415_ sky130_fd_sc_hd__mux2_1
XFILLER_0_76_334 VGND VGND VPWR VPWR sky130_fd_sc_hd__fill_2
XANTENNA__6539__A1 _1818_ VGND VGND VPWR VPWR sky130_fd_sc_hd__diode_2
X_5815_ _2670_ _2675_ _2678_ VGND VGND VPWR VPWR _2679_ sky130_fd_sc_hd__o21ai_1
XFILLER_0_107_609 VGND VGND VPWR VPWR sky130_fd_sc_hd__decap_6
X_6795_ net336 _3130_ _3366_ VGND VGND VPWR VPWR _3377_ sky130_fd_sc_hd__mux2_1
XFILLER_0_91_337 VGND VGND VPWR VPWR sky130_fd_sc_hd__fill_2
XFILLER_0_76_389 VGND VGND VPWR VPWR sky130_fd_sc_hd__decap_3
XFILLER_0_29_294 VGND VGND VPWR VPWR sky130_fd_sc_hd__fill_2
X_5746_ u_pe_array.g_pe_row\[0\].g_pe_col\[3\].u_pe.psum_out\[1\] _2614_ VGND VGND
+ VPWR VPWR _2616_ sky130_fd_sc_hd__nand2_1
X_5677_ u_pe_array.g_pe_row\[1\].g_pe_col\[0\].u_pe.psum_out\[8\] u_pe_array.g_pe_row\[1\].g_pe_col\[0\].u_pe.psum_out\[9\]
+ _2478_ VGND VGND VPWR VPWR _2567_ sky130_fd_sc_hd__and3_1
XFILLER_0_114_141 VGND VGND VPWR VPWR sky130_fd_sc_hd__decap_3
XFILLER_0_114_130 VGND VGND VPWR VPWR sky130_fd_sc_hd__decap_4
X_7416_ clknet_leaf_30_clk _0465_ VGND VGND VPWR VPWR u_pe_array.u_fifo1.buffer\[8\]\[6\]
+ sky130_fd_sc_hd__dfxtp_1
X_4628_ _1669_ _1674_ VGND VGND VPWR VPWR _1678_ sky130_fd_sc_hd__and2_1
XANTENNA__7341__RESET_B net812 VGND VGND VPWR VPWR sky130_fd_sc_hd__diode_2
Xhold530 u_pe_array.g_pe_row\[0\].g_pe_col\[1\].u_pe.act_val\[0\] VGND VGND VPWR VPWR
+ net606 sky130_fd_sc_hd__dlygate4sd3_1
Xhold541 u_pe_array.g_pe_row\[1\].g_pe_col\[0\].u_pe.psum_out\[2\] VGND VGND VPWR
+ VPWR net617 sky130_fd_sc_hd__dlygate4sd3_1
Xhold563 u_pe_array.g_pe_row\[1\].g_pe_col\[2\].u_pe.psum_out\[7\] VGND VGND VPWR
+ VPWR net639 sky130_fd_sc_hd__dlygate4sd3_1
Xhold552 u_pe_array.g_pe_row\[0\].g_pe_col\[2\].u_pe.psum_out\[6\] VGND VGND VPWR
+ VPWR net628 sky130_fd_sc_hd__dlygate4sd3_1
X_7347_ clknet_leaf_62_clk _0402_ net818 VGND VGND VPWR VPWR u_pe_array.g_pe_row\[0\].g_pe_col\[2\].u_pe.psum_out\[1\]
+ sky130_fd_sc_hd__dfrtp_2
XFILLER_0_12_150 VGND VGND VPWR VPWR sky130_fd_sc_hd__fill_1
XFILLER_0_13_673 VGND VGND VPWR VPWR sky130_fd_sc_hd__decap_4
X_4559_ _1608_ _1611_ _1616_ _1628_ VGND VGND VPWR VPWR _1629_ sky130_fd_sc_hd__a211o_1
Xhold585 u_pe_array.g_pe_row\[1\].g_pe_col\[0\].u_pe.psum_out\[5\] VGND VGND VPWR
+ VPWR net661 sky130_fd_sc_hd__dlygate4sd3_1
Xhold574 u_pe_array.g_pe_row\[3\].g_pe_col\[3\].u_pe.move_reg\[7\] VGND VGND VPWR
+ VPWR net650 sky130_fd_sc_hd__dlygate4sd3_1
X_7278_ clknet_leaf_69_clk net140 net814 VGND VGND VPWR VPWR u_pe_array.g_pe_row\[0\].g_pe_col\[3\].u_pe.move_reg\[7\]
+ sky130_fd_sc_hd__dfrtp_1
Xhold596 u_pe_array.g_pe_row\[0\].g_pe_col\[3\].u_pe.psum_out\[2\] VGND VGND VPWR
+ VPWR net672 sky130_fd_sc_hd__dlygate4sd3_1
XFILLER_0_110_391 VGND VGND VPWR VPWR sky130_fd_sc_hd__decap_3
X_6229_ u_pe_array.g_pe_row\[0\].g_pe_col\[0\].u_pe.act_val\[3\] VGND VGND VPWR VPWR
+ _3023_ sky130_fd_sc_hd__inv_2
XANTENNA__5640__C _2478_ VGND VGND VPWR VPWR sky130_fd_sc_hd__diode_2
XFILLER_0_99_437 VGND VGND VPWR VPWR sky130_fd_sc_hd__decap_3
XTAP_890 VGND VPWR sky130_fd_sc_hd__tapvpwrvgnd_1
XFILLER_0_95_632 VGND VGND VPWR VPWR sky130_fd_sc_hd__fill_2
XFILLER_0_95_621 VGND VGND VPWR VPWR sky130_fd_sc_hd__decap_4
XFILLER_0_67_345 VGND VGND VPWR VPWR sky130_fd_sc_hd__fill_2
XFILLER_0_55_518 VGND VGND VPWR VPWR sky130_fd_sc_hd__decap_8
XANTENNA__5202__A1 _1725_ VGND VGND VPWR VPWR sky130_fd_sc_hd__diode_2
XANTENNA__7429__RESET_B net74 VGND VGND VPWR VPWR sky130_fd_sc_hd__diode_2
XFILLER_0_35_220 VGND VGND VPWR VPWR sky130_fd_sc_hd__fill_2
XANTENNA__3764__B2 _0916_ VGND VGND VPWR VPWR sky130_fd_sc_hd__diode_2
XFILLER_0_63_595 VGND VGND VPWR VPWR sky130_fd_sc_hd__fill_1
XANTENNA__7082__RESET_B net816 VGND VGND VPWR VPWR sky130_fd_sc_hd__diode_2
XANTENNA__7011__RESET_B net818 VGND VGND VPWR VPWR sky130_fd_sc_hd__diode_2
XANTENNA__3602__A1_N _0729_ VGND VGND VPWR VPWR sky130_fd_sc_hd__diode_2
Xoutput61 net61 VGND VGND VPWR VPWR psum_out1[9] sky130_fd_sc_hd__clkbuf_4
Xoutput50 net50 VGND VGND VPWR VPWR psum_out1[10] sky130_fd_sc_hd__clkbuf_4
XANTENNA_max_cap71_A _0913_ VGND VGND VPWR VPWR sky130_fd_sc_hd__diode_2
XANTENNA__3819__A2 _1009_ VGND VGND VPWR VPWR sky130_fd_sc_hd__diode_2
XFILLER_0_37_69 VGND VGND VPWR VPWR sky130_fd_sc_hd__fill_2
XFILLER_0_86_621 VGND VGND VPWR VPWR sky130_fd_sc_hd__fill_1
XFILLER_0_58_301 VGND VGND VPWR VPWR sky130_fd_sc_hd__decap_4
XFILLER_0_53_57 VGND VGND VPWR VPWR sky130_fd_sc_hd__fill_1
X_3930_ u_pe_array.g_pe_row\[3\].g_pe_col\[2\].u_pe.psum_out\[11\] _1009_ VGND VGND
+ VPWR VPWR _1111_ sky130_fd_sc_hd__and2b_1
XFILLER_0_73_304 VGND VGND VPWR VPWR sky130_fd_sc_hd__fill_2
X_3861_ _1047_ _1048_ VGND VGND VPWR VPWR _1049_ sky130_fd_sc_hd__nand2_1
X_5600_ u_pe_array.g_pe_row\[1\].g_pe_col\[0\].u_pe.act_val\[1\] u_pe_array.g_pe_row\[1\].g_pe_col\[0\].u_pe.psum_out\[2\]
+ _2478_ VGND VGND VPWR VPWR _2496_ sky130_fd_sc_hd__and3b_1
XFILLER_0_73_337 VGND VGND VPWR VPWR sky130_fd_sc_hd__decap_3
X_3792_ net645 _0834_ _0837_ _0993_ VGND VGND VPWR VPWR _0042_ sky130_fd_sc_hd__a22o_1
X_6580_ _3258_ VGND VGND VPWR VPWR _0565_ sky130_fd_sc_hd__clkbuf_1
XANTENNA__4952__B1 _1534_ VGND VGND VPWR VPWR sky130_fd_sc_hd__diode_2
X_5531_ _0914_ _2446_ _2447_ _0861_ _2443_ VGND VGND VPWR VPWR _0327_ sky130_fd_sc_hd__o32ai_1
XFILLER_0_6_637 VGND VGND VPWR VPWR sky130_fd_sc_hd__decap_6
XFILLER_0_5_125 VPWR VGND VPWR VGND sky130_ef_sc_hd__decap_12
XFILLER_0_112_601 VPWR VGND VPWR VGND sky130_ef_sc_hd__decap_12
XFILLER_0_5_169 VPWR VGND VPWR VGND sky130_ef_sc_hd__decap_12
XFILLER_0_26_286 VGND VGND VPWR VPWR sky130_fd_sc_hd__fill_1
XFILLER_0_41_212 VGND VGND VPWR VPWR sky130_fd_sc_hd__decap_3
XFILLER_0_41_223 VGND VGND VPWR VPWR sky130_fd_sc_hd__fill_1
X_5462_ _2375_ _2384_ VGND VGND VPWR VPWR _2385_ sky130_fd_sc_hd__nor2_1
XFILLER_0_75_7 VPWR VGND VPWR VGND sky130_ef_sc_hd__decap_12
X_7201_ clknet_leaf_69_clk _0266_ net814 VGND VGND VPWR VPWR u_pe_array.g_pe_row\[1\].g_pe_col\[3\].u_pe.psum_out\[5\]
+ sky130_fd_sc_hd__dfrtp_1
XFILLER_0_112_645 VPWR VGND VPWR VGND sky130_ef_sc_hd__decap_12
XFILLER_0_111_122 VGND VGND VPWR VPWR sky130_fd_sc_hd__decap_3
X_5393_ u_pe_array.u_fifo1.buffer\[3\]\[5\] _2282_ _2283_ u_pe_array.u_fifo1.buffer\[2\]\[5\]
+ _2327_ VGND VGND VPWR VPWR _2328_ sky130_fd_sc_hd__a221o_1
X_4413_ _1500_ _1502_ _1508_ VGND VGND VPWR VPWR _1510_ sky130_fd_sc_hd__or3_1
X_7132_ clknet_leaf_13_clk _0201_ net816 VGND VGND VPWR VPWR u_pe_array.g_pe_row\[2\].g_pe_col\[1\].u_pe.psum_out\[9\]
+ sky130_fd_sc_hd__dfrtp_2
X_4344_ _1444_ _1446_ VGND VGND VPWR VPWR _1448_ sky130_fd_sc_hd__or2_1
XANTENNA__6329__S _3110_ VGND VGND VPWR VPWR sky130_fd_sc_hd__diode_2
X_7063_ clknet_leaf_90_clk _0136_ net819 VGND VGND VPWR VPWR u_pe_array.g_pe_row\[2\].g_pe_col\[3\].u_pe.psum_out\[0\]
+ sky130_fd_sc_hd__dfrtp_1
X_6014_ _2743_ u_pe_array.g_pe_row\[0\].g_pe_col\[2\].u_pe.psum_out\[11\] VGND VGND
+ VPWR VPWR _2846_ sky130_fd_sc_hd__and2b_1
X_4275_ net677 _1392_ _1258_ _1393_ VGND VGND VPWR VPWR _0125_ sky130_fd_sc_hd__a22o_1
XFILLER_0_68_109 VGND VGND VPWR VPWR sky130_fd_sc_hd__fill_2
XTAP_1319 VGND VPWR sky130_fd_sc_hd__tapvpwrvgnd_1
XTAP_1308 VGND VPWR sky130_fd_sc_hd__tapvpwrvgnd_1
XFILLER_0_49_334 VGND VGND VPWR VPWR sky130_fd_sc_hd__fill_2
XFILLER_0_49_312 VGND VGND VPWR VPWR sky130_fd_sc_hd__fill_2
XFILLER_0_49_301 VGND VGND VPWR VPWR sky130_fd_sc_hd__decap_4
X_6916_ clknet_leaf_59_clk _0002_ net813 VGND VGND VPWR VPWR u_fsm.cnt\[2\] sky130_fd_sc_hd__dfrtp_1
X_6847_ _3405_ VGND VGND VPWR VPWR _0685_ sky130_fd_sc_hd__clkbuf_1
XFILLER_0_9_442 VGND VGND VPWR VPWR sky130_fd_sc_hd__fill_2
XFILLER_0_37_518 VGND VGND VPWR VPWR sky130_fd_sc_hd__decap_3
X_6778_ _3368_ VGND VGND VPWR VPWR _0653_ sky130_fd_sc_hd__clkbuf_1
XFILLER_0_92_668 VGND VGND VPWR VPWR sky130_fd_sc_hd__fill_2
XFILLER_0_76_197 VGND VGND VPWR VPWR sky130_fd_sc_hd__decap_3
XANTENNA__5735__A2 _2600_ VGND VGND VPWR VPWR sky130_fd_sc_hd__diode_2
XFILLER_0_45_573 VGND VGND VPWR VPWR sky130_fd_sc_hd__decap_6
X_5729_ net244 _2600_ _2603_ _2336_ VGND VGND VPWR VPWR _0369_ sky130_fd_sc_hd__a22o_1
XFILLER_0_103_601 VPWR VGND VPWR VGND sky130_ef_sc_hd__decap_12
XANTENNA__5408__S _1661_ VGND VGND VPWR VPWR sky130_fd_sc_hd__diode_2
XANTENNA__3717__A u_pe_array.g_pe_row\[3\].g_pe_col\[3\].u_pe.act_val\[5\] VGND VGND
+ VPWR VPWR sky130_fd_sc_hd__diode_2
XANTENNA__4820__B _0833_ VGND VGND VPWR VPWR sky130_fd_sc_hd__diode_2
XFILLER_0_20_429 VGND VGND VPWR VPWR sky130_fd_sc_hd__fill_2
Xhold371 u_pe_array.u_fifo1.buffer\[5\]\[0\] VGND VGND VPWR VPWR net447 sky130_fd_sc_hd__dlygate4sd3_1
Xhold360 u_pe_array.g_pe_row\[3\].g_pe_col\[1\].u_pe.psum_out\[12\] VGND VGND VPWR
+ VPWR net436 sky130_fd_sc_hd__dlygate4sd3_1
Xhold393 u_pe_array.u_fifo1.buffer\[5\]\[1\] VGND VGND VPWR VPWR net469 sky130_fd_sc_hd__dlygate4sd3_1
Xhold382 u_pe_array.u_fifo1.buffer\[2\]\[4\] VGND VGND VPWR VPWR net458 sky130_fd_sc_hd__dlygate4sd3_1
XFILLER_0_99_201 VGND VGND VPWR VPWR sky130_fd_sc_hd__decap_3
XFILLER_0_99_234 VGND VGND VPWR VPWR sky130_fd_sc_hd__fill_2
XANTENNA__4474__A2 _1152_ VGND VGND VPWR VPWR sky130_fd_sc_hd__diode_2
XANTENNA__4982__S _0756_ VGND VGND VPWR VPWR sky130_fd_sc_hd__diode_2
XANTENNA__5379__A _1787_ VGND VGND VPWR VPWR sky130_fd_sc_hd__diode_2
XFILLER_0_68_621 VGND VGND VPWR VPWR sky130_fd_sc_hd__fill_1
XFILLER_0_114_29 VPWR VGND VPWR VGND sky130_ef_sc_hd__decap_12
XFILLER_0_68_654 VGND VGND VPWR VPWR sky130_fd_sc_hd__decap_3
XFILLER_0_67_186 VGND VGND VPWR VPWR sky130_fd_sc_hd__decap_4
XANTENNA__7263__RESET_B net812 VGND VGND VPWR VPWR sky130_fd_sc_hd__diode_2
XFILLER_0_55_337 VGND VGND VPWR VPWR sky130_fd_sc_hd__decap_4
XANTENNA__4934__B1 _0885_ VGND VGND VPWR VPWR sky130_fd_sc_hd__diode_2
XFILLER_0_70_307 VGND VGND VPWR VPWR sky130_fd_sc_hd__fill_1
XFILLER_0_63_381 VGND VGND VPWR VPWR sky130_fd_sc_hd__decap_8
XFILLER_0_106_472 VGND VGND VPWR VPWR sky130_fd_sc_hd__decap_4
XFILLER_0_3_629 VPWR VGND VPWR VGND sky130_ef_sc_hd__decap_12
XFILLER_0_23_234 VGND VGND VPWR VPWR sky130_fd_sc_hd__fill_2
XFILLER_0_11_407 VGND VGND VPWR VPWR sky130_fd_sc_hd__decap_4
XFILLER_0_2_139 VGND VGND VPWR VPWR sky130_fd_sc_hd__fill_1
XFILLER_0_48_46 VGND VGND VPWR VPWR sky130_fd_sc_hd__fill_2
X_4060_ _1170_ _1183_ _1184_ _1215_ VGND VGND VPWR VPWR _1216_ sky130_fd_sc_hd__or4_1
XFILLER_0_3_15 VPWR VGND VPWR VGND sky130_ef_sc_hd__decap_12
XANTENNA__5414__A1 u_pe_array.g_pe_row\[1\].g_pe_col\[1\].u_pe.w_reg\[0\] VGND VGND
+ VPWR VPWR sky130_fd_sc_hd__diode_2
XFILLER_0_58_131 VGND VGND VPWR VPWR sky130_fd_sc_hd__fill_1
X_4962_ u_pe_array.u_fifo2.rd_ptr\[3\] VGND VGND VPWR VPWR _1958_ sky130_fd_sc_hd__inv_2
X_4893_ net683 _1714_ _1897_ _1898_ VGND VGND VPWR VPWR _0238_ sky130_fd_sc_hd__a22o_1
X_6701_ _3328_ VGND VGND VPWR VPWR _0616_ sky130_fd_sc_hd__clkbuf_1
X_3913_ u_pe_array.g_pe_row\[3\].g_pe_col\[2\].u_pe.psum_out\[9\] _1009_ VGND VGND
+ VPWR VPWR _1096_ sky130_fd_sc_hd__nand2_1
X_6632_ u_pe_array.g_pe_row\[3\].g_pe_col\[3\].u_pe.act_val\[2\] _2738_ _0836_ _3285_
+ VGND VGND VPWR VPWR _0590_ sky130_fd_sc_hd__a22o_1
X_3844_ _1031_ _1032_ VGND VGND VPWR VPWR _1033_ sky130_fd_sc_hd__nor2_1
X_6563_ net311 _1814_ _3239_ VGND VGND VPWR VPWR _3249_ sky130_fd_sc_hd__mux2_1
X_3775_ _0981_ _0982_ VGND VGND VPWR VPWR _0983_ sky130_fd_sc_hd__xnor2_1
XFILLER_0_42_521 VGND VGND VPWR VPWR sky130_fd_sc_hd__decap_4
XFILLER_0_89_53 VGND VGND VPWR VPWR sky130_fd_sc_hd__decap_3
X_5514_ _2430_ _2431_ VGND VGND VPWR VPWR _2432_ sky130_fd_sc_hd__nor2_1
XANTENNA__6986__RESET_B net816 VGND VGND VPWR VPWR sky130_fd_sc_hd__diode_2
XFILLER_0_6_489 VPWR VGND VPWR VGND sky130_ef_sc_hd__decap_12
XFILLER_0_14_234 VGND VGND VPWR VPWR sky130_fd_sc_hd__decap_4
XANTENNA__4132__S _0855_ VGND VGND VPWR VPWR sky130_fd_sc_hd__diode_2
X_6494_ net479 _1802_ _3208_ VGND VGND VPWR VPWR _3212_ sky130_fd_sc_hd__mux2_1
XFILLER_0_42_543 VGND VGND VPWR VPWR sky130_fd_sc_hd__decap_8
XFILLER_0_112_442 VPWR VGND VPWR VGND sky130_ef_sc_hd__decap_12
X_5445_ u_pe_array.g_pe_row\[1\].g_pe_col\[1\].u_pe.w_reg\[0\] u_pe_array.g_pe_row\[1\].g_pe_col\[1\].u_pe.act_val\[2\]
+ _2354_ VGND VGND VPWR VPWR _2369_ sky130_fd_sc_hd__and3_1
XANTENNA__6915__RESET_B net813 VGND VGND VPWR VPWR sky130_fd_sc_hd__diode_2
XFILLER_0_42_576 VGND VGND VPWR VPWR sky130_fd_sc_hd__fill_2
XFILLER_0_66_3 VPWR VGND VPWR VGND sky130_ef_sc_hd__decap_12
X_5376_ u_pe_array.u_fifo1.buffer\[1\]\[3\] _2278_ _2310_ _2312_ VGND VGND VPWR VPWR
+ _2313_ sky130_fd_sc_hd__a211o_1
X_7115_ clknet_leaf_13_clk _0186_ net816 VGND VGND VPWR VPWR u_pe_array.g_pe_row\[2\].g_pe_col\[0\].u_pe.move_reg\[7\]
+ sky130_fd_sc_hd__dfrtp_1
X_4327_ _1425_ _1426_ _1430_ VGND VGND VPWR VPWR _1432_ sky130_fd_sc_hd__o21ai_1
XANTENNA__4368__A _0914_ VGND VGND VPWR VPWR sky130_fd_sc_hd__diode_2
X_4258_ _1373_ _1376_ _1381_ VGND VGND VPWR VPWR _1383_ sky130_fd_sc_hd__or3_1
X_7046_ clknet_leaf_76_clk _0121_ net815 VGND VGND VPWR VPWR u_pe_array.g_pe_row\[2\].g_pe_col\[3\].u_pe.w_buffer\[0\]
+ sky130_fd_sc_hd__dfrtp_1
X_4189_ u_pe_array.g_pe_row\[3\].g_pe_col\[0\].u_pe.psum_out\[5\] _1319_ VGND VGND
+ VPWR VPWR _1320_ sky130_fd_sc_hd__xnor2_1
XFILLER_0_96_215 VGND VGND VPWR VPWR sky130_fd_sc_hd__decap_4
XANTENNA__5405__B2 _2336_ VGND VGND VPWR VPWR sky130_fd_sc_hd__diode_2
XTAP_1105 VGND VPWR sky130_fd_sc_hd__tapvpwrvgnd_1
XTAP_1138 VGND VPWR sky130_fd_sc_hd__tapvpwrvgnd_1
XTAP_1116 VGND VPWR sky130_fd_sc_hd__tapvpwrvgnd_1
XTAP_1127 VGND VPWR sky130_fd_sc_hd__tapvpwrvgnd_1
XTAP_1149 VGND VPWR sky130_fd_sc_hd__tapvpwrvgnd_1
XFILLER_0_92_443 VGND VGND VPWR VPWR sky130_fd_sc_hd__fill_2
XFILLER_0_92_421 VGND VGND VPWR VPWR sky130_fd_sc_hd__fill_2
XFILLER_0_37_337 VGND VGND VPWR VPWR sky130_fd_sc_hd__fill_2
XFILLER_0_80_616 VGND VGND VPWR VPWR sky130_fd_sc_hd__fill_2
XANTENNA__3447__A _0722_ VGND VGND VPWR VPWR sky130_fd_sc_hd__diode_2
XFILLER_0_18_584 VGND VGND VPWR VPWR sky130_fd_sc_hd__decap_4
XFILLER_0_18_595 VGND VGND VPWR VPWR sky130_fd_sc_hd__fill_1
XFILLER_0_60_340 VGND VGND VPWR VPWR sky130_fd_sc_hd__fill_2
XFILLER_0_33_543 VGND VGND VPWR VPWR sky130_fd_sc_hd__decap_6
XFILLER_0_60_384 VGND VGND VPWR VPWR sky130_fd_sc_hd__fill_2
XFILLER_0_60_362 VGND VGND VPWR VPWR sky130_fd_sc_hd__fill_2
XFILLER_0_103_475 VGND VGND VPWR VPWR sky130_fd_sc_hd__fill_2
XFILLER_0_20_259 VGND VGND VPWR VPWR sky130_fd_sc_hd__fill_2
Xhold190 u_pe_array.u_fifo1.buffer\[0\]\[9\] VGND VGND VPWR VPWR net266 sky130_fd_sc_hd__dlygate4sd3_1
XANTENNA__4709__C _1672_ VGND VGND VPWR VPWR sky130_fd_sc_hd__diode_2
XFILLER_0_87_237 VGND VGND VPWR VPWR sky130_fd_sc_hd__fill_2
XANTENNA__3958__A1 _1130_ VGND VGND VPWR VPWR sky130_fd_sc_hd__diode_2
XFILLER_0_95_292 VGND VGND VPWR VPWR sky130_fd_sc_hd__fill_2
XANTENNA__4080__B1 _1145_ VGND VGND VPWR VPWR sky130_fd_sc_hd__diode_2
XFILLER_0_50_58 VGND VGND VPWR VPWR sky130_fd_sc_hd__fill_2
XFILLER_0_71_649 VGND VGND VPWR VPWR sky130_fd_sc_hd__fill_2
XFILLER_0_70_104 VGND VGND VPWR VPWR sky130_fd_sc_hd__fill_1
XFILLER_0_55_178 VGND VGND VPWR VPWR sky130_fd_sc_hd__fill_1
X_3560_ _0726_ _0780_ _0804_ VGND VGND VPWR VPWR _0805_ sky130_fd_sc_hd__a21o_1
XFILLER_0_3_426 VGND VGND VPWR VPWR sky130_fd_sc_hd__fill_2
XFILLER_0_24_565 VGND VGND VPWR VPWR sky130_fd_sc_hd__decap_3
X_3491_ u_pe_array.g_pe_row\[3\].g_pe_col\[0\].u_pe.psum_out\[12\] _0745_ _0753_ _0728_
+ VGND VGND VPWR VPWR net52 sky130_fd_sc_hd__o211a_2
XANTENNA__3791__S _0754_ VGND VGND VPWR VPWR sky130_fd_sc_hd__diode_2
X_5230_ u_pe_array.g_pe_row\[1\].g_pe_col\[2\].u_pe.psum_out\[3\] _2181_ VGND VGND
+ VPWR VPWR _2182_ sky130_fd_sc_hd__xor2_1
XANTENNA__5883__B2 _0722_ VGND VGND VPWR VPWR sky130_fd_sc_hd__diode_2
XFILLER_0_52_9 VGND VGND VPWR VPWR sky130_fd_sc_hd__fill_2
X_5161_ _2123_ _2125_ _2131_ VGND VGND VPWR VPWR _2133_ sky130_fd_sc_hd__or3_1
X_5092_ _0865_ VGND VGND VPWR VPWR _2071_ sky130_fd_sc_hd__buf_8
XFILLER_0_75_55 VGND VGND VPWR VPWR sky130_fd_sc_hd__fill_1
X_4112_ u_pe_array.g_pe_row\[3\].g_pe_col\[3\].u_pe.psum_out\[2\] u_pe_array.g_pe_row\[3\].g_pe_col\[3\].u_pe.act_val\[2\]
+ _0769_ VGND VGND VPWR VPWR _1259_ sky130_fd_sc_hd__mux2_1
XFILLER_0_75_77 VGND VGND VPWR VPWR sky130_fd_sc_hd__fill_2
X_4043_ _1145_ _1200_ u_pe_array.g_pe_row\[3\].g_pe_col\[1\].u_pe.psum_out\[6\] VGND
+ VGND VPWR VPWR _1201_ sky130_fd_sc_hd__nand3_2
XANTENNA__6607__S _3269_ VGND VGND VPWR VPWR sky130_fd_sc_hd__diode_2
XFILLER_0_78_204 VGND VGND VPWR VPWR sky130_fd_sc_hd__fill_2
XANTENNA__7185__RESET_B net73 VGND VGND VPWR VPWR sky130_fd_sc_hd__diode_2
X_5994_ _2818_ _2820_ _2821_ _2827_ _0913_ VGND VGND VPWR VPWR _2829_ sky130_fd_sc_hd__a41o_1
XFILLER_0_93_229 VGND VGND VPWR VPWR sky130_fd_sc_hd__decap_3
XFILLER_0_93_218 VGND VGND VPWR VPWR sky130_fd_sc_hd__fill_2
X_4945_ _1944_ _1945_ net827 _0916_ VGND VGND VPWR VPWR _0243_ sky130_fd_sc_hd__a2bb2o_1
XANTENNA__7114__RESET_B net816 VGND VGND VPWR VPWR sky130_fd_sc_hd__diode_2
XFILLER_0_59_473 VGND VGND VPWR VPWR sky130_fd_sc_hd__fill_2
XFILLER_0_59_462 VGND VGND VPWR VPWR sky130_fd_sc_hd__fill_2
XFILLER_0_47_602 VGND VGND VPWR VPWR sky130_fd_sc_hd__fill_2
XFILLER_0_19_315 VGND VGND VPWR VPWR sky130_fd_sc_hd__fill_1
XANTENNA__4071__B1 net72 VGND VGND VPWR VPWR sky130_fd_sc_hd__diode_2
XFILLER_0_47_646 VGND VGND VPWR VPWR sky130_fd_sc_hd__fill_2
XFILLER_0_47_635 VGND VGND VPWR VPWR sky130_fd_sc_hd__fill_2
X_7664_ clknet_leaf_29_clk _0713_ VGND VGND VPWR VPWR u_pe_array.u_fifo1.buffer\[7\]\[9\]
+ sky130_fd_sc_hd__dfxtp_1
X_4876_ u_pe_array.g_pe_row\[2\].g_pe_col\[0\].u_pe.psum_out\[3\] _1866_ _1867_ VGND
+ VGND VPWR VPWR _1883_ sky130_fd_sc_hd__a21o_1
X_7595_ clknet_leaf_22_clk _0644_ VGND VGND VPWR VPWR u_pe_array.u_fifo1.buffer\[2\]\[5\]
+ sky130_fd_sc_hd__dfxtp_1
XANTENNA__5466__B _2345_ VGND VGND VPWR VPWR sky130_fd_sc_hd__diode_2
X_6615_ net222 _1810_ _3269_ VGND VGND VPWR VPWR _3277_ sky130_fd_sc_hd__mux2_1
XFILLER_0_6_253 VGND VGND VPWR VPWR sky130_fd_sc_hd__decap_4
X_3827_ u_pe_array.g_pe_row\[3\].g_pe_col\[2\].u_pe.act_val\[1\] _1009_ VGND VGND
+ VPWR VPWR _1017_ sky130_fd_sc_hd__or2b_1
XFILLER_0_61_159 VGND VGND VPWR VPWR sky130_fd_sc_hd__fill_2
XFILLER_0_15_532 VGND VGND VPWR VPWR sky130_fd_sc_hd__fill_1
X_3758_ u_pe_array.g_pe_row\[3\].g_pe_col\[3\].u_pe.psum_out\[10\] _0869_ VGND VGND
+ VPWR VPWR _0968_ sky130_fd_sc_hd__or2_1
X_6546_ _3240_ VGND VGND VPWR VPWR _0549_ sky130_fd_sc_hd__clkbuf_1
XANTENNA__6115__A2 _0867_ VGND VGND VPWR VPWR sky130_fd_sc_hd__diode_2
XANTENNA_load_slew5_A net76 VGND VGND VPWR VPWR sky130_fd_sc_hd__diode_2
X_3689_ _0903_ u_pe_array.g_pe_row\[3\].g_pe_col\[3\].u_pe.act_val\[4\] u_pe_array.g_pe_row\[3\].g_pe_col\[3\].u_pe.w_reg\[0\]
+ _0869_ VGND VGND VPWR VPWR _0905_ sky130_fd_sc_hd__nand4_1
X_6477_ net354 _1812_ net67 VGND VGND VPWR VPWR _3203_ sky130_fd_sc_hd__mux2_1
XFILLER_0_30_557 VGND VGND VPWR VPWR sky130_fd_sc_hd__fill_2
X_5428_ u_pe_array.g_pe_row\[1\].g_pe_col\[1\].u_pe.act_val\[0\] _2344_ _2345_ VGND
+ VGND VPWR VPWR _2353_ sky130_fd_sc_hd__a21bo_1
X_5359_ u_pe_array.u_fifo1.buffer\[8\]\[1\] _2273_ _2293_ _2297_ _0819_ VGND VGND
+ VPWR VPWR _2298_ sky130_fd_sc_hd__a221o_1
XANTENNA__4429__A2 _1392_ VGND VGND VPWR VPWR sky130_fd_sc_hd__diode_2
X_7029_ clknet_leaf_80_clk _0106_ net815 VGND VGND VPWR VPWR u_pe_array.g_pe_row\[2\].g_pe_col\[3\].u_pe.move_reg\[11\]
+ sky130_fd_sc_hd__dfrtp_1
XANTENNA__6517__S _3224_ VGND VGND VPWR VPWR sky130_fd_sc_hd__diode_2
XANTENNA__6051__B2 _0722_ VGND VGND VPWR VPWR sky130_fd_sc_hd__diode_2
XFILLER_0_108_501 VGND VGND VPWR VPWR sky130_fd_sc_hd__fill_2
XFILLER_0_37_101 VGND VGND VPWR VPWR sky130_fd_sc_hd__fill_2
XFILLER_0_37_123 VGND VGND VPWR VPWR sky130_fd_sc_hd__decap_8
XANTENNA__4561__A _1536_ VGND VGND VPWR VPWR sky130_fd_sc_hd__diode_2
XFILLER_0_37_134 VGND VGND VPWR VPWR sky130_fd_sc_hd__decap_6
XFILLER_0_37_167 VGND VGND VPWR VPWR sky130_fd_sc_hd__fill_1
XFILLER_0_108_545 VPWR VGND VPWR VGND sky130_ef_sc_hd__decap_12
XFILLER_0_108_589 VPWR VGND VPWR VGND sky130_ef_sc_hd__decap_12
XFILLER_0_52_148 VPWR VGND VPWR VGND sky130_ef_sc_hd__decap_12
XFILLER_0_18_381 VGND VGND VPWR VPWR sky130_fd_sc_hd__fill_1
XFILLER_0_33_362 VGND VGND VPWR VPWR sky130_fd_sc_hd__fill_2
XFILLER_0_60_181 VGND VGND VPWR VPWR sky130_fd_sc_hd__fill_2
XFILLER_0_29_15 VGND VGND VPWR VPWR sky130_fd_sc_hd__decap_3
XFILLER_0_29_37 VGND VGND VPWR VPWR sky130_fd_sc_hd__decap_4
XTAP_708 VGND VPWR sky130_fd_sc_hd__tapvpwrvgnd_1
XTAP_719 VGND VPWR sky130_fd_sc_hd__tapvpwrvgnd_1
XFILLER_0_88_513 VGND VGND VPWR VPWR sky130_fd_sc_hd__fill_2
XFILLER_0_0_38 VPWR VGND VPWR VGND sky130_ef_sc_hd__decap_12
XFILLER_0_0_27 VGND VGND VPWR VPWR sky130_fd_sc_hd__fill_1
XFILLER_0_75_229 VGND VGND VPWR VPWR sky130_fd_sc_hd__fill_2
XFILLER_0_61_57 VPWR VGND VPWR VGND sky130_ef_sc_hd__decap_12
XTAP_1491 VGND VPWR sky130_fd_sc_hd__tapvpwrvgnd_1
XTAP_1480 VGND VPWR sky130_fd_sc_hd__tapvpwrvgnd_1
X_4730_ _1672_ u_pe_array.g_pe_row\[2\].g_pe_col\[1\].u_pe.psum_out\[9\] _1771_ VGND
+ VGND VPWR VPWR _1772_ sky130_fd_sc_hd__and3_1
X_4661_ _1706_ _1707_ _1708_ VGND VGND VPWR VPWR _1709_ sky130_fd_sc_hd__and3_1
X_7380_ clknet_leaf_46_clk _0433_ net812 VGND VGND VPWR VPWR u_pe_array.g_pe_row\[0\].g_pe_col\[1\].u_pe.psum_out\[4\]
+ sky130_fd_sc_hd__dfrtp_1
X_6400_ u_pe_array.u_fifo2.count\[3\] _3158_ VGND VGND VPWR VPWR _3161_ sky130_fd_sc_hd__nand2_1
XFILLER_0_9_36 VGND VGND VPWR VPWR sky130_fd_sc_hd__fill_2
X_3612_ net23 _0842_ _0819_ VGND VGND VPWR VPWR _0843_ sky130_fd_sc_hd__mux2_1
X_4592_ u_pe_array.g_pe_row\[2\].g_pe_col\[1\].u_pe.act_val\[3\] u_pe_array.g_pe_row\[2\].g_pe_col\[1\].u_pe.psum_out\[3\]
+ _0770_ VGND VGND VPWR VPWR _1654_ sky130_fd_sc_hd__mux2_1
X_6331_ _1787_ _1126_ net54 VGND VGND VPWR VPWR _3114_ sky130_fd_sc_hd__a21o_2
XFILLER_0_3_223 VGND VGND VPWR VPWR sky130_fd_sc_hd__fill_1
X_3543_ _0722_ _0780_ _0784_ _0789_ VGND VGND VPWR VPWR u_fsm.next_state\[2\] sky130_fd_sc_hd__a211o_1
XFILLER_0_3_267 VGND VGND VPWR VPWR sky130_fd_sc_hd__fill_1
X_6262_ _3040_ _3043_ _3041_ VGND VGND VPWR VPWR _3054_ sky130_fd_sc_hd__o21ba_1
X_3474_ _0728_ _0743_ VGND VGND VPWR VPWR _0744_ sky130_fd_sc_hd__and2_1
X_6193_ u_pe_array.g_pe_row\[0\].g_pe_col\[0\].u_pe.act_val\[0\] u_pe_array.g_pe_row\[0\].g_pe_col\[0\].u_pe.psum_out\[0\]
+ u_pe_array.g_pe_row\[0\].g_pe_col\[0\].u_pe.w_reg\[0\] VGND VGND VPWR VPWR _2991_
+ sky130_fd_sc_hd__nand3_1
X_5213_ u_pe_array.g_pe_row\[1\].g_pe_col\[2\].u_pe.act_val\[0\] _2157_ _2158_ VGND
+ VGND VPWR VPWR _2166_ sky130_fd_sc_hd__a21bo_1
X_5144_ _1725_ _2116_ _2117_ _2071_ net675 VGND VGND VPWR VPWR _0270_ sky130_fd_sc_hd__a32o_1
XANTENNA__7366__RESET_B net812 VGND VGND VPWR VPWR sky130_fd_sc_hd__diode_2
X_5075_ _2054_ VGND VGND VPWR VPWR _2055_ sky130_fd_sc_hd__inv_2
XANTENNA__3619__B1 _0837_ VGND VGND VPWR VPWR sky130_fd_sc_hd__diode_2
X_4026_ _1183_ _1185_ VGND VGND VPWR VPWR _1186_ sky130_fd_sc_hd__nand2_1
XFILLER_0_29_3 VPWR VGND VPWR VGND sky130_ef_sc_hd__decap_12
XFILLER_0_79_557 VGND VGND VPWR VPWR sky130_fd_sc_hd__decap_3
XFILLER_0_94_505 VGND VGND VPWR VPWR sky130_fd_sc_hd__fill_2
Xclkbuf_leaf_91_clk clknet_3_1__leaf_clk VGND VGND VPWR VPWR clknet_leaf_91_clk sky130_fd_sc_hd__clkbuf_16
XFILLER_0_35_80 VGND VGND VPWR VPWR sky130_fd_sc_hd__decap_6
XANTENNA__5477__A u_pe_array.g_pe_row\[1\].g_pe_col\[1\].u_pe.w_reg\[0\] VGND VGND
+ VPWR VPWR sky130_fd_sc_hd__diode_2
XFILLER_0_59_281 VGND VGND VPWR VPWR sky130_fd_sc_hd__decap_4
X_5977_ _2812_ VGND VGND VPWR VPWR _2813_ sky130_fd_sc_hd__inv_2
X_4928_ _0914_ _1928_ _1929_ _0861_ _1930_ VGND VGND VPWR VPWR _0241_ sky130_fd_sc_hd__o32ai_1
X_7647_ clknet_leaf_23_clk _0696_ VGND VGND VPWR VPWR u_pe_array.u_fifo1.buffer\[6\]\[5\]
+ sky130_fd_sc_hd__dfxtp_1
XFILLER_0_19_178 VGND VGND VPWR VPWR sky130_fd_sc_hd__fill_1
XANTENNA__6930__RESET_B net819 VGND VGND VPWR VPWR sky130_fd_sc_hd__diode_2
X_4859_ u_pe_array.g_pe_row\[2\].g_pe_col\[0\].u_pe.act_val\[2\] u_pe_array.g_pe_row\[2\].g_pe_col\[0\].u_pe.act_val\[3\]
+ u_pe_array.g_pe_row\[2\].g_pe_col\[0\].u_pe.w_reg\[0\] _1847_ VGND VGND VPWR VPWR
+ _1867_ sky130_fd_sc_hd__and4b_1
XANTENNA_clkbuf_leaf_7_clk_A clknet_3_0__leaf_clk VGND VGND VPWR VPWR sky130_fd_sc_hd__diode_2
XFILLER_0_7_573 VPWR VGND VPWR VGND sky130_ef_sc_hd__decap_12
XFILLER_0_34_137 VGND VGND VPWR VPWR sky130_fd_sc_hd__decap_3
X_7578_ clknet_leaf_27_clk _0627_ VGND VGND VPWR VPWR u_pe_array.u_fifo1.buffer\[1\]\[1\]
+ sky130_fd_sc_hd__dfxtp_1
XANTENNA__5544__B1 _2174_ VGND VGND VPWR VPWR sky130_fd_sc_hd__diode_2
XFILLER_0_43_671 VGND VGND VPWR VPWR sky130_fd_sc_hd__fill_1
Xclkbuf_3_0__f_clk clknet_0_clk VGND VGND VPWR VPWR clknet_3_0__leaf_clk sky130_fd_sc_hd__clkbuf_16
XFILLER_0_70_490 VGND VGND VPWR VPWR sky130_fd_sc_hd__fill_2
X_6529_ net295 _1808_ _3224_ VGND VGND VPWR VPWR _3231_ sky130_fd_sc_hd__mux2_1
XFILLER_0_30_332 VGND VGND VPWR VPWR sky130_fd_sc_hd__fill_2
XANTENNA__7036__RESET_B net816 VGND VGND VPWR VPWR sky130_fd_sc_hd__diode_2
XFILLER_0_85_505 VGND VGND VPWR VPWR sky130_fd_sc_hd__fill_2
XFILLER_0_57_218 VGND VGND VPWR VPWR sky130_fd_sc_hd__decap_4
Xclkbuf_leaf_82_clk clknet_3_4__leaf_clk VGND VGND VPWR VPWR clknet_leaf_82_clk sky130_fd_sc_hd__clkbuf_16
XFILLER_0_38_432 VGND VGND VPWR VPWR sky130_fd_sc_hd__fill_2
XFILLER_0_108_342 VGND VGND VPWR VPWR sky130_fd_sc_hd__fill_2
XFILLER_0_38_498 VGND VGND VPWR VPWR sky130_fd_sc_hd__fill_2
XFILLER_0_53_457 VGND VGND VPWR VPWR sky130_fd_sc_hd__decap_3
XFILLER_0_53_468 VGND VGND VPWR VPWR sky130_fd_sc_hd__decap_8
XFILLER_0_34_660 VGND VGND VPWR VPWR sky130_fd_sc_hd__fill_2
XFILLER_0_111_529 VPWR VGND VPWR VGND sky130_ef_sc_hd__decap_12
XFILLER_0_0_237 VPWR VGND VPWR VGND sky130_ef_sc_hd__decap_12
XFILLER_0_0_259 VGND VGND VPWR VPWR sky130_fd_sc_hd__fill_2
XTAP_505 VGND VPWR sky130_fd_sc_hd__tapvpwrvgnd_1
XTAP_516 VGND VPWR sky130_fd_sc_hd__tapvpwrvgnd_1
XTAP_527 VGND VPWR sky130_fd_sc_hd__tapvpwrvgnd_1
XTAP_538 VGND VPWR sky130_fd_sc_hd__tapvpwrvgnd_1
XTAP_549 VGND VPWR sky130_fd_sc_hd__tapvpwrvgnd_1
X_5900_ _2740_ _2741_ _2742_ _2571_ net392 VGND VGND VPWR VPWR _0401_ sky130_fd_sc_hd__a32o_1
X_6880_ net228 _3130_ _3412_ VGND VGND VPWR VPWR _3423_ sky130_fd_sc_hd__mux2_1
Xclkbuf_leaf_73_clk clknet_3_5__leaf_clk VGND VGND VPWR VPWR clknet_leaf_73_clk sky130_fd_sc_hd__clkbuf_16
XFILLER_0_88_398 VGND VGND VPWR VPWR sky130_fd_sc_hd__decap_3
X_5831_ _0913_ _2693_ VGND VGND VPWR VPWR _2694_ sky130_fd_sc_hd__or2_1
XFILLER_0_8_304 VGND VGND VPWR VPWR sky130_fd_sc_hd__decap_4
XFILLER_0_29_432 VGND VGND VPWR VPWR sky130_fd_sc_hd__decap_3
X_5762_ _2611_ _2629_ u_pe_array.g_pe_row\[0\].g_pe_col\[3\].u_pe.act_val\[3\] u_pe_array.g_pe_row\[0\].g_pe_col\[3\].u_pe.w_reg\[0\]
+ VGND VGND VPWR VPWR _2630_ sky130_fd_sc_hd__a22o_1
X_4713_ net72 _1756_ VGND VGND VPWR VPWR _1757_ sky130_fd_sc_hd__or2_1
XFILLER_0_16_115 VGND VGND VPWR VPWR sky130_fd_sc_hd__decap_3
X_7501_ clknet_leaf_1_clk _0550_ VGND VGND VPWR VPWR u_pe_array.u_fifo2.buffer\[5\]\[1\]
+ sky130_fd_sc_hd__dfxtp_1
XFILLER_0_29_476 VGND VGND VPWR VPWR sky130_fd_sc_hd__fill_2
XFILLER_0_29_498 VGND VGND VPWR VPWR sky130_fd_sc_hd__decap_4
X_5693_ u_pe_array.g_pe_row\[1\].g_pe_col\[0\].u_pe.psum_out\[11\] _2478_ VGND VGND
+ VPWR VPWR _2581_ sky130_fd_sc_hd__and2b_1
XFILLER_0_71_210 VGND VGND VPWR VPWR sky130_fd_sc_hd__fill_2
X_4644_ _1692_ VGND VGND VPWR VPWR _1693_ sky130_fd_sc_hd__inv_2
X_7432_ clknet_leaf_7_clk _0481_ net74 VGND VGND VPWR VPWR u_pe_array.u_fifo2.count\[1\]
+ sky130_fd_sc_hd__dfrtp_1
XFILLER_0_21_82 VGND VGND VPWR VPWR sky130_fd_sc_hd__fill_2
X_7363_ clknet_leaf_44_clk _0418_ net75 VGND VGND VPWR VPWR u_pe_array.g_pe_row\[0\].g_pe_col\[0\].u_pe.act_val\[2\]
+ sky130_fd_sc_hd__dfrtp_1
Xhold701 u_pe_array.g_pe_row\[2\].g_pe_col\[0\].u_pe.psum_out\[8\] VGND VGND VPWR
+ VPWR net777 sky130_fd_sc_hd__dlygate4sd3_1
XFILLER_0_52_490 VGND VGND VPWR VPWR sky130_fd_sc_hd__fill_2
X_4575_ _1634_ _1637_ _1642_ VGND VGND VPWR VPWR _1644_ sky130_fd_sc_hd__or3_1
Xhold712 u_pe_array.g_pe_row\[0\].g_pe_col\[2\].u_pe.act_val\[3\] VGND VGND VPWR VPWR
+ net788 sky130_fd_sc_hd__dlygate4sd3_1
X_6314_ _3086_ _3090_ _3097_ _3099_ _3096_ VGND VGND VPWR VPWR _3100_ sky130_fd_sc_hd__a32o_1
Xhold734 u_pe_array.g_pe_row\[1\].g_pe_col\[1\].u_pe.move_reg\[8\] VGND VGND VPWR
+ VPWR net810 sky130_fd_sc_hd__dlygate4sd3_1
X_7294_ clknet_leaf_57_clk _0353_ net813 VGND VGND VPWR VPWR u_pe_array.g_pe_row\[1\].g_pe_col\[0\].u_pe.psum_out\[8\]
+ sky130_fd_sc_hd__dfrtp_2
X_3526_ u_pe_array.g_pe_row\[1\].g_pe_col\[0\].u_pe.psum_out\[11\] _0769_ _0776_ _0754_
+ VGND VGND VPWR VPWR net38 sky130_fd_sc_hd__o211a_2
XFILLER_0_4_587 VGND VGND VPWR VPWR sky130_fd_sc_hd__fill_1
Xhold745 u_pe_array.g_pe_row\[2\].g_pe_col\[2\].u_pe.psum_out\[8\] VGND VGND VPWR
+ VPWR net829 sky130_fd_sc_hd__dlygate4sd3_1
Xhold723 u_pe_array.g_pe_row\[1\].g_pe_col\[2\].u_pe.w_buffer\[0\] VGND VGND VPWR
+ VPWR net799 sky130_fd_sc_hd__dlygate4sd3_1
X_6245_ u_pe_array.g_pe_row\[0\].g_pe_col\[0\].u_pe.psum_out\[5\] _3037_ VGND VGND
+ VPWR VPWR _3038_ sky130_fd_sc_hd__xnor2_1
XFILLER_0_12_365 VGND VGND VPWR VPWR sky130_fd_sc_hd__decap_8
XANTENNA__7547__RESET_B net815 VGND VGND VPWR VPWR sky130_fd_sc_hd__diode_2
X_3457_ _0728_ _0731_ VGND VGND VPWR VPWR _0732_ sky130_fd_sc_hd__and2_1
X_6176_ _2971_ _2974_ _2979_ VGND VGND VPWR VPWR _2980_ sky130_fd_sc_hd__o21ai_1
X_5127_ _2063_ _2065_ _2076_ VGND VGND VPWR VPWR _2102_ sky130_fd_sc_hd__a21oi_1
XFILLER_0_98_129 VGND VGND VPWR VPWR sky130_fd_sc_hd__fill_2
X_5058_ _2036_ _2038_ VGND VGND VPWR VPWR _2039_ sky130_fd_sc_hd__xnor2_2
X_4009_ _1164_ _1165_ _1169_ VGND VGND VPWR VPWR _1170_ sky130_fd_sc_hd__nor3_1
Xclkbuf_leaf_64_clk clknet_3_5__leaf_clk VGND VGND VPWR VPWR clknet_leaf_64_clk sky130_fd_sc_hd__clkbuf_16
XFILLER_0_1_81 VPWR VGND VPWR VGND sky130_ef_sc_hd__decap_12
XANTENNA__4568__A1 _0914_ VGND VGND VPWR VPWR sky130_fd_sc_hd__diode_2
XFILLER_0_90_530 VGND VGND VPWR VPWR sky130_fd_sc_hd__fill_2
XFILLER_0_75_593 VGND VGND VPWR VPWR sky130_fd_sc_hd__fill_2
XFILLER_0_35_446 VGND VGND VPWR VPWR sky130_fd_sc_hd__fill_2
XFILLER_0_90_585 VGND VGND VPWR VPWR sky130_fd_sc_hd__decap_3
XANTENNA__3528__C1 _0754_ VGND VGND VPWR VPWR sky130_fd_sc_hd__diode_2
XANTENNA__5654__B _2478_ VGND VGND VPWR VPWR sky130_fd_sc_hd__diode_2
XFILLER_0_62_287 VGND VGND VPWR VPWR sky130_fd_sc_hd__decap_8
XFILLER_0_22_129 VGND VGND VPWR VPWR sky130_fd_sc_hd__fill_2
XANTENNA__3455__A _0729_ VGND VGND VPWR VPWR sky130_fd_sc_hd__diode_2
XANTENNA__7288__RESET_B net813 VGND VGND VPWR VPWR sky130_fd_sc_hd__diode_2
XANTENNA__7217__RESET_B net812 VGND VGND VPWR VPWR sky130_fd_sc_hd__diode_2
Xhold50 u_pe_array.g_pe_row\[1\].g_pe_col\[0\].u_pe.move_reg\[7\] VGND VGND VPWR VPWR
+ net126 sky130_fd_sc_hd__dlygate4sd3_1
XANTENNA_input32_A w_in_flat[5] VGND VGND VPWR VPWR sky130_fd_sc_hd__diode_2
Xhold72 _0256_ VGND VGND VPWR VPWR net148 sky130_fd_sc_hd__dlygate4sd3_1
Xhold83 u_pe_array.g_pe_row\[3\].g_pe_col\[1\].u_pe.move_reg\[7\] VGND VGND VPWR VPWR
+ net159 sky130_fd_sc_hd__dlygate4sd3_1
XANTENNA__5048__A2 _2029_ VGND VGND VPWR VPWR sky130_fd_sc_hd__diode_2
Xhold61 _0341_ VGND VGND VPWR VPWR net137 sky130_fd_sc_hd__dlygate4sd3_1
Xhold94 u_pe_array.g_pe_row\[2\].g_pe_col\[3\].u_pe.move_reg\[11\] VGND VGND VPWR
+ VPWR net170 sky130_fd_sc_hd__dlygate4sd3_1
XFILLER_0_58_505 VGND VGND VPWR VPWR sky130_fd_sc_hd__fill_2
XFILLER_0_42_15 VGND VGND VPWR VPWR sky130_fd_sc_hd__fill_1
XFILLER_0_109_673 VGND VGND VPWR VPWR sky130_fd_sc_hd__decap_4
XFILLER_0_26_446 VGND VGND VPWR VPWR sky130_fd_sc_hd__fill_2
XANTENNA__5845__A _2611_ VGND VGND VPWR VPWR sky130_fd_sc_hd__diode_2
XFILLER_0_41_416 VGND VGND VPWR VPWR sky130_fd_sc_hd__fill_1
XFILLER_0_6_15 VPWR VGND VPWR VGND sky130_ef_sc_hd__decap_12
XFILLER_0_1_524 VPWR VGND VPWR VGND sky130_ef_sc_hd__decap_12
X_4360_ _1407_ _1461_ u_pe_array.g_pe_row\[2\].g_pe_col\[3\].u_pe.psum_out\[6\] VGND
+ VGND VPWR VPWR _1462_ sky130_fd_sc_hd__nand3_2
XFILLER_0_22_663 VGND VGND VPWR VPWR sky130_fd_sc_hd__fill_2
XFILLER_0_111_337 VPWR VGND VPWR VGND sky130_ef_sc_hd__decap_12
XTAP_324 VGND VPWR sky130_fd_sc_hd__tapvpwrvgnd_1
XTAP_313 VGND VPWR sky130_fd_sc_hd__tapvpwrvgnd_1
XTAP_302 VGND VPWR sky130_fd_sc_hd__tapvpwrvgnd_1
X_4291_ u_pe_array.g_pe_row\[2\].g_pe_col\[3\].u_pe.psum_out\[10\] u_pe_array.g_pe_row\[2\].g_pe_col\[3\].u_pe.move_reg\[10\]
+ _0855_ VGND VGND VPWR VPWR _1402_ sky130_fd_sc_hd__mux2_1
X_6030_ u_pe_array.g_pe_row\[0\].g_pe_col\[1\].u_pe.psum_out\[1\] u_pe_array.g_pe_row\[0\].g_pe_col\[1\].u_pe.act_val\[1\]
+ _0745_ VGND VGND VPWR VPWR _2857_ sky130_fd_sc_hd__mux2_1
XANTENNA__5589__B_N _2478_ VGND VGND VPWR VPWR sky130_fd_sc_hd__diode_2
XTAP_357 VGND VPWR sky130_fd_sc_hd__tapvpwrvgnd_1
XTAP_346 VGND VPWR sky130_fd_sc_hd__tapvpwrvgnd_1
XTAP_335 VGND VPWR sky130_fd_sc_hd__tapvpwrvgnd_1
XANTENNA__4908__B _1847_ VGND VGND VPWR VPWR sky130_fd_sc_hd__diode_2
XTAP_379 VGND VPWR sky130_fd_sc_hd__tapvpwrvgnd_1
XTAP_368 VGND VPWR sky130_fd_sc_hd__tapvpwrvgnd_1
XANTENNA__5039__A2 _1666_ VGND VGND VPWR VPWR sky130_fd_sc_hd__diode_2
XFILLER_0_107_51 VGND VGND VPWR VPWR sky130_fd_sc_hd__decap_4
XFILLER_0_83_77 VGND VGND VPWR VPWR sky130_fd_sc_hd__fill_2
Xclkbuf_leaf_46_clk clknet_3_7__leaf_clk VGND VGND VPWR VPWR clknet_leaf_46_clk sky130_fd_sc_hd__clkbuf_16
XFILLER_0_83_99 VGND VGND VPWR VPWR sky130_fd_sc_hd__fill_1
XANTENNA__6615__S _3269_ VGND VGND VPWR VPWR sky130_fd_sc_hd__diode_2
XFILLER_0_49_516 VGND VGND VPWR VPWR sky130_fd_sc_hd__fill_2
XFILLER_0_49_505 VGND VGND VPWR VPWR sky130_fd_sc_hd__decap_3
XPHY_19 VGND VGND VPWR VPWR sky130_fd_sc_hd__decap_3
XFILLER_0_16_60 VGND VGND VPWR VPWR sky130_fd_sc_hd__decap_4
X_6932_ clknet_leaf_92_clk _0015_ net819 VGND VGND VPWR VPWR u_pe_array.g_pe_row\[3\].g_pe_col\[2\].u_pe.act_val\[4\]
+ sky130_fd_sc_hd__dfrtp_2
X_6863_ _3414_ VGND VGND VPWR VPWR _0692_ sky130_fd_sc_hd__clkbuf_1
XFILLER_0_88_195 VGND VGND VPWR VPWR sky130_fd_sc_hd__fill_1
XFILLER_0_88_184 VGND VGND VPWR VPWR sky130_fd_sc_hd__fill_2
XFILLER_0_76_302 VGND VGND VPWR VPWR sky130_fd_sc_hd__decap_4
XFILLER_0_76_357 VGND VGND VPWR VPWR sky130_fd_sc_hd__fill_2
XANTENNA__5747__B1 _2571_ VGND VGND VPWR VPWR sky130_fd_sc_hd__diode_2
X_5814_ _2677_ u_pe_array.g_pe_row\[0\].g_pe_col\[3\].u_pe.psum_out\[7\] _2666_ VGND
+ VGND VPWR VPWR _2678_ sky130_fd_sc_hd__mux2_1
X_6794_ _3376_ VGND VGND VPWR VPWR _0661_ sky130_fd_sc_hd__clkbuf_1
XFILLER_0_91_327 VGND VGND VPWR VPWR sky130_fd_sc_hd__decap_4
XFILLER_0_57_571 VGND VGND VPWR VPWR sky130_fd_sc_hd__fill_1
XFILLER_0_91_349 VGND VGND VPWR VPWR sky130_fd_sc_hd__decap_3
XANTENNA__3974__S _0755_ VGND VGND VPWR VPWR sky130_fd_sc_hd__diode_2
XFILLER_0_57_593 VGND VGND VPWR VPWR sky130_fd_sc_hd__decap_8
X_5745_ u_pe_array.g_pe_row\[0\].g_pe_col\[3\].u_pe.psum_out\[1\] _2614_ VGND VGND
+ VPWR VPWR _2615_ sky130_fd_sc_hd__or2_1
XANTENNA__6350__S _3110_ VGND VGND VPWR VPWR sky130_fd_sc_hd__diode_2
XFILLER_0_96_3 VPWR VGND VPWR VGND sky130_ef_sc_hd__decap_12
X_5676_ u_pe_array.g_pe_row\[1\].g_pe_col\[0\].u_pe.psum_out\[9\] _2478_ VGND VGND
+ VPWR VPWR _2566_ sky130_fd_sc_hd__or2_1
X_7415_ clknet_leaf_22_clk _0464_ VGND VGND VPWR VPWR u_pe_array.u_fifo1.buffer\[8\]\[5\]
+ sky130_fd_sc_hd__dfxtp_1
X_4627_ _1273_ _1676_ _1677_ _1534_ net476 VGND VGND VPWR VPWR _0193_ sky130_fd_sc_hd__a32o_1
XFILLER_0_72_585 VGND VGND VPWR VPWR sky130_fd_sc_hd__decap_3
XFILLER_0_114_186 VGND VGND VPWR VPWR sky130_fd_sc_hd__fill_2
XFILLER_0_4_362 VGND VGND VPWR VPWR sky130_fd_sc_hd__fill_2
Xhold520 u_pe_array.g_pe_row\[1\].g_pe_col\[3\].u_pe.move_reg\[11\] VGND VGND VPWR
+ VPWR net596 sky130_fd_sc_hd__dlygate4sd3_1
XFILLER_0_114_197 VGND VGND VPWR VPWR sky130_fd_sc_hd__fill_1
XFILLER_0_102_359 VGND VGND VPWR VPWR sky130_fd_sc_hd__fill_2
Xhold542 u_pe_array.g_pe_row\[1\].g_pe_col\[1\].u_pe.act_val\[2\] VGND VGND VPWR VPWR
+ net618 sky130_fd_sc_hd__dlygate4sd3_1
X_7346_ clknet_leaf_82_clk _0401_ net13 VGND VGND VPWR VPWR u_pe_array.g_pe_row\[0\].g_pe_col\[2\].u_pe.psum_out\[0\]
+ sky130_fd_sc_hd__dfrtp_1
Xhold531 u_pe_array.u_fifo2.buffer\[8\]\[1\] VGND VGND VPWR VPWR net607 sky130_fd_sc_hd__dlygate4sd3_1
X_4558_ _1623_ VGND VGND VPWR VPWR _1628_ sky130_fd_sc_hd__inv_2
Xhold553 u_pe_array.g_pe_row\[1\].g_pe_col\[3\].u_pe.move_reg\[7\] VGND VGND VPWR
+ VPWR net629 sky130_fd_sc_hd__dlygate4sd3_1
XFILLER_0_40_471 VGND VGND VPWR VPWR sky130_fd_sc_hd__fill_2
Xhold575 u_pe_array.g_pe_row\[0\].g_pe_col\[0\].u_pe.act_val\[4\] VGND VGND VPWR VPWR
+ net651 sky130_fd_sc_hd__dlygate4sd3_1
XANTENNA__7381__RESET_B net812 VGND VGND VPWR VPWR sky130_fd_sc_hd__diode_2
Xhold586 u_pe_array.g_pe_row\[2\].g_pe_col\[0\].u_pe.psum_out\[3\] VGND VGND VPWR
+ VPWR net662 sky130_fd_sc_hd__dlygate4sd3_1
Xhold564 u_pe_array.g_pe_row\[1\].g_pe_col\[0\].u_pe.act_val\[2\] VGND VGND VPWR VPWR
+ net640 sky130_fd_sc_hd__dlygate4sd3_1
Xhold597 u_pe_array.u_fifo1.count\[0\] VGND VGND VPWR VPWR net673 sky130_fd_sc_hd__dlygate4sd3_1
X_3509_ _0766_ VGND VGND VPWR VPWR net43 sky130_fd_sc_hd__clkbuf_1
X_4489_ net693 _1152_ _0887_ _1565_ VGND VGND VPWR VPWR _0167_ sky130_fd_sc_hd__a22o_1
X_7277_ clknet_leaf_66_clk net134 net814 VGND VGND VPWR VPWR u_pe_array.g_pe_row\[0\].g_pe_col\[3\].u_pe.move_reg\[6\]
+ sky130_fd_sc_hd__dfrtp_1
X_6228_ _2740_ _3021_ _3022_ _0866_ net432 VGND VGND VPWR VPWR _0449_ sky130_fd_sc_hd__a32o_1
XANTENNA__6475__A1 _1810_ VGND VGND VPWR VPWR sky130_fd_sc_hd__diode_2
XANTENNA__5921__C _2743_ VGND VGND VPWR VPWR sky130_fd_sc_hd__diode_2
XANTENNA__7310__RESET_B net814 VGND VGND VPWR VPWR sky130_fd_sc_hd__diode_2
X_6159_ _2963_ VGND VGND VPWR VPWR _2964_ sky130_fd_sc_hd__inv_2
XTAP_880 VGND VPWR sky130_fd_sc_hd__tapvpwrvgnd_1
XANTENNA__4818__B _0833_ VGND VGND VPWR VPWR sky130_fd_sc_hd__diode_2
XTAP_891 VGND VPWR sky130_fd_sc_hd__tapvpwrvgnd_1
XFILLER_0_99_449 VGND VGND VPWR VPWR sky130_fd_sc_hd__fill_2
XANTENNA__4238__B1 _1144_ VGND VGND VPWR VPWR sky130_fd_sc_hd__diode_2
XFILLER_0_79_151 VGND VGND VPWR VPWR sky130_fd_sc_hd__fill_2
XFILLER_0_79_140 VGND VGND VPWR VPWR sky130_fd_sc_hd__fill_1
Xclkbuf_leaf_37_clk clknet_3_3__leaf_clk VGND VGND VPWR VPWR clknet_leaf_37_clk sky130_fd_sc_hd__clkbuf_16
XANTENNA__6525__S _3224_ VGND VGND VPWR VPWR sky130_fd_sc_hd__diode_2
XFILLER_0_79_173 VGND VGND VPWR VPWR sky130_fd_sc_hd__fill_1
XFILLER_0_82_305 VGND VGND VPWR VPWR sky130_fd_sc_hd__decap_3
XFILLER_0_106_643 VGND VGND VPWR VPWR sky130_fd_sc_hd__fill_1
XFILLER_0_90_371 VGND VGND VPWR VPWR sky130_fd_sc_hd__fill_2
XANTENNA__3516__A2 _0769_ VGND VGND VPWR VPWR sky130_fd_sc_hd__diode_2
XFILLER_0_50_235 VGND VGND VPWR VPWR sky130_fd_sc_hd__fill_2
XFILLER_0_23_449 VGND VGND VPWR VPWR sky130_fd_sc_hd__fill_2
Xoutput40 net40 VGND VGND VPWR VPWR psum_out0[1] sky130_fd_sc_hd__clkbuf_4
Xoutput51 net51 VGND VGND VPWR VPWR psum_out1[11] sky130_fd_sc_hd__clkbuf_4
XFILLER_0_31_493 VGND VGND VPWR VPWR sky130_fd_sc_hd__fill_2
XANTENNA__7051__RESET_B net819 VGND VGND VPWR VPWR sky130_fd_sc_hd__diode_2
Xclkbuf_leaf_28_clk clknet_3_3__leaf_clk VGND VGND VPWR VPWR clknet_leaf_28_clk sky130_fd_sc_hd__clkbuf_16
XFILLER_0_46_508 VGND VGND VPWR VPWR sky130_fd_sc_hd__fill_2
XFILLER_0_85_187 VGND VGND VPWR VPWR sky130_fd_sc_hd__fill_1
XFILLER_0_85_165 VGND VGND VPWR VPWR sky130_fd_sc_hd__decap_3
XFILLER_0_73_316 VGND VGND VPWR VPWR sky130_fd_sc_hd__decap_3
X_3860_ _1045_ _1046_ VGND VGND VPWR VPWR _1048_ sky130_fd_sc_hd__or2_1
XANTENNA_clkbuf_leaf_32_clk_A clknet_3_3__leaf_clk VGND VGND VPWR VPWR sky130_fd_sc_hd__diode_2
XFILLER_0_73_349 VGND VGND VPWR VPWR sky130_fd_sc_hd__fill_2
XFILLER_0_66_390 VGND VGND VPWR VPWR sky130_fd_sc_hd__decap_6
X_3791_ _0739_ _0992_ _0754_ VGND VGND VPWR VPWR _0993_ sky130_fd_sc_hd__mux2_1
XANTENNA__3794__S _0754_ VGND VGND VPWR VPWR sky130_fd_sc_hd__diode_2
XPHY_190 VGND VGND VPWR VPWR sky130_fd_sc_hd__decap_3
XANTENNA__4952__A1 _1725_ VGND VGND VPWR VPWR sky130_fd_sc_hd__diode_2
X_5530_ _2437_ _2439_ _2445_ VGND VGND VPWR VPWR _2447_ sky130_fd_sc_hd__a21oi_2
XFILLER_0_54_563 VGND VGND VPWR VPWR sky130_fd_sc_hd__fill_2
XFILLER_0_54_541 VGND VGND VPWR VPWR sky130_fd_sc_hd__decap_8
XFILLER_0_5_137 VPWR VGND VPWR VGND sky130_ef_sc_hd__decap_12
XFILLER_0_26_232 VGND VGND VPWR VPWR sky130_fd_sc_hd__decap_4
XFILLER_0_82_9 VGND VGND VPWR VPWR sky130_fd_sc_hd__fill_2
XFILLER_0_81_393 VGND VGND VPWR VPWR sky130_fd_sc_hd__fill_2
X_5461_ _2382_ _2383_ VGND VGND VPWR VPWR _2384_ sky130_fd_sc_hd__or2_1
XFILLER_0_14_427 VGND VGND VPWR VPWR sky130_fd_sc_hd__fill_2
XFILLER_0_112_613 VPWR VGND VPWR VGND sky130_ef_sc_hd__decap_12
XFILLER_0_111_101 VGND VGND VPWR VPWR sky130_fd_sc_hd__fill_2
XANTENNA_clkbuf_leaf_47_clk_A clknet_3_7__leaf_clk VGND VGND VPWR VPWR sky130_fd_sc_hd__diode_2
X_7200_ clknet_leaf_73_clk _0265_ net815 VGND VGND VPWR VPWR u_pe_array.g_pe_row\[1\].g_pe_col\[3\].u_pe.psum_out\[4\]
+ sky130_fd_sc_hd__dfrtp_1
X_4412_ _1500_ _1502_ _1508_ VGND VGND VPWR VPWR _1509_ sky130_fd_sc_hd__o21ai_1
XFILLER_0_112_657 VPWR VGND VPWR VGND sky130_ef_sc_hd__decap_12
X_5392_ u_pe_array.u_fifo1.buffer\[5\]\[5\] _2284_ _2285_ u_pe_array.u_fifo1.buffer\[6\]\[5\]
+ _2286_ VGND VGND VPWR VPWR _2327_ sky130_fd_sc_hd__a221o_1
XFILLER_0_1_321 VGND VGND VPWR VPWR sky130_fd_sc_hd__fill_2
X_7131_ clknet_leaf_13_clk _0200_ net816 VGND VGND VPWR VPWR u_pe_array.g_pe_row\[2\].g_pe_col\[1\].u_pe.psum_out\[8\]
+ sky130_fd_sc_hd__dfrtp_2
X_4343_ _1444_ _1446_ VGND VGND VPWR VPWR _1447_ sky130_fd_sc_hd__nand2_1
XFILLER_0_22_493 VGND VGND VPWR VPWR sky130_fd_sc_hd__fill_2
X_7062_ clknet_leaf_76_clk net90 net815 VGND VGND VPWR VPWR u_pe_array.g_pe_row\[2\].g_pe_col\[3\].u_pe.w_reg\[1\]
+ sky130_fd_sc_hd__dfrtp_1
X_4274_ u_pe_array.g_pe_row\[2\].g_pe_col\[3\].u_pe.psum_out\[2\] u_pe_array.g_pe_row\[2\].g_pe_col\[3\].u_pe.act_val\[2\]
+ _0769_ VGND VGND VPWR VPWR _1393_ sky130_fd_sc_hd__mux2_1
X_6013_ u_pe_array.g_pe_row\[0\].g_pe_col\[2\].u_pe.psum_out\[11\] _2743_ VGND VGND
+ VPWR VPWR _2845_ sky130_fd_sc_hd__and2b_1
XANTENNA__3969__S _0755_ VGND VGND VPWR VPWR sky130_fd_sc_hd__diode_2
Xclkbuf_leaf_19_clk clknet_3_2__leaf_clk VGND VGND VPWR VPWR clknet_leaf_19_clk sky130_fd_sc_hd__clkbuf_16
XFILLER_0_89_471 VGND VGND VPWR VPWR sky130_fd_sc_hd__fill_2
XTAP_1309 VGND VPWR sky130_fd_sc_hd__tapvpwrvgnd_1
X_6915_ clknet_leaf_37_clk _0001_ net813 VGND VGND VPWR VPWR u_fsm.cnt\[1\] sky130_fd_sc_hd__dfrtp_4
X_6846_ net205 _3124_ _3397_ VGND VGND VPWR VPWR _3405_ sky130_fd_sc_hd__mux2_1
XFILLER_0_92_603 VGND VGND VPWR VPWR sky130_fd_sc_hd__decap_3
XFILLER_0_76_165 VGND VGND VPWR VPWR sky130_fd_sc_hd__fill_2
X_6777_ net530 _3112_ _3366_ VGND VGND VPWR VPWR _3368_ sky130_fd_sc_hd__mux2_1
XANTENNA__5196__B2 _1665_ VGND VGND VPWR VPWR sky130_fd_sc_hd__diode_2
X_3989_ _0864_ _1150_ _1151_ _1144_ net591 VGND VGND VPWR VPWR _0081_ sky130_fd_sc_hd__a32o_1
XFILLER_0_17_254 VGND VGND VPWR VPWR sky130_fd_sc_hd__fill_2
X_5728_ u_pe_array.g_pe_row\[0\].g_pe_col\[3\].u_pe.psum_out\[9\] u_pe_array.g_pe_row\[0\].g_pe_col\[3\].u_pe.move_reg\[9\]
+ _2469_ VGND VGND VPWR VPWR _2603_ sky130_fd_sc_hd__mux2_1
XFILLER_0_72_360 VGND VGND VPWR VPWR sky130_fd_sc_hd__fill_2
XFILLER_0_60_522 VGND VGND VPWR VPWR sky130_fd_sc_hd__fill_2
XFILLER_0_103_613 VGND VGND VPWR VPWR sky130_fd_sc_hd__decap_3
X_5659_ _2543_ _2549_ VGND VGND VPWR VPWR _2551_ sky130_fd_sc_hd__or2_1
XANTENNA__7562__RESET_B net816 VGND VGND VPWR VPWR sky130_fd_sc_hd__diode_2
XFILLER_0_60_544 VGND VGND VPWR VPWR sky130_fd_sc_hd__fill_2
XFILLER_0_5_671 VGND VGND VPWR VPWR sky130_fd_sc_hd__fill_1
XFILLER_0_60_577 VGND VGND VPWR VPWR sky130_fd_sc_hd__fill_1
XFILLER_0_13_471 VGND VGND VPWR VPWR sky130_fd_sc_hd__decap_8
XFILLER_0_32_279 VGND VGND VPWR VPWR sky130_fd_sc_hd__fill_2
Xhold361 u_pe_array.u_fifo1.buffer\[2\]\[1\] VGND VGND VPWR VPWR net437 sky130_fd_sc_hd__dlygate4sd3_1
XFILLER_0_13_493 VGND VGND VPWR VPWR sky130_fd_sc_hd__decap_8
X_7329_ clknet_leaf_80_clk _0386_ net13 VGND VGND VPWR VPWR u_pe_array.g_pe_row\[0\].g_pe_col\[2\].u_pe.w_buffer\[0\]
+ sky130_fd_sc_hd__dfrtp_1
Xhold350 u_pe_array.u_fifo2.buffer\[0\]\[3\] VGND VGND VPWR VPWR net426 sky130_fd_sc_hd__dlygate4sd3_1
Xhold394 u_pe_array.u_fifo1.buffer\[4\]\[1\] VGND VGND VPWR VPWR net470 sky130_fd_sc_hd__dlygate4sd3_1
Xhold383 u_pe_array.u_fifo1.buffer\[6\]\[2\] VGND VGND VPWR VPWR net459 sky130_fd_sc_hd__dlygate4sd3_1
Xhold372 u_pe_array.u_fifo2.buffer\[1\]\[1\] VGND VGND VPWR VPWR net448 sky130_fd_sc_hd__dlygate4sd3_1
XANTENNA__6448__A1 _1810_ VGND VGND VPWR VPWR sky130_fd_sc_hd__diode_2
XANTENNA__4564__A _1536_ VGND VGND VPWR VPWR sky130_fd_sc_hd__diode_2
XFILLER_0_95_441 VGND VGND VPWR VPWR sky130_fd_sc_hd__fill_2
XFILLER_0_67_110 VGND VGND VPWR VPWR sky130_fd_sc_hd__fill_2
XFILLER_0_95_485 VGND VGND VPWR VPWR sky130_fd_sc_hd__fill_1
XFILLER_0_95_474 VGND VGND VPWR VPWR sky130_fd_sc_hd__fill_2
XFILLER_0_83_625 VGND VGND VPWR VPWR sky130_fd_sc_hd__fill_1
XFILLER_0_67_165 VGND VGND VPWR VPWR sky130_fd_sc_hd__decap_3
XFILLER_0_67_154 VGND VGND VPWR VPWR sky130_fd_sc_hd__fill_2
XFILLER_0_36_530 VGND VGND VPWR VPWR sky130_fd_sc_hd__fill_2
XFILLER_0_83_669 VGND VGND VPWR VPWR sky130_fd_sc_hd__decap_3
XFILLER_0_63_371 VGND VGND VPWR VPWR sky130_fd_sc_hd__fill_2
XFILLER_0_63_393 VGND VGND VPWR VPWR sky130_fd_sc_hd__decap_6
XANTENNA__7232__RESET_B net75 VGND VGND VPWR VPWR sky130_fd_sc_hd__diode_2
XFILLER_0_51_577 VGND VGND VPWR VPWR sky130_fd_sc_hd__fill_1
XFILLER_0_48_58 VGND VGND VPWR VPWR sky130_fd_sc_hd__fill_2
XFILLER_0_48_69 VGND VGND VPWR VPWR sky130_fd_sc_hd__fill_2
XANTENNA__4458__B _1536_ VGND VGND VPWR VPWR sky130_fd_sc_hd__diode_2
XFILLER_0_3_27 VPWR VGND VPWR VGND sky130_ef_sc_hd__decap_12
XANTENNA__5289__B _2158_ VGND VGND VPWR VPWR sky130_fd_sc_hd__diode_2
XANTENNA__6611__A1 _1806_ VGND VGND VPWR VPWR sky130_fd_sc_hd__diode_2
XFILLER_0_80_23 VGND VGND VPWR VPWR sky130_fd_sc_hd__fill_2
X_4961_ _1957_ VGND VGND VPWR VPWR _0247_ sky130_fd_sc_hd__clkbuf_1
X_4892_ _1884_ _1887_ _1896_ _0885_ VGND VGND VPWR VPWR _1898_ sky130_fd_sc_hd__o31a_1
X_6700_ net412 _3116_ _3324_ VGND VGND VPWR VPWR _3328_ sky130_fd_sc_hd__mux2_1
XFILLER_0_46_305 VGND VGND VPWR VPWR sky130_fd_sc_hd__fill_1
XFILLER_0_19_519 VGND VGND VPWR VPWR sky130_fd_sc_hd__decap_3
X_3912_ _1094_ _1095_ net821 _0916_ VGND VGND VPWR VPWR _0060_ sky130_fd_sc_hd__a2bb2o_1
XFILLER_0_104_41 VPWR VGND VPWR VGND sky130_ef_sc_hd__decap_12
XFILLER_0_74_658 VGND VGND VPWR VPWR sky130_fd_sc_hd__fill_2
XANTENNA__5178__A1 _1830_ VGND VGND VPWR VPWR sky130_fd_sc_hd__diode_2
XFILLER_0_6_402 VGND VGND VPWR VPWR sky130_fd_sc_hd__fill_2
X_6631_ _0990_ net9 _0747_ VGND VGND VPWR VPWR _3285_ sky130_fd_sc_hd__mux2_1
XFILLER_0_39_390 VGND VGND VPWR VPWR sky130_fd_sc_hd__fill_2
X_3843_ _1030_ u_pe_array.g_pe_row\[3\].g_pe_col\[2\].u_pe.psum_out\[3\] _1009_ VGND
+ VGND VPWR VPWR _1032_ sky130_fd_sc_hd__and3_1
XFILLER_0_104_85 VGND VGND VPWR VPWR sky130_fd_sc_hd__decap_3
XANTENNA__4921__B _1847_ VGND VGND VPWR VPWR sky130_fd_sc_hd__diode_2
X_6562_ _3248_ VGND VGND VPWR VPWR _0557_ sky130_fd_sc_hd__clkbuf_1
XFILLER_0_6_468 VGND VGND VPWR VPWR sky130_fd_sc_hd__fill_2
XFILLER_0_27_574 VGND VGND VPWR VPWR sky130_fd_sc_hd__fill_2
X_3774_ u_pe_array.g_pe_row\[3\].g_pe_col\[3\].u_pe.psum_out\[12\] _0974_ VGND VGND
+ VPWR VPWR _0982_ sky130_fd_sc_hd__xnor2_1
XFILLER_0_81_190 VGND VGND VPWR VPWR sky130_fd_sc_hd__decap_4
X_5513_ _2345_ u_pe_array.g_pe_row\[1\].g_pe_col\[1\].u_pe.psum_out\[9\] VGND VGND
+ VPWR VPWR _2431_ sky130_fd_sc_hd__nor2_1
X_6493_ _3211_ VGND VGND VPWR VPWR _0525_ sky130_fd_sc_hd__clkbuf_1
XFILLER_0_42_555 VPWR VGND VPWR VGND sky130_ef_sc_hd__decap_12
XFILLER_0_112_421 VGND VGND VPWR VPWR sky130_fd_sc_hd__decap_6
X_5444_ u_pe_array.g_pe_row\[1\].g_pe_col\[1\].u_pe.psum_out\[3\] _2367_ VGND VGND
+ VPWR VPWR _2368_ sky130_fd_sc_hd__xor2_1
Xclkbuf_leaf_8_clk clknet_3_0__leaf_clk VGND VGND VPWR VPWR clknet_leaf_8_clk sky130_fd_sc_hd__clkbuf_16
XFILLER_0_112_454 VPWR VGND VPWR VGND sky130_ef_sc_hd__decap_12
X_5375_ u_pe_array.u_fifo1.buffer\[3\]\[3\] _2282_ _2283_ u_pe_array.u_fifo1.buffer\[2\]\[3\]
+ _2311_ VGND VGND VPWR VPWR _2312_ sky130_fd_sc_hd__a221o_1
X_7114_ clknet_leaf_13_clk _0185_ net816 VGND VGND VPWR VPWR u_pe_array.g_pe_row\[2\].g_pe_col\[0\].u_pe.move_reg\[6\]
+ sky130_fd_sc_hd__dfrtp_1
XFILLER_0_59_3 VPWR VGND VPWR VGND sky130_ef_sc_hd__decap_12
XFILLER_0_10_452 VGND VGND VPWR VPWR sky130_fd_sc_hd__decap_4
XFILLER_0_10_430 VGND VGND VPWR VPWR sky130_fd_sc_hd__fill_1
X_4326_ _1425_ _1426_ _1430_ VGND VGND VPWR VPWR _1431_ sky130_fd_sc_hd__nor3_1
XANTENNA__6955__RESET_B net815 VGND VGND VPWR VPWR sky130_fd_sc_hd__diode_2
X_4257_ _1373_ _1376_ _1381_ VGND VGND VPWR VPWR _1382_ sky130_fd_sc_hd__o21ai_1
X_7045_ clknet_leaf_36_clk _0120_ net76 VGND VGND VPWR VPWR u_pe_array.g_pe_row\[3\].g_pe_col\[0\].u_pe.psum_out\[12\]
+ sky130_fd_sc_hd__dfrtp_1
XANTENNA__6850__A1 _3128_ VGND VGND VPWR VPWR sky130_fd_sc_hd__diode_2
X_4188_ _1317_ _1318_ VGND VGND VPWR VPWR _1319_ sky130_fd_sc_hd__xnor2_1
XANTENNA__5405__A2 _2144_ VGND VGND VPWR VPWR sky130_fd_sc_hd__diode_2
XTAP_1117 VGND VPWR sky130_fd_sc_hd__tapvpwrvgnd_1
XTAP_1128 VGND VPWR sky130_fd_sc_hd__tapvpwrvgnd_1
XTAP_1106 VGND VPWR sky130_fd_sc_hd__tapvpwrvgnd_1
XFILLER_0_54_90 VGND VGND VPWR VPWR sky130_fd_sc_hd__fill_2
XFILLER_0_49_132 VGND VGND VPWR VPWR sky130_fd_sc_hd__fill_2
XTAP_1139 VGND VPWR sky130_fd_sc_hd__tapvpwrvgnd_1
XFILLER_0_49_165 VGND VGND VPWR VPWR sky130_fd_sc_hd__decap_3
X_6829_ _3395_ VGND VGND VPWR VPWR _0677_ sky130_fd_sc_hd__clkbuf_1
XFILLER_0_64_102 VGND VGND VPWR VPWR sky130_fd_sc_hd__fill_1
XFILLER_0_9_240 VGND VGND VPWR VPWR sky130_fd_sc_hd__fill_1
XFILLER_0_92_477 VGND VGND VPWR VPWR sky130_fd_sc_hd__fill_2
XFILLER_0_64_179 VGND VGND VPWR VPWR sky130_fd_sc_hd__fill_1
XANTENNA__6684__A4 _1787_ VGND VGND VPWR VPWR sky130_fd_sc_hd__diode_2
Xhold180 u_pe_array.u_fifo2.buffer\[0\]\[6\] VGND VGND VPWR VPWR net256 sky130_fd_sc_hd__dlygate4sd3_1
Xhold191 u_pe_array.u_fifo2.buffer\[5\]\[7\] VGND VGND VPWR VPWR net267 sky130_fd_sc_hd__dlygate4sd3_1
XFILLER_0_87_205 VGND VGND VPWR VPWR sky130_fd_sc_hd__decap_6
XFILLER_0_34_27 VGND VGND VPWR VPWR sky130_fd_sc_hd__fill_1
XFILLER_0_34_38 VGND VGND VPWR VPWR sky130_fd_sc_hd__fill_2
XFILLER_0_68_452 VGND VGND VPWR VPWR sky130_fd_sc_hd__fill_2
XFILLER_0_95_271 VGND VGND VPWR VPWR sky130_fd_sc_hd__fill_2
XANTENNA__5329__S _0828_ VGND VGND VPWR VPWR sky130_fd_sc_hd__diode_2
XFILLER_0_55_157 VGND VGND VPWR VPWR sky130_fd_sc_hd__fill_1
XFILLER_0_24_522 VGND VGND VPWR VPWR sky130_fd_sc_hd__decap_3
XFILLER_0_51_330 VGND VGND VPWR VPWR sky130_fd_sc_hd__decap_4
XFILLER_0_106_270 VGND VGND VPWR VPWR sky130_fd_sc_hd__decap_8
X_3490_ u_pe_array.g_pe_row\[3\].g_pe_col\[0\].u_pe.move_reg\[12\] _0730_ VGND VGND
+ VPWR VPWR _0753_ sky130_fd_sc_hd__or2_1
XFILLER_0_51_352 VGND VGND VPWR VPWR sky130_fd_sc_hd__decap_8
XFILLER_0_3_449 VGND VGND VPWR VPWR sky130_fd_sc_hd__fill_2
XFILLER_0_59_57 VPWR VGND VPWR VGND sky130_ef_sc_hd__decap_12
XANTENNA__5883__A2 _2600_ VGND VGND VPWR VPWR sky130_fd_sc_hd__diode_2
X_5160_ _2123_ _2125_ _2131_ VGND VGND VPWR VPWR _2132_ sky130_fd_sc_hd__o21ai_1
X_5091_ _2066_ _2068_ VGND VGND VPWR VPWR _2070_ sky130_fd_sc_hd__or2_1
X_4111_ _0836_ VGND VGND VPWR VPWR _1258_ sky130_fd_sc_hd__buf_8
X_4042_ u_pe_array.g_pe_row\[3\].g_pe_col\[1\].u_pe.act_val\[5\] VGND VGND VPWR VPWR
+ _1200_ sky130_fd_sc_hd__inv_2
XANTENNA__4843__B1 _1534_ VGND VGND VPWR VPWR sky130_fd_sc_hd__diode_2
X_5993_ _2818_ _2820_ _2821_ _2827_ VGND VGND VPWR VPWR _2828_ sky130_fd_sc_hd__a31oi_2
X_4944_ _1938_ _1943_ _0885_ VGND VGND VPWR VPWR _1945_ sky130_fd_sc_hd__o21ai_1
XANTENNA__6623__S _3269_ VGND VGND VPWR VPWR sky130_fd_sc_hd__diode_2
X_7663_ clknet_leaf_26_clk _0712_ VGND VGND VPWR VPWR u_pe_array.u_fifo1.buffer\[7\]\[8\]
+ sky130_fd_sc_hd__dfxtp_1
X_4875_ _1879_ _1880_ u_pe_array.g_pe_row\[2\].g_pe_col\[0\].u_pe.psum_out\[4\] VGND
+ VGND VPWR VPWR _1882_ sky130_fd_sc_hd__a21o_1
XFILLER_0_74_444 VGND VGND VPWR VPWR sky130_fd_sc_hd__fill_2
X_7594_ clknet_leaf_23_clk _0643_ VGND VGND VPWR VPWR u_pe_array.u_fifo1.buffer\[2\]\[4\]
+ sky130_fd_sc_hd__dfxtp_1
XANTENNA__5020__B1 _0833_ VGND VGND VPWR VPWR sky130_fd_sc_hd__diode_2
XFILLER_0_46_168 VGND VGND VPWR VPWR sky130_fd_sc_hd__decap_4
X_6614_ _3276_ VGND VGND VPWR VPWR _0581_ sky130_fd_sc_hd__clkbuf_1
XANTENNA__7154__RESET_B net814 VGND VGND VPWR VPWR sky130_fd_sc_hd__diode_2
XFILLER_0_27_360 VGND VGND VPWR VPWR sky130_fd_sc_hd__decap_3
XFILLER_0_27_371 VGND VGND VPWR VPWR sky130_fd_sc_hd__fill_2
X_3826_ u_pe_array.g_pe_row\[3\].g_pe_col\[2\].u_pe.act_val\[2\] u_pe_array.g_pe_row\[3\].g_pe_col\[2\].u_pe.w_reg\[0\]
+ VGND VGND VPWR VPWR _1016_ sky130_fd_sc_hd__nand2_1
X_3757_ u_pe_array.g_pe_row\[3\].g_pe_col\[3\].u_pe.psum_out\[10\] _0869_ VGND VGND
+ VPWR VPWR _0967_ sky130_fd_sc_hd__nand2_1
X_6545_ net527 _1788_ _3239_ VGND VGND VPWR VPWR _3240_ sky130_fd_sc_hd__mux2_1
XFILLER_0_42_341 VPWR VGND VPWR VGND sky130_ef_sc_hd__decap_12
X_6476_ _3202_ VGND VGND VPWR VPWR _0517_ sky130_fd_sc_hd__clkbuf_1
X_3688_ u_pe_array.g_pe_row\[3\].g_pe_col\[3\].u_pe.act_val\[4\] u_pe_array.g_pe_row\[3\].g_pe_col\[3\].u_pe.w_reg\[0\]
+ _0869_ _0903_ VGND VGND VPWR VPWR _0904_ sky130_fd_sc_hd__a22o_1
XFILLER_0_30_525 VGND VGND VPWR VPWR sky130_fd_sc_hd__fill_2
X_5427_ u_pe_array.g_pe_row\[1\].g_pe_col\[1\].u_pe.psum_out\[1\] _2348_ _2351_ VGND
+ VGND VPWR VPWR _2352_ sky130_fd_sc_hd__a21o_1
XFILLER_0_30_569 VGND VGND VPWR VPWR sky130_fd_sc_hd__fill_2
X_5358_ u_pe_array.u_fifo1.buffer\[1\]\[1\] _2278_ _2294_ _2296_ VGND VGND VPWR VPWR
+ _2297_ sky130_fd_sc_hd__a211o_1
XANTENNA__3714__C _0869_ VGND VGND VPWR VPWR sky130_fd_sc_hd__diode_2
X_4309_ u_pe_array.g_pe_row\[2\].g_pe_col\[3\].u_pe.act_val\[1\] _1407_ VGND VGND
+ VPWR VPWR _1415_ sky130_fd_sc_hd__or2b_1
X_5289_ u_pe_array.g_pe_row\[1\].g_pe_col\[2\].u_pe.psum_out\[8\] _2158_ VGND VGND
+ VPWR VPWR _2236_ sky130_fd_sc_hd__or2_1
X_7028_ clknet_leaf_78_clk net196 net815 VGND VGND VPWR VPWR u_pe_array.g_pe_row\[2\].g_pe_col\[3\].u_pe.move_reg\[10\]
+ sky130_fd_sc_hd__dfrtp_1
XANTENNA__4826__B _0833_ VGND VGND VPWR VPWR sky130_fd_sc_hd__diode_2
XANTENNA__3637__B2 u_fsm.psum_shift_en VGND VGND VPWR VPWR sky130_fd_sc_hd__diode_2
XFILLER_0_97_525 VGND VGND VPWR VPWR sky130_fd_sc_hd__fill_2
XFILLER_0_97_547 VGND VGND VPWR VPWR sky130_fd_sc_hd__fill_2
XANTENNA__6051__A2 _2738_ VGND VGND VPWR VPWR sky130_fd_sc_hd__diode_2
XANTENNA__6533__S _3224_ VGND VGND VPWR VPWR sky130_fd_sc_hd__diode_2
XFILLER_0_65_433 VGND VGND VPWR VPWR sky130_fd_sc_hd__decap_3
XFILLER_0_65_411 VGND VGND VPWR VPWR sky130_fd_sc_hd__fill_1
XFILLER_0_37_113 VGND VGND VPWR VPWR sky130_fd_sc_hd__fill_1
XFILLER_0_108_557 VPWR VGND VPWR VGND sky130_ef_sc_hd__decap_12
XFILLER_0_65_488 VGND VGND VPWR VPWR sky130_fd_sc_hd__fill_2
XANTENNA__5011__B1 _0833_ VGND VGND VPWR VPWR sky130_fd_sc_hd__diode_2
XFILLER_0_92_296 VGND VGND VPWR VPWR sky130_fd_sc_hd__decap_3
XFILLER_0_20_29 VGND VGND VPWR VPWR sky130_fd_sc_hd__fill_2
XFILLER_0_0_419 VGND VGND VPWR VPWR sky130_fd_sc_hd__fill_1
XANTENNA__3905__B _1009_ VGND VGND VPWR VPWR sky130_fd_sc_hd__diode_2
XANTENNA__4117__A2 _1138_ VGND VGND VPWR VPWR sky130_fd_sc_hd__diode_2
XFILLER_0_29_49 VGND VGND VPWR VPWR sky130_fd_sc_hd__decap_6
XTAP_709 VGND VPWR sky130_fd_sc_hd__tapvpwrvgnd_1
XANTENNA__5865__A2 _2387_ VGND VGND VPWR VPWR sky130_fd_sc_hd__diode_2
XANTENNA__6814__A1 _3120_ VGND VGND VPWR VPWR sky130_fd_sc_hd__diode_2
XANTENNA__5078__B1 _1534_ VGND VGND VPWR VPWR sky130_fd_sc_hd__diode_2
XANTENNA__3628__B2 u_fsm.psum_shift_en VGND VGND VPWR VPWR sky130_fd_sc_hd__diode_2
XFILLER_0_88_503 VGND VGND VPWR VPWR sky130_fd_sc_hd__decap_3
XANTENNA__4752__A _0788_ VGND VGND VPWR VPWR sky130_fd_sc_hd__diode_2
XANTENNA__5848__A _2611_ VGND VGND VPWR VPWR sky130_fd_sc_hd__diode_2
XFILLER_0_56_433 VGND VGND VPWR VPWR sky130_fd_sc_hd__fill_2
XTAP_1492 VGND VPWR sky130_fd_sc_hd__tapvpwrvgnd_1
XTAP_1481 VGND VPWR sky130_fd_sc_hd__tapvpwrvgnd_1
XTAP_1470 VGND VPWR sky130_fd_sc_hd__tapvpwrvgnd_1
XFILLER_0_61_69 VPWR VGND VPWR VGND sky130_ef_sc_hd__decap_12
XFILLER_0_29_658 VGND VGND VPWR VPWR sky130_fd_sc_hd__decap_4
X_4660_ u_pe_array.g_pe_row\[2\].g_pe_col\[1\].u_pe.psum_out\[3\] _1691_ _1692_ VGND
+ VGND VPWR VPWR _1708_ sky130_fd_sc_hd__a21o_1
XFILLER_0_71_403 VGND VGND VPWR VPWR sky130_fd_sc_hd__decap_6
XANTENNA__5002__B1 _0833_ VGND VGND VPWR VPWR sky130_fd_sc_hd__diode_2
XFILLER_0_9_15 VGND VGND VPWR VPWR sky130_fd_sc_hd__decap_3
XFILLER_0_28_168 VGND VGND VPWR VPWR sky130_fd_sc_hd__fill_2
XFILLER_0_28_179 VGND VGND VPWR VPWR sky130_fd_sc_hd__fill_1
XFILLER_0_114_505 VGND VGND VPWR VPWR sky130_fd_sc_hd__decap_6
XFILLER_0_71_436 VPWR VGND VPWR VGND sky130_ef_sc_hd__decap_12
XANTENNA__6679__A _0819_ VGND VGND VPWR VPWR sky130_fd_sc_hd__diode_2
X_3611_ u_pe_array.g_pe_row\[2\].g_pe_col\[2\].u_pe.act_val\[2\] u_pe_array.g_pe_row\[2\].g_pe_col\[2\].u_pe.psum_out\[2\]
+ _0755_ VGND VGND VPWR VPWR _0842_ sky130_fd_sc_hd__mux2_1
X_6330_ _3113_ VGND VGND VPWR VPWR _0460_ sky130_fd_sc_hd__clkbuf_1
X_4591_ net736 _1524_ _1258_ _1653_ VGND VGND VPWR VPWR _0181_ sky130_fd_sc_hd__a22o_1
XFILLER_0_71_469 VGND VGND VPWR VPWR sky130_fd_sc_hd__decap_8
XFILLER_0_24_363 VGND VGND VPWR VPWR sky130_fd_sc_hd__fill_1
X_3542_ u_fsm.ch_cnt\[0\] u_fsm.ch_cnt\[1\] _0785_ _0788_ VGND VGND VPWR VPWR _0789_
+ sky130_fd_sc_hd__a31o_1
X_6261_ _3051_ _3052_ VGND VGND VPWR VPWR _3053_ sky130_fd_sc_hd__or2_2
X_3473_ u_pe_array.g_pe_row\[3\].g_pe_col\[0\].u_pe.act_val\[5\] u_pe_array.g_pe_row\[3\].g_pe_col\[0\].u_pe.psum_out\[5\]
+ _0730_ VGND VGND VPWR VPWR _0743_ sky130_fd_sc_hd__mux2_1
XFILLER_0_3_279 VGND VGND VPWR VPWR sky130_fd_sc_hd__fill_1
XANTENNA__4108__A2 _1138_ VGND VGND VPWR VPWR sky130_fd_sc_hd__diode_2
X_6192_ u_pe_array.g_pe_row\[0\].g_pe_col\[0\].u_pe.act_val\[0\] u_pe_array.g_pe_row\[0\].g_pe_col\[0\].u_pe.w_reg\[0\]
+ u_pe_array.g_pe_row\[0\].g_pe_col\[0\].u_pe.psum_out\[0\] VGND VGND VPWR VPWR _2990_
+ sky130_fd_sc_hd__a21o_1
X_5212_ u_pe_array.g_pe_row\[1\].g_pe_col\[2\].u_pe.psum_out\[1\] _2161_ _2164_ VGND
+ VGND VPWR VPWR _2165_ sky130_fd_sc_hd__a21o_1
XFILLER_0_86_77 VGND VGND VPWR VPWR sky130_fd_sc_hd__decap_4
X_5143_ _2108_ _2110_ _2115_ VGND VGND VPWR VPWR _2117_ sky130_fd_sc_hd__or3_1
X_5074_ _2047_ _2048_ _2052_ VGND VGND VPWR VPWR _2054_ sky130_fd_sc_hd__o21ai_1
XFILLER_0_19_93 VGND VGND VPWR VPWR sky130_fd_sc_hd__decap_4
XANTENNA__4816__A0 _1834_ VGND VGND VPWR VPWR sky130_fd_sc_hd__diode_2
X_4025_ _1170_ _1184_ VGND VGND VPWR VPWR _1185_ sky130_fd_sc_hd__or2_1
XANTENNA__4292__B2 _1399_ VGND VGND VPWR VPWR sky130_fd_sc_hd__diode_2
XANTENNA__6353__S _3110_ VGND VGND VPWR VPWR sky130_fd_sc_hd__diode_2
XANTENNA__6033__A2 _2738_ VGND VGND VPWR VPWR sky130_fd_sc_hd__diode_2
XANTENNA__7335__RESET_B net812 VGND VGND VPWR VPWR sky130_fd_sc_hd__diode_2
XFILLER_0_66_208 VGND VGND VPWR VPWR sky130_fd_sc_hd__decap_3
XANTENNA__4044__A1 _1145_ VGND VGND VPWR VPWR sky130_fd_sc_hd__diode_2
X_5976_ _2810_ _2811_ VGND VGND VPWR VPWR _2812_ sky130_fd_sc_hd__and2_1
X_4927_ net777 VGND VGND VPWR VPWR _1930_ sky130_fd_sc_hd__inv_2
XFILLER_0_19_146 VGND VGND VPWR VPWR sky130_fd_sc_hd__fill_2
X_7646_ clknet_leaf_23_clk _0695_ VGND VGND VPWR VPWR u_pe_array.u_fifo1.buffer\[6\]\[4\]
+ sky130_fd_sc_hd__dfxtp_1
X_4858_ u_pe_array.g_pe_row\[2\].g_pe_col\[0\].u_pe.act_val\[3\] u_pe_array.g_pe_row\[2\].g_pe_col\[0\].u_pe.w_reg\[0\]
+ _1847_ _1865_ VGND VGND VPWR VPWR _1866_ sky130_fd_sc_hd__a22o_1
XFILLER_0_7_541 VPWR VGND VPWR VGND sky130_ef_sc_hd__decap_12
XFILLER_0_105_505 VGND VGND VPWR VPWR sky130_fd_sc_hd__fill_1
X_3809_ _0721_ VGND VGND VPWR VPWR _1004_ sky130_fd_sc_hd__buf_6
XFILLER_0_7_585 VPWR VGND VPWR VGND sky130_ef_sc_hd__decap_12
X_7577_ clknet_leaf_21_clk _0626_ VGND VGND VPWR VPWR u_pe_array.u_fifo1.buffer\[1\]\[0\]
+ sky130_fd_sc_hd__dfxtp_1
XANTENNA__4601__S _0855_ VGND VGND VPWR VPWR sky130_fd_sc_hd__diode_2
X_4789_ _1817_ VGND VGND VPWR VPWR _0215_ sky130_fd_sc_hd__clkbuf_1
XANTENNA__6970__RESET_B net818 VGND VGND VPWR VPWR sky130_fd_sc_hd__diode_2
X_6528_ _3230_ VGND VGND VPWR VPWR _0541_ sky130_fd_sc_hd__clkbuf_1
X_6459_ _3193_ VGND VGND VPWR VPWR _0509_ sky130_fd_sc_hd__clkbuf_1
XFILLER_0_11_580 VGND VGND VPWR VPWR sky130_fd_sc_hd__decap_6
XANTENNA__4283__B2 _1004_ VGND VGND VPWR VPWR sky130_fd_sc_hd__diode_2
XFILLER_0_85_517 VGND VGND VPWR VPWR sky130_fd_sc_hd__fill_2
XANTENNA__3491__C1 _0728_ VGND VGND VPWR VPWR sky130_fd_sc_hd__diode_2
XFILLER_0_38_400 VGND VGND VPWR VPWR sky130_fd_sc_hd__decap_3
XANTENNA__7076__RESET_B net815 VGND VGND VPWR VPWR sky130_fd_sc_hd__diode_2
XANTENNA__7005__RESET_B net816 VGND VGND VPWR VPWR sky130_fd_sc_hd__diode_2
XFILLER_0_108_321 VPWR VGND VPWR VGND sky130_ef_sc_hd__decap_12
XFILLER_0_93_561 VGND VGND VPWR VPWR sky130_fd_sc_hd__fill_2
XANTENNA__3794__A0 _0741_ VGND VGND VPWR VPWR sky130_fd_sc_hd__diode_2
XFILLER_0_26_617 VGND VGND VPWR VPWR sky130_fd_sc_hd__fill_2
XFILLER_0_108_365 VGND VGND VPWR VPWR sky130_fd_sc_hd__decap_8
XFILLER_0_25_149 VGND VGND VPWR VPWR sky130_fd_sc_hd__fill_1
XFILLER_0_34_650 VGND VGND VPWR VPWR sky130_fd_sc_hd__fill_2
XFILLER_0_34_672 VGND VGND VPWR VPWR sky130_fd_sc_hd__fill_2
XFILLER_0_0_216 VGND VGND VPWR VPWR sky130_fd_sc_hd__decap_8
XFILLER_0_0_249 VGND VGND VPWR VPWR sky130_fd_sc_hd__decap_3
XFILLER_0_21_366 VGND VGND VPWR VPWR sky130_fd_sc_hd__decap_4
XTAP_506 VGND VPWR sky130_fd_sc_hd__tapvpwrvgnd_1
XTAP_517 VGND VPWR sky130_fd_sc_hd__tapvpwrvgnd_1
XTAP_528 VGND VPWR sky130_fd_sc_hd__tapvpwrvgnd_1
XTAP_539 VGND VPWR sky130_fd_sc_hd__tapvpwrvgnd_1
XANTENNA__3797__S _0745_ VGND VGND VPWR VPWR sky130_fd_sc_hd__diode_2
XFILLER_0_88_388 VGND VGND VPWR VPWR sky130_fd_sc_hd__decap_3
X_5830_ _2683_ _2686_ _2691_ VGND VGND VPWR VPWR _2693_ sky130_fd_sc_hd__a21oi_1
XANTENNA__5297__B _2158_ VGND VGND VPWR VPWR sky130_fd_sc_hd__diode_2
XFILLER_0_8_316 VPWR VGND VPWR VGND sky130_ef_sc_hd__decap_12
XFILLER_0_29_444 VGND VGND VPWR VPWR sky130_fd_sc_hd__fill_2
X_5761_ u_pe_array.g_pe_row\[0\].g_pe_col\[3\].u_pe.act_val\[2\] VGND VGND VPWR VPWR
+ _2629_ sky130_fd_sc_hd__inv_2
XFILLER_0_84_583 VGND VGND VPWR VPWR sky130_fd_sc_hd__fill_2
X_4712_ _1746_ _1749_ _1754_ VGND VGND VPWR VPWR _1756_ sky130_fd_sc_hd__a21oi_1
XFILLER_0_17_617 VGND VGND VPWR VPWR sky130_fd_sc_hd__decap_3
XFILLER_0_17_639 VGND VGND VPWR VPWR sky130_fd_sc_hd__fill_2
X_7500_ clknet_leaf_4_clk _0549_ VGND VGND VPWR VPWR u_pe_array.u_fifo2.buffer\[5\]\[0\]
+ sky130_fd_sc_hd__dfxtp_1
XFILLER_0_112_41 VPWR VGND VPWR VGND sky130_ef_sc_hd__decap_12
X_5692_ u_pe_array.g_pe_row\[1\].g_pe_col\[0\].u_pe.psum_out\[10\] _2565_ _2573_ _2577_
+ VGND VGND VPWR VPWR _2580_ sky130_fd_sc_hd__a2bb2o_1
XFILLER_0_71_233 VGND VGND VPWR VPWR sky130_fd_sc_hd__decap_3
XFILLER_0_71_222 VGND VGND VPWR VPWR sky130_fd_sc_hd__fill_2
X_7431_ clknet_leaf_7_clk _0480_ net74 VGND VGND VPWR VPWR u_pe_array.u_fifo2.count\[0\]
+ sky130_fd_sc_hd__dfrtp_4
XFILLER_0_44_458 VGND VGND VPWR VPWR sky130_fd_sc_hd__fill_2
XFILLER_0_16_138 VGND VGND VPWR VPWR sky130_fd_sc_hd__fill_2
X_4643_ u_pe_array.g_pe_row\[2\].g_pe_col\[1\].u_pe.act_val\[2\] u_pe_array.g_pe_row\[2\].g_pe_col\[1\].u_pe.act_val\[3\]
+ u_pe_array.g_pe_row\[2\].g_pe_col\[1\].u_pe.w_reg\[0\] _1672_ VGND VGND VPWR VPWR
+ _1692_ sky130_fd_sc_hd__and4b_1
XFILLER_0_71_244 VPWR VGND VPWR VGND sky130_ef_sc_hd__decap_12
XFILLER_0_4_533 VPWR VGND VPWR VGND sky130_ef_sc_hd__decap_12
X_7362_ clknet_leaf_44_clk _0417_ net75 VGND VGND VPWR VPWR u_pe_array.g_pe_row\[0\].g_pe_col\[0\].u_pe.act_val\[1\]
+ sky130_fd_sc_hd__dfrtp_2
Xhold702 u_pe_array.g_pe_row\[1\].g_pe_col\[0\].u_pe.psum_out\[11\] VGND VGND VPWR
+ VPWR net778 sky130_fd_sc_hd__dlygate4sd3_1
X_4574_ _1634_ _1637_ _1642_ VGND VGND VPWR VPWR _1643_ sky130_fd_sc_hd__o21ai_1
XFILLER_0_97_65 VGND VGND VPWR VPWR sky130_fd_sc_hd__fill_2
X_6313_ u_pe_array.g_pe_row\[0\].g_pe_col\[0\].u_pe.psum_out\[9\] u_pe_array.g_pe_row\[0\].g_pe_col\[0\].u_pe.psum_out\[10\]
+ _2992_ VGND VGND VPWR VPWR _3099_ sky130_fd_sc_hd__o21a_1
Xhold746 u_pe_array.g_pe_row\[1\].g_pe_col\[1\].u_pe.psum_out\[8\] VGND VGND VPWR
+ VPWR net830 sky130_fd_sc_hd__dlygate4sd3_1
Xhold713 u_pe_array.g_pe_row\[2\].g_pe_col\[0\].u_pe.act_val\[4\] VGND VGND VPWR VPWR
+ net789 sky130_fd_sc_hd__dlygate4sd3_1
X_3525_ u_pe_array.g_pe_row\[1\].g_pe_col\[0\].u_pe.move_reg\[11\] _0770_ VGND VGND
+ VPWR VPWR _0776_ sky130_fd_sc_hd__or2_1
X_7293_ clknet_leaf_56_clk _0352_ net75 VGND VGND VPWR VPWR u_pe_array.g_pe_row\[1\].g_pe_col\[0\].u_pe.psum_out\[7\]
+ sky130_fd_sc_hd__dfrtp_4
Xhold724 u_pe_array.g_pe_row\[2\].g_pe_col\[3\].u_pe.w_buffer\[0\] VGND VGND VPWR
+ VPWR net800 sky130_fd_sc_hd__dlygate4sd3_1
XFILLER_0_24_182 VGND VGND VPWR VPWR sky130_fd_sc_hd__fill_2
Xhold735 u_pe_array.g_pe_row\[2\].g_pe_col\[2\].u_pe.move_reg\[12\] VGND VGND VPWR
+ VPWR net811 sky130_fd_sc_hd__dlygate4sd3_1
X_6244_ u_pe_array.g_pe_row\[0\].g_pe_col\[0\].u_pe.act_val\[4\] _2992_ VGND VGND
+ VPWR VPWR _3037_ sky130_fd_sc_hd__and2b_1
XFILLER_0_12_388 VGND VGND VPWR VPWR sky130_fd_sc_hd__fill_2
X_3456_ u_pe_array.g_pe_row\[3\].g_pe_col\[0\].u_pe.act_val\[0\] u_pe_array.g_pe_row\[3\].g_pe_col\[0\].u_pe.psum_out\[0\]
+ _0730_ VGND VGND VPWR VPWR _0731_ sky130_fd_sc_hd__mux2_1
X_6175_ u_pe_array.g_pe_row\[0\].g_pe_col\[1\].u_pe.psum_out\[10\] _2975_ _2978_ VGND
+ VGND VPWR VPWR _2979_ sky130_fd_sc_hd__a21oi_1
XFILLER_0_41_3 VGND VGND VPWR VPWR sky130_fd_sc_hd__fill_2
X_5126_ _2090_ _2096_ VGND VGND VPWR VPWR _2101_ sky130_fd_sc_hd__or2b_1
X_5057_ u_pe_array.g_pe_row\[1\].g_pe_col\[3\].u_pe.psum_out\[2\] _2037_ VGND VGND
+ VPWR VPWR _2038_ sky130_fd_sc_hd__xnor2_2
X_4008_ _1166_ _1168_ VGND VGND VPWR VPWR _1169_ sky130_fd_sc_hd__xnor2_1
X_5959_ net754 _2387_ _2795_ _2796_ VGND VGND VPWR VPWR _0406_ sky130_fd_sc_hd__a22o_1
XFILLER_0_1_93 VPWR VGND VPWR VGND sky130_ef_sc_hd__decap_12
XFILLER_0_75_572 VGND VGND VPWR VPWR sky130_fd_sc_hd__fill_1
XFILLER_0_47_252 VGND VGND VPWR VPWR sky130_fd_sc_hd__fill_2
XANTENNA__3776__B1 _0887_ VGND VGND VPWR VPWR sky130_fd_sc_hd__diode_2
X_7629_ clknet_leaf_20_clk _0678_ VGND VGND VPWR VPWR u_pe_array.u_fifo1.buffer\[5\]\[0\]
+ sky130_fd_sc_hd__dfxtp_1
XFILLER_0_50_406 VGND VGND VPWR VPWR sky130_fd_sc_hd__fill_2
XFILLER_0_7_371 VGND VGND VPWR VPWR sky130_fd_sc_hd__fill_2
XFILLER_0_105_368 VGND VGND VPWR VPWR sky130_fd_sc_hd__decap_3
XFILLER_0_30_141 VGND VGND VPWR VPWR sky130_fd_sc_hd__decap_8
XANTENNA__3471__A _0728_ VGND VGND VPWR VPWR sky130_fd_sc_hd__diode_2
Xhold40 _0315_ VGND VGND VPWR VPWR net116 sky130_fd_sc_hd__dlygate4sd3_1
Xhold73 u_pe_array.g_pe_row\[0\].g_pe_col\[1\].u_pe.move_reg\[6\] VGND VGND VPWR VPWR
+ net149 sky130_fd_sc_hd__dlygate4sd3_1
Xhold51 _0311_ VGND VGND VPWR VPWR net127 sky130_fd_sc_hd__dlygate4sd3_1
XANTENNA__7257__RESET_B net812 VGND VGND VPWR VPWR sky130_fd_sc_hd__diode_2
Xhold62 u_pe_array.g_pe_row\[3\].g_pe_col\[1\].u_pe.move_reg\[8\] VGND VGND VPWR VPWR
+ net138 sky130_fd_sc_hd__dlygate4sd3_1
XANTENNA_input25_A v_in1[4] VGND VGND VPWR VPWR sky130_fd_sc_hd__diode_2
XFILLER_0_98_620 VGND VGND VPWR VPWR sky130_fd_sc_hd__decap_3
Xhold95 u_pe_array.g_pe_row\[0\].g_pe_col\[0\].u_pe.move_reg\[6\] VGND VGND VPWR VPWR
+ net171 sky130_fd_sc_hd__dlygate4sd3_1
Xhold84 u_pe_array.g_pe_row\[1\].g_pe_col\[1\].u_pe.move_reg\[12\] VGND VGND VPWR
+ VPWR net160 sky130_fd_sc_hd__dlygate4sd3_1
XFILLER_0_98_653 VPWR VGND VPWR VGND sky130_ef_sc_hd__decap_12
XFILLER_0_97_185 VGND VGND VPWR VPWR sky130_fd_sc_hd__fill_1
XFILLER_0_73_509 VGND VGND VPWR VPWR sky130_fd_sc_hd__fill_2
XFILLER_0_109_641 VPWR VGND VPWR VGND sky130_ef_sc_hd__decap_12
XFILLER_0_66_561 VGND VGND VPWR VPWR sky130_fd_sc_hd__fill_2
XANTENNA__6006__B _2743_ VGND VGND VPWR VPWR sky130_fd_sc_hd__diode_2
XFILLER_0_38_263 VGND VGND VPWR VPWR sky130_fd_sc_hd__decap_6
XFILLER_0_81_575 VGND VGND VPWR VPWR sky130_fd_sc_hd__fill_2
XFILLER_0_81_553 VGND VGND VPWR VPWR sky130_fd_sc_hd__fill_2
XFILLER_0_53_255 VGND VGND VPWR VPWR sky130_fd_sc_hd__decap_3
XFILLER_0_81_586 VGND VGND VPWR VPWR sky130_fd_sc_hd__fill_2
XFILLER_0_53_299 VGND VGND VPWR VPWR sky130_fd_sc_hd__fill_2
XFILLER_0_111_305 VPWR VGND VPWR VGND sky130_ef_sc_hd__decap_12
XFILLER_0_1_503 VGND VGND VPWR VPWR sky130_fd_sc_hd__fill_1
XFILLER_0_34_491 VGND VGND VPWR VPWR sky130_fd_sc_hd__fill_1
XFILLER_0_111_349 VPWR VGND VPWR VGND sky130_ef_sc_hd__decap_12
XFILLER_0_6_27 VGND VGND VPWR VPWR sky130_fd_sc_hd__fill_1
XFILLER_0_1_536 VPWR VGND VPWR VGND sky130_ef_sc_hd__decap_12
XFILLER_0_1_569 VPWR VGND VPWR VGND sky130_ef_sc_hd__decap_12
XFILLER_0_67_57 VGND VGND VPWR VPWR sky130_fd_sc_hd__decap_4
XTAP_314 VGND VPWR sky130_fd_sc_hd__tapvpwrvgnd_1
XTAP_303 VGND VPWR sky130_fd_sc_hd__tapvpwrvgnd_1
X_4290_ net189 _1392_ _1401_ _1399_ VGND VGND VPWR VPWR _0132_ sky130_fd_sc_hd__a22o_1
XFILLER_0_67_68 VGND VGND VPWR VPWR sky130_fd_sc_hd__decap_4
XTAP_358 VGND VPWR sky130_fd_sc_hd__tapvpwrvgnd_1
XTAP_347 VGND VPWR sky130_fd_sc_hd__tapvpwrvgnd_1
XTAP_325 VGND VPWR sky130_fd_sc_hd__tapvpwrvgnd_1
XTAP_336 VGND VPWR sky130_fd_sc_hd__tapvpwrvgnd_1
XTAP_369 VGND VPWR sky130_fd_sc_hd__tapvpwrvgnd_1
XANTENNA_clkbuf_leaf_6_clk_A clknet_3_0__leaf_clk VGND VGND VPWR VPWR sky130_fd_sc_hd__diode_2
XANTENNA__5995__B2 _0875_ VGND VGND VPWR VPWR sky130_fd_sc_hd__diode_2
X_6931_ clknet_leaf_8_clk _0014_ net819 VGND VGND VPWR VPWR u_pe_array.g_pe_row\[3\].g_pe_col\[2\].u_pe.act_val\[3\]
+ sky130_fd_sc_hd__dfrtp_2
X_6862_ net505 _3112_ _3412_ VGND VGND VPWR VPWR _3414_ sky130_fd_sc_hd__mux2_1
XFILLER_0_88_174 VGND VGND VPWR VPWR sky130_fd_sc_hd__decap_8
XFILLER_0_49_539 VGND VGND VPWR VPWR sky130_fd_sc_hd__fill_2
XFILLER_0_49_528 VGND VGND VPWR VPWR sky130_fd_sc_hd__fill_2
XFILLER_0_64_509 VGND VGND VPWR VPWR sky130_fd_sc_hd__fill_2
XFILLER_0_8_102 VGND VGND VPWR VPWR sky130_fd_sc_hd__fill_2
X_5813_ _2611_ u_pe_array.g_pe_row\[0\].g_pe_col\[3\].u_pe.psum_out\[7\] VGND VGND
+ VPWR VPWR _2677_ sky130_fd_sc_hd__xor2_1
XANTENNA__5747__A1 _2258_ VGND VGND VPWR VPWR sky130_fd_sc_hd__diode_2
X_6793_ net289 _3128_ _3366_ VGND VGND VPWR VPWR _3376_ sky130_fd_sc_hd__mux2_1
XFILLER_0_91_306 VGND VGND VPWR VPWR sky130_fd_sc_hd__fill_1
XFILLER_0_57_561 VGND VGND VPWR VPWR sky130_fd_sc_hd__fill_2
XFILLER_0_8_113 VGND VGND VPWR VPWR sky130_fd_sc_hd__fill_2
XFILLER_0_17_403 VGND VGND VPWR VPWR sky130_fd_sc_hd__fill_2
XFILLER_0_17_414 VGND VGND VPWR VPWR sky130_fd_sc_hd__fill_2
XFILLER_0_29_241 VGND VGND VPWR VPWR sky130_fd_sc_hd__fill_1
XANTENNA__6631__S _0747_ VGND VGND VPWR VPWR sky130_fd_sc_hd__diode_2
XFILLER_0_29_285 VGND VGND VPWR VPWR sky130_fd_sc_hd__decap_3
X_5744_ _2609_ _2613_ VGND VGND VPWR VPWR _2614_ sky130_fd_sc_hd__xnor2_1
X_5675_ u_pe_array.g_pe_row\[1\].g_pe_col\[0\].u_pe.psum_out\[9\] _2478_ VGND VGND
+ VPWR VPWR _2565_ sky130_fd_sc_hd__nand2_1
XFILLER_0_17_469 VGND VGND VPWR VPWR sky130_fd_sc_hd__fill_2
X_7414_ clknet_leaf_22_clk _0463_ VGND VGND VPWR VPWR u_pe_array.u_fifo1.buffer\[8\]\[4\]
+ sky130_fd_sc_hd__dfxtp_1
XFILLER_0_89_3 VPWR VGND VPWR VGND sky130_ef_sc_hd__decap_12
X_4626_ u_pe_array.g_pe_row\[2\].g_pe_col\[1\].u_pe.psum_out\[1\] _1675_ VGND VGND
+ VPWR VPWR _1677_ sky130_fd_sc_hd__nand2_1
XFILLER_0_25_480 VGND VGND VPWR VPWR sky130_fd_sc_hd__decap_3
XFILLER_0_32_439 VGND VGND VPWR VPWR sky130_fd_sc_hd__fill_1
XFILLER_0_102_316 VGND VGND VPWR VPWR sky130_fd_sc_hd__fill_2
X_7345_ clknet_leaf_82_clk net86 net13 VGND VGND VPWR VPWR u_pe_array.g_pe_row\[0\].g_pe_col\[2\].u_pe.w_reg\[1\]
+ sky130_fd_sc_hd__dfrtp_1
Xhold510 u_pe_array.g_pe_row\[2\].g_pe_col\[3\].u_pe.act_val\[4\] VGND VGND VPWR VPWR
+ net586 sky130_fd_sc_hd__dlygate4sd3_1
Xhold554 u_pe_array.g_pe_row\[0\].g_pe_col\[2\].u_pe.psum_out\[7\] VGND VGND VPWR
+ VPWR net630 sky130_fd_sc_hd__dlygate4sd3_1
Xhold532 u_pe_array.g_pe_row\[3\].g_pe_col\[2\].u_pe.psum_out\[7\] VGND VGND VPWR
+ VPWR net608 sky130_fd_sc_hd__dlygate4sd3_1
X_4557_ _1626_ VGND VGND VPWR VPWR _1627_ sky130_fd_sc_hd__inv_2
Xhold521 u_pe_array.g_pe_row\[1\].g_pe_col\[3\].u_pe.act_val\[4\] VGND VGND VPWR VPWR
+ net597 sky130_fd_sc_hd__dlygate4sd3_1
Xhold543 u_pe_array.g_pe_row\[1\].g_pe_col\[3\].u_pe.move_reg\[9\] VGND VGND VPWR
+ VPWR net619 sky130_fd_sc_hd__dlygate4sd3_1
Xhold576 u_pe_array.g_pe_row\[3\].g_pe_col\[0\].u_pe.psum_out\[2\] VGND VGND VPWR
+ VPWR net652 sky130_fd_sc_hd__dlygate4sd3_1
X_3508_ _0754_ _0765_ VGND VGND VPWR VPWR _0766_ sky130_fd_sc_hd__and2_1
XFILLER_0_12_174 VPWR VGND VPWR VGND sky130_ef_sc_hd__decap_12
X_4488_ _1553_ _1564_ VGND VGND VPWR VPWR _1565_ sky130_fd_sc_hd__xor2_1
Xhold565 u_pe_array.g_pe_row\[2\].g_pe_col\[2\].u_pe.act_val\[0\] VGND VGND VPWR VPWR
+ net641 sky130_fd_sc_hd__dlygate4sd3_1
X_7276_ clknet_leaf_69_clk _0337_ net814 VGND VGND VPWR VPWR u_pe_array.g_pe_row\[0\].g_pe_col\[3\].u_pe.act_val\[5\]
+ sky130_fd_sc_hd__dfrtp_2
Xhold587 u_pe_array.g_pe_row\[0\].g_pe_col\[3\].u_pe.psum_out\[3\] VGND VGND VPWR
+ VPWR net663 sky130_fd_sc_hd__dlygate4sd3_1
X_6227_ _3018_ _3020_ _3009_ VGND VGND VPWR VPWR _3022_ sky130_fd_sc_hd__o21ai_1
Xhold598 u_pe_array.g_pe_row\[3\].g_pe_col\[3\].u_pe.psum_out\[9\] VGND VGND VPWR
+ VPWR net674 sky130_fd_sc_hd__dlygate4sd3_1
X_6158_ u_pe_array.g_pe_row\[0\].g_pe_col\[1\].u_pe.psum_out\[7\] u_pe_array.g_pe_row\[0\].g_pe_col\[1\].u_pe.psum_out\[8\]
+ _2959_ _2873_ VGND VGND VPWR VPWR _2963_ sky130_fd_sc_hd__o211a_1
XANTENNA__5683__B1 _2478_ VGND VGND VPWR VPWR sky130_fd_sc_hd__diode_2
XTAP_870 VGND VPWR sky130_fd_sc_hd__tapvpwrvgnd_1
XTAP_892 VGND VPWR sky130_fd_sc_hd__tapvpwrvgnd_1
XTAP_881 VGND VPWR sky130_fd_sc_hd__tapvpwrvgnd_1
X_5109_ _2029_ _2084_ u_pe_array.g_pe_row\[1\].g_pe_col\[3\].u_pe.psum_out\[6\] VGND
+ VGND VPWR VPWR _2086_ sky130_fd_sc_hd__a21o_1
X_6089_ _2899_ _2900_ VGND VGND VPWR VPWR _2901_ sky130_fd_sc_hd__and2b_1
XANTENNA__6806__S _3382_ VGND VGND VPWR VPWR sky130_fd_sc_hd__diode_2
XANTENNA__4238__A1 _1273_ VGND VGND VPWR VPWR sky130_fd_sc_hd__diode_2
XANTENNA__5435__B1 _0885_ VGND VGND VPWR VPWR sky130_fd_sc_hd__diode_2
XANTENNA__7350__RESET_B net818 VGND VGND VPWR VPWR sky130_fd_sc_hd__diode_2
XFILLER_0_79_163 VGND VGND VPWR VPWR sky130_fd_sc_hd__decap_4
XFILLER_0_95_656 VGND VGND VPWR VPWR sky130_fd_sc_hd__decap_8
XFILLER_0_94_166 VGND VGND VPWR VPWR sky130_fd_sc_hd__fill_2
XANTENNA__6541__S _3224_ VGND VGND VPWR VPWR sky130_fd_sc_hd__diode_2
XFILLER_0_35_200 VPWR VGND VPWR VGND sky130_ef_sc_hd__decap_12
XFILLER_0_105_121 VGND VGND VPWR VPWR sky130_fd_sc_hd__fill_1
XFILLER_0_90_361 VGND VGND VPWR VPWR sky130_fd_sc_hd__decap_3
XFILLER_0_35_288 VGND VGND VPWR VPWR sky130_fd_sc_hd__fill_2
XFILLER_0_105_176 VGND VGND VPWR VPWR sky130_fd_sc_hd__fill_1
XFILLER_0_50_269 VGND VGND VPWR VPWR sky130_fd_sc_hd__decap_4
Xoutput41 net41 VGND VGND VPWR VPWR psum_out0[2] sky130_fd_sc_hd__clkbuf_4
Xoutput52 net52 VGND VGND VPWR VPWR psum_out1[12] sky130_fd_sc_hd__buf_2
XANTENNA__3913__B _1009_ VGND VGND VPWR VPWR sky130_fd_sc_hd__diode_2
XANTENNA__7091__RESET_B net819 VGND VGND VPWR VPWR sky130_fd_sc_hd__diode_2
XFILLER_0_53_15 VPWR VGND VPWR VGND sky130_ef_sc_hd__decap_12
XANTENNA__7020__RESET_B net819 VGND VGND VPWR VPWR sky130_fd_sc_hd__diode_2
XFILLER_0_98_472 VGND VGND VPWR VPWR sky130_fd_sc_hd__fill_2
XFILLER_0_85_100 VGND VGND VPWR VPWR sky130_fd_sc_hd__fill_2
XFILLER_0_86_645 VGND VGND VPWR VPWR sky130_fd_sc_hd__fill_2
XANTENNA__5729__B2 _2336_ VGND VGND VPWR VPWR sky130_fd_sc_hd__diode_2
XFILLER_0_26_211 VGND VGND VPWR VPWR sky130_fd_sc_hd__fill_1
X_3790_ u_pe_array.g_pe_row\[3\].g_pe_col\[2\].u_pe.psum_out\[3\] u_pe_array.g_pe_row\[3\].g_pe_col\[2\].u_pe.act_val\[3\]
+ _0745_ VGND VGND VPWR VPWR _0992_ sky130_fd_sc_hd__mux2_2
XFILLER_0_109_460 VGND VGND VPWR VPWR sky130_fd_sc_hd__decap_3
XPHY_191 VGND VGND VPWR VPWR sky130_fd_sc_hd__decap_3
XPHY_180 VGND VGND VPWR VPWR sky130_fd_sc_hd__decap_3
XFILLER_0_5_105 VGND VGND VPWR VPWR sky130_fd_sc_hd__decap_6
X_5460_ _2379_ _2380_ _2381_ VGND VGND VPWR VPWR _2383_ sky130_fd_sc_hd__a21oi_1
XFILLER_0_81_383 VGND VGND VPWR VPWR sky130_fd_sc_hd__fill_2
XFILLER_0_5_149 VPWR VGND VPWR VGND sky130_ef_sc_hd__decap_12
XFILLER_0_112_625 VPWR VGND VPWR VGND sky130_ef_sc_hd__decap_12
X_4411_ u_pe_array.g_pe_row\[2\].g_pe_col\[3\].u_pe.psum_out\[10\] _1504_ _1507_ VGND
+ VGND VPWR VPWR _1508_ sky130_fd_sc_hd__a21oi_1
XFILLER_0_41_225 VGND VGND VPWR VPWR sky130_fd_sc_hd__decap_4
X_5391_ u_pe_array.u_fifo1.buffer\[4\]\[5\] _2279_ _2280_ u_pe_array.u_fifo1.buffer\[7\]\[5\]
+ VGND VGND VPWR VPWR _2326_ sky130_fd_sc_hd__a22o_1
XFILLER_0_10_601 VGND VGND VPWR VPWR sky130_fd_sc_hd__fill_1
XFILLER_0_1_333 VGND VGND VPWR VPWR sky130_fd_sc_hd__decap_3
XFILLER_0_112_669 VGND VGND VPWR VPWR sky130_fd_sc_hd__decap_8
XFILLER_0_78_89 VPWR VGND VPWR VGND sky130_ef_sc_hd__decap_12
X_7130_ clknet_leaf_13_clk _0199_ net816 VGND VGND VPWR VPWR u_pe_array.g_pe_row\[2\].g_pe_col\[1\].u_pe.psum_out\[7\]
+ sky130_fd_sc_hd__dfrtp_4
XFILLER_0_10_645 VPWR VGND VPWR VGND sky130_ef_sc_hd__decap_12
X_4342_ _1431_ _1445_ VGND VGND VPWR VPWR _1446_ sky130_fd_sc_hd__or2_1
X_4273_ _0832_ VGND VGND VPWR VPWR _1392_ sky130_fd_sc_hd__buf_6
X_7061_ clknet_leaf_77_clk net87 net815 VGND VGND VPWR VPWR u_pe_array.g_pe_row\[2\].g_pe_col\[3\].u_pe.w_reg\[0\]
+ sky130_fd_sc_hd__dfrtp_4
XANTENNA__7179__RESET_B net815 VGND VGND VPWR VPWR sky130_fd_sc_hd__diode_2
XANTENNA__7108__RESET_B net76 VGND VGND VPWR VPWR sky130_fd_sc_hd__diode_2
X_6012_ u_pe_array.g_pe_row\[0\].g_pe_col\[2\].u_pe.psum_out\[10\] _2830_ _2837_ _2841_
+ VGND VGND VPWR VPWR _2844_ sky130_fd_sc_hd__a2bb2o_1
.ends
