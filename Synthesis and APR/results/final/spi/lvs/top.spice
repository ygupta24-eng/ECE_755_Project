* NGSPICE file created from top.ext - technology: sky130A

* Black-box entry subcircuit for sky130_fd_sc_hd__decap_6 abstract view
.subckt sky130_fd_sc_hd__decap_6 VGND VNB VPB VPWR
.ends

* Black-box entry subcircuit for sky130_ef_sc_hd__decap_12 abstract view
.subckt sky130_ef_sc_hd__decap_12 VPWR VGND VPB VNB
.ends

* Black-box entry subcircuit for sky130_fd_sc_hd__mux2_1 abstract view
.subckt sky130_fd_sc_hd__mux2_1 A0 A1 S VGND VNB VPB VPWR X
.ends

* Black-box entry subcircuit for sky130_fd_sc_hd__dfrtp_4 abstract view
.subckt sky130_fd_sc_hd__dfrtp_4 CLK D RESET_B VGND VNB VPB VPWR Q
.ends

* Black-box entry subcircuit for sky130_fd_sc_hd__decap_4 abstract view
.subckt sky130_fd_sc_hd__decap_4 VGND VNB VPB VPWR
.ends

* Black-box entry subcircuit for sky130_fd_sc_hd__a22o_1 abstract view
.subckt sky130_fd_sc_hd__a22o_1 A1 A2 B1 B2 VGND VNB VPB VPWR X
.ends

* Black-box entry subcircuit for sky130_fd_sc_hd__nand4_1 abstract view
.subckt sky130_fd_sc_hd__nand4_1 A B C D VGND VNB VPB VPWR Y
.ends

* Black-box entry subcircuit for sky130_fd_sc_hd__fill_2 abstract view
.subckt sky130_fd_sc_hd__fill_2 VGND VNB VPB VPWR
.ends

* Black-box entry subcircuit for sky130_fd_sc_hd__nand2_1 abstract view
.subckt sky130_fd_sc_hd__nand2_1 A B VGND VNB VPB VPWR Y
.ends

* Black-box entry subcircuit for sky130_fd_sc_hd__and3_1 abstract view
.subckt sky130_fd_sc_hd__and3_1 A B C VGND VNB VPB VPWR X
.ends

* Black-box entry subcircuit for sky130_fd_sc_hd__fill_1 abstract view
.subckt sky130_fd_sc_hd__fill_1 VGND VNB VPB VPWR
.ends

* Black-box entry subcircuit for sky130_fd_sc_hd__dlygate4sd3_1 abstract view
.subckt sky130_fd_sc_hd__dlygate4sd3_1 A VGND VNB VPB VPWR X
.ends

* Black-box entry subcircuit for sky130_fd_sc_hd__buf_1 abstract view
.subckt sky130_fd_sc_hd__buf_1 A VGND VNB VPB VPWR X
.ends

* Black-box entry subcircuit for sky130_fd_sc_hd__dfrtp_1 abstract view
.subckt sky130_fd_sc_hd__dfrtp_1 CLK D RESET_B VGND VNB VPB VPWR Q
.ends

* Black-box entry subcircuit for sky130_fd_sc_hd__decap_3 abstract view
.subckt sky130_fd_sc_hd__decap_3 VGND VNB VPB VPWR
.ends

* Black-box entry subcircuit for sky130_fd_sc_hd__o211a_1 abstract view
.subckt sky130_fd_sc_hd__o211a_1 A1 A2 B1 C1 VGND VNB VPB VPWR X
.ends

* Black-box entry subcircuit for sky130_fd_sc_hd__clkbuf_16 abstract view
.subckt sky130_fd_sc_hd__clkbuf_16 A VGND VNB VPB VPWR X
.ends

* Black-box entry subcircuit for sky130_fd_sc_hd__or2_1 abstract view
.subckt sky130_fd_sc_hd__or2_1 A B VGND VNB VPB VPWR X
.ends

* Black-box entry subcircuit for sky130_fd_sc_hd__decap_8 abstract view
.subckt sky130_fd_sc_hd__decap_8 VGND VNB VPB VPWR
.ends

* Black-box entry subcircuit for sky130_fd_sc_hd__and2_1 abstract view
.subckt sky130_fd_sc_hd__and2_1 A B VGND VNB VPB VPWR X
.ends

* Black-box entry subcircuit for sky130_fd_sc_hd__a32o_1 abstract view
.subckt sky130_fd_sc_hd__a32o_1 A1 A2 A3 B1 B2 VGND VNB VPB VPWR X
.ends

* Black-box entry subcircuit for sky130_fd_sc_hd__clkbuf_1 abstract view
.subckt sky130_fd_sc_hd__clkbuf_1 A VGND VNB VPB VPWR X
.ends

* Black-box entry subcircuit for sky130_fd_sc_hd__xnor2_1 abstract view
.subckt sky130_fd_sc_hd__xnor2_1 A B VGND VNB VPB VPWR Y
.ends

* Black-box entry subcircuit for sky130_fd_sc_hd__tapvpwrvgnd_1 abstract view
.subckt sky130_fd_sc_hd__tapvpwrvgnd_1 VGND VPWR
.ends

* Black-box entry subcircuit for sky130_fd_sc_hd__dfxtp_1 abstract view
.subckt sky130_fd_sc_hd__dfxtp_1 CLK D VGND VNB VPB VPWR Q
.ends

* Black-box entry subcircuit for sky130_fd_sc_hd__a211o_1 abstract view
.subckt sky130_fd_sc_hd__a211o_1 A1 A2 B1 C1 VGND VNB VPB VPWR X
.ends

* Black-box entry subcircuit for sky130_fd_sc_hd__and3b_1 abstract view
.subckt sky130_fd_sc_hd__and3b_1 A_N B C VGND VNB VPB VPWR X
.ends

* Black-box entry subcircuit for sky130_fd_sc_hd__xor2_1 abstract view
.subckt sky130_fd_sc_hd__xor2_1 A B VGND VNB VPB VPWR X
.ends

* Black-box entry subcircuit for sky130_fd_sc_hd__nor2_1 abstract view
.subckt sky130_fd_sc_hd__nor2_1 A B VGND VNB VPB VPWR Y
.ends

* Black-box entry subcircuit for sky130_fd_sc_hd__dfrtp_2 abstract view
.subckt sky130_fd_sc_hd__dfrtp_2 CLK D RESET_B VGND VNB VPB VPWR Q
.ends

* Black-box entry subcircuit for sky130_fd_sc_hd__a21oi_1 abstract view
.subckt sky130_fd_sc_hd__a21oi_1 A1 A2 B1 VGND VNB VPB VPWR Y
.ends

* Black-box entry subcircuit for sky130_fd_sc_hd__a21o_1 abstract view
.subckt sky130_fd_sc_hd__a21o_1 A1 A2 B1 VGND VNB VPB VPWR X
.ends

* Black-box entry subcircuit for sky130_fd_sc_hd__o21a_1 abstract view
.subckt sky130_fd_sc_hd__o21a_1 A1 A2 B1 VGND VNB VPB VPWR X
.ends

* Black-box entry subcircuit for sky130_fd_sc_hd__a2bb2o_1 abstract view
.subckt sky130_fd_sc_hd__a2bb2o_1 A1_N A2_N B1 B2 VGND VNB VPB VPWR X
.ends

* Black-box entry subcircuit for sky130_fd_sc_hd__and2b_1 abstract view
.subckt sky130_fd_sc_hd__and2b_1 A_N B VGND VNB VPB VPWR X
.ends

* Black-box entry subcircuit for sky130_fd_sc_hd__buf_6 abstract view
.subckt sky130_fd_sc_hd__buf_6 A VGND VNB VPB VPWR X
.ends

* Black-box entry subcircuit for sky130_fd_sc_hd__nor3_1 abstract view
.subckt sky130_fd_sc_hd__nor3_1 A B C VGND VNB VPB VPWR Y
.ends

* Black-box entry subcircuit for sky130_fd_sc_hd__a31o_1 abstract view
.subckt sky130_fd_sc_hd__a31o_1 A1 A2 A3 B1 VGND VNB VPB VPWR X
.ends

* Black-box entry subcircuit for sky130_fd_sc_hd__a21bo_1 abstract view
.subckt sky130_fd_sc_hd__a21bo_1 A1 A2 B1_N VGND VNB VPB VPWR X
.ends

* Black-box entry subcircuit for sky130_fd_sc_hd__diode_2 abstract view
.subckt sky130_fd_sc_hd__diode_2 DIODE VGND VNB VPB VPWR
.ends

* Black-box entry subcircuit for sky130_fd_sc_hd__or2b_1 abstract view
.subckt sky130_fd_sc_hd__or2b_1 A B_N VGND VNB VPB VPWR X
.ends

* Black-box entry subcircuit for sky130_fd_sc_hd__clkbuf_4 abstract view
.subckt sky130_fd_sc_hd__clkbuf_4 A VGND VNB VPB VPWR X
.ends

* Black-box entry subcircuit for sky130_fd_sc_hd__buf_4 abstract view
.subckt sky130_fd_sc_hd__buf_4 A VGND VNB VPB VPWR X
.ends

* Black-box entry subcircuit for sky130_fd_sc_hd__buf_2 abstract view
.subckt sky130_fd_sc_hd__buf_2 A VGND VNB VPB VPWR X
.ends

* Black-box entry subcircuit for sky130_fd_sc_hd__and3_4 abstract view
.subckt sky130_fd_sc_hd__and3_4 A B C VGND VNB VPB VPWR X
.ends

* Black-box entry subcircuit for sky130_fd_sc_hd__o22ai_1 abstract view
.subckt sky130_fd_sc_hd__o22ai_1 A1 A2 B1 B2 VGND VNB VPB VPWR Y
.ends

* Black-box entry subcircuit for sky130_fd_sc_hd__nor4_1 abstract view
.subckt sky130_fd_sc_hd__nor4_1 A B C D VGND VNB VPB VPWR Y
.ends

* Black-box entry subcircuit for sky130_fd_sc_hd__inv_2 abstract view
.subckt sky130_fd_sc_hd__inv_2 A VGND VNB VPB VPWR Y
.ends

* Black-box entry subcircuit for sky130_fd_sc_hd__a21boi_2 abstract view
.subckt sky130_fd_sc_hd__a21boi_2 A1 A2 B1_N VGND VNB VPB VPWR Y
.ends

* Black-box entry subcircuit for sky130_fd_sc_hd__or3b_1 abstract view
.subckt sky130_fd_sc_hd__or3b_1 A B C_N VGND VNB VPB VPWR X
.ends

* Black-box entry subcircuit for sky130_fd_sc_hd__nand3_1 abstract view
.subckt sky130_fd_sc_hd__nand3_1 A B C VGND VNB VPB VPWR Y
.ends

* Black-box entry subcircuit for sky130_fd_sc_hd__a21boi_1 abstract view
.subckt sky130_fd_sc_hd__a21boi_1 A1 A2 B1_N VGND VNB VPB VPWR Y
.ends

* Black-box entry subcircuit for sky130_fd_sc_hd__or3_1 abstract view
.subckt sky130_fd_sc_hd__or3_1 A B C VGND VNB VPB VPWR X
.ends

* Black-box entry subcircuit for sky130_fd_sc_hd__o211a_2 abstract view
.subckt sky130_fd_sc_hd__o211a_2 A1 A2 B1 C1 VGND VNB VPB VPWR X
.ends

* Black-box entry subcircuit for sky130_fd_sc_hd__o21ai_2 abstract view
.subckt sky130_fd_sc_hd__o21ai_2 A1 A2 B1 VGND VNB VPB VPWR Y
.ends

* Black-box entry subcircuit for sky130_fd_sc_hd__buf_12 abstract view
.subckt sky130_fd_sc_hd__buf_12 A VGND VNB VPB VPWR X
.ends

* Black-box entry subcircuit for sky130_fd_sc_hd__o21ai_1 abstract view
.subckt sky130_fd_sc_hd__o21ai_1 A1 A2 B1 VGND VNB VPB VPWR Y
.ends

* Black-box entry subcircuit for sky130_fd_sc_hd__a221o_1 abstract view
.subckt sky130_fd_sc_hd__a221o_1 A1 A2 B1 B2 C1 VGND VNB VPB VPWR X
.ends

* Black-box entry subcircuit for sky130_fd_sc_hd__a211oi_1 abstract view
.subckt sky130_fd_sc_hd__a211oi_1 A1 A2 B1 C1 VGND VNB VPB VPWR Y
.ends

* Black-box entry subcircuit for sky130_fd_sc_hd__and3_2 abstract view
.subckt sky130_fd_sc_hd__and3_2 A B C VGND VNB VPB VPWR X
.ends

* Black-box entry subcircuit for sky130_fd_sc_hd__o2bb2a_1 abstract view
.subckt sky130_fd_sc_hd__o2bb2a_1 A1_N A2_N B1 B2 VGND VNB VPB VPWR X
.ends

* Black-box entry subcircuit for sky130_fd_sc_hd__o21bai_1 abstract view
.subckt sky130_fd_sc_hd__o21bai_1 A1 A2 B1_N VGND VNB VPB VPWR Y
.ends

* Black-box entry subcircuit for sky130_fd_sc_hd__buf_8 abstract view
.subckt sky130_fd_sc_hd__buf_8 A VGND VNB VPB VPWR X
.ends

* Black-box entry subcircuit for sky130_fd_sc_hd__mux2_2 abstract view
.subckt sky130_fd_sc_hd__mux2_2 A0 A1 S VGND VNB VPB VPWR X
.ends

* Black-box entry subcircuit for sky130_fd_sc_hd__or2_2 abstract view
.subckt sky130_fd_sc_hd__or2_2 A B VGND VNB VPB VPWR X
.ends

* Black-box entry subcircuit for sky130_fd_sc_hd__nand3_2 abstract view
.subckt sky130_fd_sc_hd__nand3_2 A B C VGND VNB VPB VPWR Y
.ends

* Black-box entry subcircuit for sky130_fd_sc_hd__o2111a_1 abstract view
.subckt sky130_fd_sc_hd__o2111a_1 A1 A2 B1 C1 D1 VGND VNB VPB VPWR X
.ends

* Black-box entry subcircuit for sky130_fd_sc_hd__o22ai_2 abstract view
.subckt sky130_fd_sc_hd__o22ai_2 A1 A2 B1 B2 VGND VNB VPB VPWR Y
.ends

* Black-box entry subcircuit for sky130_fd_sc_hd__a211oi_2 abstract view
.subckt sky130_fd_sc_hd__a211oi_2 A1 A2 B1 C1 VGND VNB VPB VPWR Y
.ends

* Black-box entry subcircuit for sky130_fd_sc_hd__clkbuf_8 abstract view
.subckt sky130_fd_sc_hd__clkbuf_8 A VGND VNB VPB VPWR X
.ends

* Black-box entry subcircuit for sky130_fd_sc_hd__nand4b_2 abstract view
.subckt sky130_fd_sc_hd__nand4b_2 A_N B C D VGND VNB VPB VPWR Y
.ends

* Black-box entry subcircuit for sky130_fd_sc_hd__or4_1 abstract view
.subckt sky130_fd_sc_hd__or4_1 A B C D VGND VNB VPB VPWR X
.ends

* Black-box entry subcircuit for sky130_fd_sc_hd__o31a_1 abstract view
.subckt sky130_fd_sc_hd__o31a_1 A1 A2 A3 B1 VGND VNB VPB VPWR X
.ends

* Black-box entry subcircuit for sky130_fd_sc_hd__o22a_1 abstract view
.subckt sky130_fd_sc_hd__o22a_1 A1 A2 B1 B2 VGND VNB VPB VPWR X
.ends

* Black-box entry subcircuit for sky130_fd_sc_hd__a311o_1 abstract view
.subckt sky130_fd_sc_hd__a311o_1 A1 A2 A3 B1 C1 VGND VNB VPB VPWR X
.ends

* Black-box entry subcircuit for sky130_fd_sc_hd__o21ba_1 abstract view
.subckt sky130_fd_sc_hd__o21ba_1 A1 A2 B1_N VGND VNB VPB VPWR X
.ends

* Black-box entry subcircuit for sky130_fd_sc_hd__nor2_2 abstract view
.subckt sky130_fd_sc_hd__nor2_2 A B VGND VNB VPB VPWR Y
.ends

* Black-box entry subcircuit for sky130_fd_sc_hd__o211ai_2 abstract view
.subckt sky130_fd_sc_hd__o211ai_2 A1 A2 B1 C1 VGND VNB VPB VPWR Y
.ends

* Black-box entry subcircuit for sky130_fd_sc_hd__clkdlybuf4s25_1 abstract view
.subckt sky130_fd_sc_hd__clkdlybuf4s25_1 A VGND VNB VPB VPWR X
.ends

* Black-box entry subcircuit for sky130_fd_sc_hd__xnor2_2 abstract view
.subckt sky130_fd_sc_hd__xnor2_2 A B VGND VNB VPB VPWR Y
.ends

* Black-box entry subcircuit for sky130_fd_sc_hd__and2_2 abstract view
.subckt sky130_fd_sc_hd__and2_2 A B VGND VNB VPB VPWR X
.ends

* Black-box entry subcircuit for sky130_fd_sc_hd__nand2b_2 abstract view
.subckt sky130_fd_sc_hd__nand2b_2 A_N B VGND VNB VPB VPWR Y
.ends

* Black-box entry subcircuit for sky130_fd_sc_hd__and4bb_2 abstract view
.subckt sky130_fd_sc_hd__and4bb_2 A_N B_N C D VGND VNB VPB VPWR X
.ends

* Black-box entry subcircuit for sky130_fd_sc_hd__and4bb_1 abstract view
.subckt sky130_fd_sc_hd__and4bb_1 A_N B_N C D VGND VNB VPB VPWR X
.ends

* Black-box entry subcircuit for sky130_fd_sc_hd__a41o_1 abstract view
.subckt sky130_fd_sc_hd__a41o_1 A1 A2 A3 A4 B1 VGND VNB VPB VPWR X
.ends

* Black-box entry subcircuit for sky130_fd_sc_hd__a21oi_2 abstract view
.subckt sky130_fd_sc_hd__a21oi_2 A1 A2 B1 VGND VNB VPB VPWR Y
.ends

* Black-box entry subcircuit for sky130_fd_sc_hd__and3b_2 abstract view
.subckt sky130_fd_sc_hd__and3b_2 A_N B C VGND VNB VPB VPWR X
.ends

* Black-box entry subcircuit for sky130_fd_sc_hd__o32a_2 abstract view
.subckt sky130_fd_sc_hd__o32a_2 A1 A2 A3 B1 B2 VGND VNB VPB VPWR X
.ends

* Black-box entry subcircuit for sky130_fd_sc_hd__inv_8 abstract view
.subckt sky130_fd_sc_hd__inv_8 A VGND VNB VPB VPWR Y
.ends

* Black-box entry subcircuit for sky130_fd_sc_hd__o41a_2 abstract view
.subckt sky130_fd_sc_hd__o41a_2 A1 A2 A3 A4 B1 VGND VNB VPB VPWR X
.ends

* Black-box entry subcircuit for sky130_fd_sc_hd__nand2_8 abstract view
.subckt sky130_fd_sc_hd__nand2_8 A B VGND VNB VPB VPWR Y
.ends

* Black-box entry subcircuit for sky130_fd_sc_hd__nor2_8 abstract view
.subckt sky130_fd_sc_hd__nor2_8 A B VGND VNB VPB VPWR Y
.ends

* Black-box entry subcircuit for sky130_fd_sc_hd__a21oi_4 abstract view
.subckt sky130_fd_sc_hd__a21oi_4 A1 A2 B1 VGND VNB VPB VPWR Y
.ends

* Black-box entry subcircuit for sky130_fd_sc_hd__dlymetal6s2s_1 abstract view
.subckt sky130_fd_sc_hd__dlymetal6s2s_1 A VGND VNB VPB VPWR X
.ends

* Black-box entry subcircuit for sky130_fd_sc_hd__nor3b_4 abstract view
.subckt sky130_fd_sc_hd__nor3b_4 A B C_N VGND VNB VPB VPWR Y
.ends

* Black-box entry subcircuit for sky130_fd_sc_hd__nand2_4 abstract view
.subckt sky130_fd_sc_hd__nand2_4 A B VGND VNB VPB VPWR Y
.ends

* Black-box entry subcircuit for sky130_fd_sc_hd__clkbuf_2 abstract view
.subckt sky130_fd_sc_hd__clkbuf_2 A VGND VNB VPB VPWR X
.ends

* Black-box entry subcircuit for sky130_fd_sc_hd__or4b_1 abstract view
.subckt sky130_fd_sc_hd__or4b_1 A B C D_N VGND VNB VPB VPWR X
.ends

* Black-box entry subcircuit for sky130_fd_sc_hd__and4b_2 abstract view
.subckt sky130_fd_sc_hd__and4b_2 A_N B C D VGND VNB VPB VPWR X
.ends

* Black-box entry subcircuit for sky130_fd_sc_hd__clkinv_4 abstract view
.subckt sky130_fd_sc_hd__clkinv_4 A VGND VNB VPB VPWR Y
.ends

* Black-box entry subcircuit for sky130_fd_sc_hd__o31a_2 abstract view
.subckt sky130_fd_sc_hd__o31a_2 A1 A2 A3 B1 VGND VNB VPB VPWR X
.ends

* Black-box entry subcircuit for sky130_fd_sc_hd__and4b_1 abstract view
.subckt sky130_fd_sc_hd__and4b_1 A_N B C D VGND VNB VPB VPWR X
.ends

* Black-box entry subcircuit for sky130_fd_sc_hd__or4_2 abstract view
.subckt sky130_fd_sc_hd__or4_2 A B C D VGND VNB VPB VPWR X
.ends

* Black-box entry subcircuit for sky130_fd_sc_hd__o211ai_1 abstract view
.subckt sky130_fd_sc_hd__o211ai_1 A1 A2 B1 C1 VGND VNB VPB VPWR Y
.ends

* Black-box entry subcircuit for sky130_fd_sc_hd__nor2b_2 abstract view
.subckt sky130_fd_sc_hd__nor2b_2 A B_N VGND VNB VPB VPWR Y
.ends

* Black-box entry subcircuit for sky130_fd_sc_hd__o32a_1 abstract view
.subckt sky130_fd_sc_hd__o32a_1 A1 A2 A3 B1 B2 VGND VNB VPB VPWR X
.ends

* Black-box entry subcircuit for sky130_fd_sc_hd__or4bb_2 abstract view
.subckt sky130_fd_sc_hd__or4bb_2 A B C_N D_N VGND VNB VPB VPWR X
.ends

* Black-box entry subcircuit for sky130_fd_sc_hd__or3_2 abstract view
.subckt sky130_fd_sc_hd__or3_2 A B C VGND VNB VPB VPWR X
.ends

* Black-box entry subcircuit for sky130_fd_sc_hd__nor3b_1 abstract view
.subckt sky130_fd_sc_hd__nor3b_1 A B C_N VGND VNB VPB VPWR Y
.ends

.subckt top VGND VPWR clk done h_in0[0] h_in0[1] h_in0[2] h_in0[3] h_in0[4] h_in0[5]
+ h_in1[0] h_in1[1] h_in1[2] h_in1[3] h_in1[4] h_in1[5] psum_out0[0] psum_out0[10]
+ psum_out0[11] psum_out0[12] psum_out0[1] psum_out0[2] psum_out0[3] psum_out0[4]
+ psum_out0[5] psum_out0[6] psum_out0[7] psum_out0[8] psum_out0[9] psum_out1[0] psum_out1[10]
+ psum_out1[11] psum_out1[12] psum_out1[1] psum_out1[2] psum_out1[3] psum_out1[4]
+ psum_out1[5] psum_out1[6] psum_out1[7] psum_out1[8] psum_out1[9] rst_n start v_in0[0]
+ v_in0[1] v_in0[2] v_in0[3] v_in0[4] v_in0[5] v_in1[0] v_in1[1] v_in1[2] v_in1[3]
+ v_in1[4] v_in1[5] w_in_flat[0] w_in_flat[1] w_in_flat[2] w_in_flat[3] w_in_flat[4]
+ w_in_flat[5] w_in_flat[6] w_in_flat[7]
XFILLER_0_94_77 VGND VGND VPWR VPWR sky130_fd_sc_hd__decap_6
XFILLER_0_76_100 VPWR VGND VPWR VGND sky130_ef_sc_hd__decap_12
X_6914_ _0911_ net760 _3439_ VGND VGND VPWR VPWR _3440_ sky130_fd_sc_hd__mux2_1
X_7894_ clknet_leaf_84_clk _0799_ net948 VGND VGND VPWR VPWR u_pe_array.u_fifo1.count\[0\]
+ sky130_fd_sc_hd__dfrtp_4
XFILLER_0_18_701 VGND VGND VPWR VPWR sky130_fd_sc_hd__decap_4
X_6845_ net623 _0911_ _3400_ VGND VGND VPWR VPWR _3401_ sky130_fd_sc_hd__mux2_1
X_3988_ net916 _1007_ _1191_ _1021_ VGND VGND VPWR VPWR _0099_ sky130_fd_sc_hd__a22o_1
X_6776_ _3354_ net775 _3352_ VGND VGND VPWR VPWR _3355_ sky130_fd_sc_hd__mux2_1
X_5727_ _2533_ u_pe_array.g_pe_row\[1\].g_pe_col\[1\].u_pe.act_val\[3\] u_pe_array.g_pe_row\[1\].g_pe_col\[1\].u_pe.w_out\[0\]
+ _1728_ VGND VGND VPWR VPWR _2535_ sky130_fd_sc_hd__nand4_1
XFILLER_0_9_499 VGND VGND VPWR VPWR sky130_fd_sc_hd__decap_4
XFILLER_0_115_430 VPWR VGND VPWR VGND sky130_ef_sc_hd__decap_12
X_5658_ u_pe_array.g_pe_row\[1\].g_pe_col\[1\].u_pe.psum_out\[2\] u_pe_array.g_pe_row\[1\].g_pe_col\[1\].u_pe.act_val\[2\]
+ _2133_ VGND VGND VPWR VPWR _2493_ sky130_fd_sc_hd__mux2_1
XFILLER_0_103_614 VGND VGND VPWR VPWR sky130_fd_sc_hd__fill_2
XFILLER_0_60_589 VGND VGND VPWR VPWR sky130_fd_sc_hd__decap_4
X_4609_ u_pe_array.g_pe_row\[2\].g_pe_col\[3\].u_pe.psum_out\[5\] _1427_ VGND VGND
+ VPWR VPWR _1673_ sky130_fd_sc_hd__nand2_1
X_5589_ _2431_ _2432_ _2434_ VGND VGND VPWR VPWR _2435_ sky130_fd_sc_hd__and3_1
XFILLER_0_102_168 VGND VGND VPWR VPWR sky130_fd_sc_hd__fill_1
Xhold362 u_pe_array.g_pe_row\[0\].g_pe_col\[1\].u_pe.move_reg\[9\] VGND VGND VPWR
+ VPWR net436 sky130_fd_sc_hd__dlygate4sd3_1
Xhold351 u_pe_array.act_from_down\[3\]\[3\] VGND VGND VPWR VPWR net425 sky130_fd_sc_hd__buf_1
XFILLER_0_7_81 VPWR VGND VPWR VGND sky130_ef_sc_hd__decap_12
X_7328_ clknet_leaf_1_clk _0234_ net944 VGND VGND VPWR VPWR u_pe_array.g_pe_row\[2\].g_pe_col\[3\].u_pe.psum_out\[1\]
+ sky130_fd_sc_hd__dfrtp_1
Xhold340 u_pe_array.act_from_up\[6\]\[5\] VGND VGND VPWR VPWR net414 sky130_fd_sc_hd__dlygate4sd3_1
Xhold395 u_pe_array.act_from_down\[1\]\[0\] VGND VGND VPWR VPWR net469 sky130_fd_sc_hd__buf_1
Xhold373 u_pe_array.act_from_up\[12\]\[11\] VGND VGND VPWR VPWR net447 sky130_fd_sc_hd__dlygate4sd3_1
Xhold384 u_pe_array.g_pe_row\[2\].g_pe_col\[3\].u_pe.move_reg\[11\] VGND VGND VPWR
+ VPWR net458 sky130_fd_sc_hd__dlygate4sd3_1
X_7259_ clknet_leaf_77_clk _0165_ net949 VGND VGND VPWR VPWR net52 sky130_fd_sc_hd__dfrtp_1
XFILLER_0_99_225 VGND VGND VPWR VPWR sky130_fd_sc_hd__fill_2
XFILLER_0_99_269 VGND VGND VPWR VPWR sky130_fd_sc_hd__fill_2
XFILLER_0_67_133 VGND VGND VPWR VPWR sky130_fd_sc_hd__fill_1
XFILLER_0_55_306 VGND VGND VPWR VPWR sky130_fd_sc_hd__fill_1
XFILLER_0_82_125 VGND VGND VPWR VPWR sky130_fd_sc_hd__fill_1
XFILLER_0_67_188 VGND VGND VPWR VPWR sky130_fd_sc_hd__decap_6
XFILLER_0_48_380 VGND VGND VPWR VPWR sky130_fd_sc_hd__decap_4
XFILLER_0_36_531 VGND VGND VPWR VPWR sky130_fd_sc_hd__fill_1
XFILLER_0_63_350 VPWR VGND VPWR VGND sky130_ef_sc_hd__decap_12
XFILLER_0_3_609 VGND VGND VPWR VPWR sky130_fd_sc_hd__decap_6
XFILLER_0_51_501 VGND VGND VPWR VPWR sky130_fd_sc_hd__decap_3
XFILLER_0_106_463 VGND VGND VPWR VPWR sky130_fd_sc_hd__decap_4
XFILLER_0_23_225 VGND VGND VPWR VPWR sky130_fd_sc_hd__decap_4
XFILLER_0_48_15 VGND VGND VPWR VPWR sky130_fd_sc_hd__decap_4
XFILLER_0_48_37 VGND VGND VPWR VPWR sky130_fd_sc_hd__decap_6
XFILLER_0_64_36 VGND VGND VPWR VPWR sky130_fd_sc_hd__decap_6
XFILLER_0_3_39 VPWR VGND VPWR VGND sky130_ef_sc_hd__decap_12
XFILLER_0_58_100 VGND VGND VPWR VPWR sky130_fd_sc_hd__decap_3
X_4960_ u_pe_array.g_pe_row\[2\].g_pe_col\[1\].u_pe.act_val\[5\] u_pe_array.g_pe_row\[2\].g_pe_col\[1\].u_pe.w_out\[0\]
+ _1929_ VGND VGND VPWR VPWR _1942_ sky130_fd_sc_hd__and3_1
XFILLER_0_58_111 VGND VGND VPWR VPWR sky130_fd_sc_hd__decap_4
XFILLER_0_86_475 VGND VGND VPWR VPWR sky130_fd_sc_hd__fill_1
X_4891_ u_pe_array.act_from_down\[9\]\[9\] _1750_ _1483_ net295 VGND VGND VPWR VPWR
+ _0311_ sky130_fd_sc_hd__a22o_1
X_3911_ u_pe_array.g_pe_row\[3\].g_pe_col\[2\].u_pe.psum_out\[9\] _1112_ _1109_ _1146_
+ VGND VGND VPWR VPWR _1147_ sky130_fd_sc_hd__o211a_1
XFILLER_0_104_53 VPWR VGND VPWR VGND sky130_ef_sc_hd__decap_12
X_6630_ net499 _1731_ _1734_ _3239_ VGND VGND VPWR VPWR _0693_ sky130_fd_sc_hd__a22o_1
XFILLER_0_13_51 VGND VGND VPWR VPWR sky130_fd_sc_hd__decap_4
X_3842_ _0894_ VGND VGND VPWR VPWR _1092_ sky130_fd_sc_hd__clkbuf_16
X_6561_ _3183_ _3187_ VGND VGND VPWR VPWR _3188_ sky130_fd_sc_hd__or2_1
XFILLER_0_104_97 VPWR VGND VPWR VGND sky130_ef_sc_hd__decap_12
XFILLER_0_73_169 VGND VGND VPWR VPWR sky130_fd_sc_hd__decap_8
X_3773_ _1026_ _1027_ VGND VGND VPWR VPWR _1029_ sky130_fd_sc_hd__and2_1
XFILLER_0_54_361 VGND VGND VPWR VPWR sky130_fd_sc_hd__decap_3
XFILLER_0_14_214 VGND VGND VPWR VPWR sky130_fd_sc_hd__decap_6
X_5512_ u_pe_array.u_fifo2.buffer\[0\]\[5\] _2324_ VGND VGND VPWR VPWR _2372_ sky130_fd_sc_hd__or2_1
XFILLER_0_42_523 VGND VGND VPWR VPWR sky130_fd_sc_hd__decap_4
X_6492_ _2795_ _3123_ _3124_ _1005_ net510 VGND VGND VPWR VPWR _0670_ sky130_fd_sc_hd__a32o_1
XFILLER_0_112_433 VPWR VGND VPWR VGND sky130_ef_sc_hd__decap_12
XFILLER_0_14_269 VGND VGND VPWR VPWR sky130_fd_sc_hd__fill_1
XFILLER_0_42_567 VGND VGND VPWR VPWR sky130_fd_sc_hd__fill_1
X_5443_ _2317_ VGND VGND VPWR VPWR _0428_ sky130_fd_sc_hd__clkbuf_1
XFILLER_0_112_455 VPWR VGND VPWR VGND sky130_ef_sc_hd__decap_12
X_5374_ u_pe_array.g_pe_row\[0\].g_pe_col\[1\].u_pe.w_out\[0\] u_pe_array.g_pe_row\[1\].g_pe_col\[1\].u_pe.w_out\[0\]
+ _0931_ VGND VGND VPWR VPWR _2267_ sky130_fd_sc_hd__mux2_1
XFILLER_0_100_606 VGND VGND VPWR VPWR sky130_fd_sc_hd__decap_4
X_4325_ u_pe_array.g_pe_row\[3\].g_pe_col\[0\].u_pe.move_reg\[11\] net62 VGND VGND
+ VPWR VPWR _1464_ sky130_fd_sc_hd__or2_1
XFILLER_0_10_431 VGND VGND VPWR VPWR sky130_fd_sc_hd__decap_8
X_7113_ clknet_leaf_5_clk _0019_ net944 VGND VGND VPWR VPWR u_pe_array.act_from_down\[11\]\[2\]
+ sky130_fd_sc_hd__dfrtp_1
X_4256_ _1406_ _1410_ VGND VGND VPWR VPWR _1411_ sky130_fd_sc_hd__nand2_1
X_7044_ _3517_ VGND VGND VPWR VPWR _0829_ sky130_fd_sc_hd__clkbuf_1
X_4187_ _1343_ _1347_ VGND VGND VPWR VPWR _1348_ sky130_fd_sc_hd__xnor2_1
XTAP_1129 VGND VPWR sky130_fd_sc_hd__tapvpwrvgnd_1
XTAP_1118 VGND VPWR sky130_fd_sc_hd__tapvpwrvgnd_1
XTAP_1107 VGND VPWR sky130_fd_sc_hd__tapvpwrvgnd_1
XFILLER_0_49_111 VGND VGND VPWR VPWR sky130_fd_sc_hd__fill_1
XFILLER_0_49_122 VGND VGND VPWR VPWR sky130_fd_sc_hd__decap_6
XFILLER_0_92_401 VPWR VGND VPWR VGND sky130_ef_sc_hd__decap_12
XFILLER_0_65_604 VGND VGND VPWR VPWR sky130_fd_sc_hd__decap_4
X_7877_ clknet_leaf_102_clk _0782_ VGND VGND VPWR VPWR u_pe_array.u_fifo2.buffer\[6\]\[5\]
+ sky130_fd_sc_hd__dfxtp_1
X_6828_ net913 _3379_ _3382_ _3390_ VGND VGND VPWR VPWR _0740_ sky130_fd_sc_hd__a211o_1
XFILLER_0_37_328 VGND VGND VPWR VPWR sky130_fd_sc_hd__fill_1
XFILLER_0_64_136 VGND VGND VPWR VPWR sky130_fd_sc_hd__decap_4
X_6759_ u_pe_array.g_pe_row\[0\].g_pe_col\[0\].u_pe.psum_out\[11\] _3340_ _3331_ VGND
+ VGND VPWR VPWR _3341_ sky130_fd_sc_hd__mux2_1
XFILLER_0_33_534 VGND VGND VPWR VPWR sky130_fd_sc_hd__decap_6
XFILLER_0_45_383 VGND VGND VPWR VPWR sky130_fd_sc_hd__decap_8
XFILLER_0_115_293 VPWR VGND VPWR VGND sky130_ef_sc_hd__decap_12
XFILLER_0_103_488 VPWR VGND VPWR VGND sky130_ef_sc_hd__decap_12
Xhold170 u_pe_array.g_pe_row\[0\].g_pe_col\[1\].u_pe.move_reg\[10\] VGND VGND VPWR
+ VPWR net244 sky130_fd_sc_hd__dlygate4sd3_1
Xhold192 _0667_ VGND VGND VPWR VPWR net266 sky130_fd_sc_hd__dlygate4sd3_1
Xhold181 u_pe_array.act_from_right\[13\]\[9\] VGND VGND VPWR VPWR net255 sky130_fd_sc_hd__dlygate4sd3_1
XFILLER_0_18_29 VPWR VGND VPWR VGND sky130_ef_sc_hd__decap_12
XTAP_1641 VGND VPWR sky130_fd_sc_hd__tapvpwrvgnd_1
XTAP_1630 VGND VPWR sky130_fd_sc_hd__tapvpwrvgnd_1
XTAP_1685 VGND VPWR sky130_fd_sc_hd__tapvpwrvgnd_1
XTAP_1674 VGND VPWR sky130_fd_sc_hd__tapvpwrvgnd_1
XTAP_1652 VGND VPWR sky130_fd_sc_hd__tapvpwrvgnd_1
XTAP_1663 VGND VPWR sky130_fd_sc_hd__tapvpwrvgnd_1
XFILLER_0_55_125 VGND VGND VPWR VPWR sky130_fd_sc_hd__decap_4
XTAP_1696 VGND VPWR sky130_fd_sc_hd__tapvpwrvgnd_1
XFILLER_0_83_445 VGND VGND VPWR VPWR sky130_fd_sc_hd__decap_3
XFILLER_0_50_27 VGND VGND VPWR VPWR sky130_fd_sc_hd__fill_1
XFILLER_0_71_629 VGND VGND VPWR VPWR sky130_fd_sc_hd__fill_1
XFILLER_0_70_106 VGND VGND VPWR VPWR sky130_fd_sc_hd__fill_1
XFILLER_0_55_169 VGND VGND VPWR VPWR sky130_fd_sc_hd__decap_4
XFILLER_0_3_417 VPWR VGND VPWR VGND sky130_ef_sc_hd__decap_12
X_5090_ u_pe_array.g_pe_row\[2\].g_pe_col\[0\].u_pe.act_val\[1\] u_pe_array.g_pe_row\[2\].g_pe_col\[0\].u_pe.psum_out\[2\]
+ _1286_ VGND VGND VPWR VPWR _2034_ sky130_fd_sc_hd__and3b_1
XFILLER_0_75_24 VGND VGND VPWR VPWR sky130_fd_sc_hd__decap_3
X_4110_ u_pe_array.g_pe_row\[3\].g_pe_col\[1\].u_pe.psum_out\[6\] u_pe_array.g_pe_row\[3\].g_pe_col\[1\].u_pe.move_reg\[6\]
+ _0947_ VGND VGND VPWR VPWR _1295_ sky130_fd_sc_hd__mux2_1
X_4041_ u_pe_array.g_pe_row\[3\].g_pe_col\[2\].u_pe.psum_out\[7\] _0934_ VGND VGND
+ VPWR VPWR _1240_ sky130_fd_sc_hd__nand2_1
XFILLER_0_38_9 VGND VGND VPWR VPWR sky130_fd_sc_hd__fill_1
X_7800_ clknet_leaf_51_clk net129 net74 VGND VGND VPWR VPWR u_pe_array.g_pe_row\[0\].g_pe_col\[0\].u_pe.move_reg\[8\]
+ sky130_fd_sc_hd__dfrtp_1
X_5992_ _2742_ _2746_ VGND VGND VPWR VPWR _2747_ sky130_fd_sc_hd__xor2_1
X_4943_ _1918_ _1926_ VGND VGND VPWR VPWR _1927_ sky130_fd_sc_hd__nor2_1
X_7731_ clknet_leaf_73_clk _0637_ net13 VGND VGND VPWR VPWR u_pe_array.g_pe_row\[0\].g_pe_col\[2\].u_pe.psum_out\[9\]
+ sky130_fd_sc_hd__dfrtp_2
XFILLER_0_47_615 VGND VGND VPWR VPWR sky130_fd_sc_hd__fill_1
X_7662_ clknet_leaf_63_clk _0568_ net74 VGND VGND VPWR VPWR u_pe_array.act_from_right\[2\]\[7\]
+ sky130_fd_sc_hd__dfrtp_1
XFILLER_0_117_503 VGND VGND VPWR VPWR sky130_fd_sc_hd__fill_1
X_6613_ u_pe_array.g_pe_row\[0\].g_pe_col\[0\].u_pe.psum_out\[1\] u_pe_array.g_pe_row\[0\].g_pe_col\[0\].u_pe.act_val\[1\]
+ _3102_ VGND VGND VPWR VPWR _3231_ sky130_fd_sc_hd__mux2_1
X_4874_ net453 _1749_ _1873_ _1878_ VGND VGND VPWR VPWR _0298_ sky130_fd_sc_hd__a22o_1
X_7593_ clknet_leaf_47_clk _0499_ net73 VGND VGND VPWR VPWR u_pe_array.g_pe_row\[1\].g_pe_col\[1\].u_pe.psum_out\[7\]
+ sky130_fd_sc_hd__dfrtp_4
X_3825_ _1003_ _1076_ VGND VGND VPWR VPWR _1077_ sky130_fd_sc_hd__nor2_1
XFILLER_0_74_489 VGND VGND VPWR VPWR sky130_fd_sc_hd__decap_3
XFILLER_0_61_117 VGND VGND VPWR VPWR sky130_fd_sc_hd__fill_1
XFILLER_0_34_309 VGND VGND VPWR VPWR sky130_fd_sc_hd__decap_3
X_6544_ u_pe_array.g_pe_row\[0\].g_pe_col\[1\].u_pe.act_val\[5\] u_pe_array.g_pe_row\[0\].g_pe_col\[1\].u_pe.w_out\[0\]
+ _3159_ VGND VGND VPWR VPWR _3172_ sky130_fd_sc_hd__and3_1
X_3756_ _1011_ _1012_ VGND VGND VPWR VPWR _1013_ sky130_fd_sc_hd__nand2_1
X_6475_ u_pe_array.act_from_down\[1\]\[6\] _0866_ _0940_ net202 VGND VGND VPWR VPWR
+ _0662_ sky130_fd_sc_hd__a22o_1
XFILLER_0_70_651 VGND VGND VPWR VPWR sky130_fd_sc_hd__fill_1
XFILLER_0_30_504 VGND VGND VPWR VPWR sky130_fd_sc_hd__decap_8
XFILLER_0_42_353 VGND VGND VPWR VPWR sky130_fd_sc_hd__fill_1
X_3687_ u_pe_array.g_pe_row\[3\].g_pe_col\[3\].u_pe.psum_out\[12\] u_pe_array.g_pe_row\[3\].g_pe_col\[3\].u_pe.move_reg\[12\]
+ _0947_ VGND VGND VPWR VPWR _0961_ sky130_fd_sc_hd__mux2_1
X_5426_ net95 _2306_ _2273_ VGND VGND VPWR VPWR _2307_ sky130_fd_sc_hd__mux2_1
XFILLER_0_100_414 VGND VGND VPWR VPWR sky130_fd_sc_hd__decap_6
XFILLER_0_100_458 VPWR VGND VPWR VGND sky130_ef_sc_hd__decap_12
XFILLER_0_100_447 VGND VGND VPWR VPWR sky130_fd_sc_hd__decap_3
X_5357_ _2251_ _2252_ VGND VGND VPWR VPWR _2253_ sky130_fd_sc_hd__and2_1
X_4308_ _1451_ VGND VGND VPWR VPWR _0159_ sky130_fd_sc_hd__clkbuf_1
X_5288_ _2183_ _2182_ _2190_ VGND VGND VPWR VPWR _2191_ sky130_fd_sc_hd__a21oi_1
XFILLER_0_10_283 VGND VGND VPWR VPWR sky130_fd_sc_hd__fill_1
X_4239_ _1380_ _1394_ _1395_ VGND VGND VPWR VPWR _1396_ sky130_fd_sc_hd__a21o_1
X_7027_ net618 _3354_ _3506_ VGND VGND VPWR VPWR _3508_ sky130_fd_sc_hd__mux2_1
X_7929_ clknet_leaf_78_clk _0834_ VGND VGND VPWR VPWR u_pe_array.u_fifo1.buffer\[5\]\[1\]
+ sky130_fd_sc_hd__dfxtp_1
XFILLER_0_38_615 VGND VGND VPWR VPWR sky130_fd_sc_hd__decap_8
XFILLER_0_108_525 VGND VGND VPWR VPWR sky130_fd_sc_hd__decap_6
XFILLER_0_108_503 VGND VGND VPWR VPWR sky130_fd_sc_hd__decap_3
XFILLER_0_65_445 VGND VGND VPWR VPWR sky130_fd_sc_hd__decap_3
XFILLER_0_37_125 VGND VGND VPWR VPWR sky130_fd_sc_hd__fill_2
XFILLER_0_37_147 VPWR VGND VPWR VGND sky130_ef_sc_hd__decap_12
XFILLER_0_53_629 VGND VGND VPWR VPWR sky130_fd_sc_hd__decap_3
XFILLER_0_37_169 VGND VGND VPWR VPWR sky130_fd_sc_hd__decap_6
XFILLER_0_80_448 VGND VGND VPWR VPWR sky130_fd_sc_hd__decap_6
XFILLER_0_33_331 VGND VGND VPWR VPWR sky130_fd_sc_hd__decap_4
XFILLER_0_46_681 VGND VGND VPWR VPWR sky130_fd_sc_hd__fill_1
XFILLER_0_46_692 VGND VGND VPWR VPWR sky130_fd_sc_hd__fill_1
XFILLER_0_52_128 VGND VGND VPWR VPWR sky130_fd_sc_hd__decap_4
XFILLER_0_61_15 VGND VGND VPWR VPWR sky130_fd_sc_hd__fill_1
XFILLER_0_0_29 VGND VGND VPWR VPWR sky130_fd_sc_hd__fill_2
XTAP_1460 VGND VPWR sky130_fd_sc_hd__tapvpwrvgnd_1
XFILLER_0_29_615 VGND VGND VPWR VPWR sky130_fd_sc_hd__fill_1
XTAP_1493 VGND VPWR sky130_fd_sc_hd__tapvpwrvgnd_1
XTAP_1482 VGND VPWR sky130_fd_sc_hd__tapvpwrvgnd_1
XTAP_1471 VGND VPWR sky130_fd_sc_hd__tapvpwrvgnd_1
XFILLER_0_56_467 VGND VGND VPWR VPWR sky130_fd_sc_hd__decap_8
XFILLER_0_16_309 VGND VGND VPWR VPWR sky130_fd_sc_hd__decap_4
XFILLER_0_9_27 VPWR VGND VPWR VGND sky130_ef_sc_hd__decap_12
X_3610_ net572 _0904_ _0906_ VGND VGND VPWR VPWR _0006_ sky130_fd_sc_hd__o21a_1
X_4590_ _1654_ _1655_ VGND VGND VPWR VPWR _1656_ sky130_fd_sc_hd__or2_1
XFILLER_0_3_225 VPWR VGND VPWR VGND sky130_ef_sc_hd__decap_12
XFILLER_0_10_41 VPWR VGND VPWR VGND sky130_ef_sc_hd__decap_12
XFILLER_0_110_701 VGND VGND VPWR VPWR sky130_fd_sc_hd__decap_4
X_6260_ u_pe_array.g_pe_row\[0\].g_pe_col\[3\].u_pe.psum_out\[11\] _2964_ _2955_ VGND
+ VGND VPWR VPWR _2965_ sky130_fd_sc_hd__mux2_1
XFILLER_0_10_85 VPWR VGND VPWR VGND sky130_ef_sc_hd__decap_12
X_5211_ net474 _1882_ _2132_ _2138_ VGND VGND VPWR VPWR _0375_ sky130_fd_sc_hd__a22o_1
X_6191_ _2901_ _2902_ net373 _1007_ VGND VGND VPWR VPWR _0591_ sky130_fd_sc_hd__a2bb2o_1
X_5142_ net689 _1904_ _2082_ _1726_ VGND VGND VPWR VPWR _0362_ sky130_fd_sc_hd__a22o_1
X_5073_ u_pe_array.g_pe_row\[2\].g_pe_col\[0\].u_pe.act_val\[0\] _1286_ u_pe_array.g_pe_row\[2\].g_pe_col\[0\].u_pe.psum_out\[1\]
+ VGND VGND VPWR VPWR _2019_ sky130_fd_sc_hd__a21oi_1
X_4024_ _1223_ _1224_ VGND VGND VPWR VPWR _1225_ sky130_fd_sc_hd__nor2_1
X_5975_ u_pe_array.g_pe_row\[1\].g_pe_col\[0\].u_pe.psum_out\[0\] u_pe_array.g_pe_row\[1\].g_pe_col\[0\].u_pe.act_val\[0\]
+ u_pe_array.g_pe_row\[1\].g_pe_col\[0\].u_pe.w_out\[0\] VGND VGND VPWR VPWR _2732_
+ sky130_fd_sc_hd__and3_1
X_4926_ u_pe_array.g_pe_row\[2\].g_pe_col\[1\].u_pe.psum_out\[3\] _1910_ VGND VGND
+ VPWR VPWR _1911_ sky130_fd_sc_hd__xor2_1
X_7714_ clknet_leaf_60_clk net239 net72 VGND VGND VPWR VPWR u_pe_array.g_pe_row\[0\].g_pe_col\[2\].u_pe.act_val\[5\]
+ sky130_fd_sc_hd__dfrtp_2
X_4857_ net79 _1749_ _1611_ _1869_ VGND VGND VPWR VPWR _0290_ sky130_fd_sc_hd__a22o_1
XFILLER_0_62_404 VPWR VGND VPWR VGND sky130_ef_sc_hd__decap_12
XFILLER_0_34_106 VGND VGND VPWR VPWR sky130_fd_sc_hd__decap_8
XFILLER_0_35_629 VGND VGND VPWR VPWR sky130_fd_sc_hd__fill_1
X_7645_ clknet_leaf_71_clk _0551_ net949 VGND VGND VPWR VPWR u_pe_array.g_pe_row\[1\].g_pe_col\[0\].u_pe.psum_out\[5\]
+ sky130_fd_sc_hd__dfrtp_2
X_7576_ clknet_leaf_45_clk _0482_ net947 VGND VGND VPWR VPWR u_pe_array.g_pe_row\[1\].g_pe_col\[1\].u_pe.act_val\[3\]
+ sky130_fd_sc_hd__dfrtp_2
X_3808_ _1059_ _1060_ VGND VGND VPWR VPWR _1061_ sky130_fd_sc_hd__and2_1
XFILLER_0_28_692 VGND VGND VPWR VPWR sky130_fd_sc_hd__decap_8
XFILLER_0_34_139 VGND VGND VPWR VPWR sky130_fd_sc_hd__fill_1
X_6527_ _3148_ _3156_ VGND VGND VPWR VPWR _3157_ sky130_fd_sc_hd__nor2_1
XFILLER_0_105_528 VGND VGND VPWR VPWR sky130_fd_sc_hd__decap_4
XFILLER_0_15_353 VGND VGND VPWR VPWR sky130_fd_sc_hd__decap_3
X_4788_ _1771_ _1780_ _1779_ VGND VGND VPWR VPWR _1811_ sky130_fd_sc_hd__a21o_1
X_3739_ u_pe_array.g_pe_row\[3\].g_pe_col\[3\].u_pe.act_val\[1\] _0988_ VGND VGND
+ VPWR VPWR _0997_ sky130_fd_sc_hd__and2b_1
XFILLER_0_43_684 VGND VGND VPWR VPWR sky130_fd_sc_hd__decap_4
X_6458_ net380 _3101_ _2987_ _3110_ VGND VGND VPWR VPWR _0650_ sky130_fd_sc_hd__a22o_1
X_6389_ u_pe_array.g_pe_row\[0\].g_pe_col\[2\].u_pe.psum_out\[7\] _2130_ VGND VGND
+ VPWR VPWR _3057_ sky130_fd_sc_hd__or2_1
X_5409_ u_pe_array.g_pe_row\[1\].g_pe_col\[2\].u_pe.psum_out\[6\] _1108_ _1110_ _2293_
+ VGND VGND VPWR VPWR _2294_ sky130_fd_sc_hd__o211a_1
XFILLER_0_97_301 VGND VGND VPWR VPWR sky130_fd_sc_hd__fill_2
XFILLER_0_57_209 VGND VGND VPWR VPWR sky130_fd_sc_hd__fill_1
XFILLER_0_65_220 VGND VGND VPWR VPWR sky130_fd_sc_hd__decap_4
XFILLER_0_108_333 VGND VGND VPWR VPWR sky130_fd_sc_hd__decap_8
XFILLER_0_108_377 VGND VGND VPWR VPWR sky130_fd_sc_hd__decap_8
XFILLER_0_19_681 VPWR VGND VPWR VGND sky130_ef_sc_hd__decap_12
XFILLER_0_53_426 VGND VGND VPWR VPWR sky130_fd_sc_hd__fill_1
XFILLER_0_34_640 VGND VGND VPWR VPWR sky130_fd_sc_hd__decap_4
XFILLER_0_0_217 VGND VGND VPWR VPWR sky130_fd_sc_hd__decap_3
XTAP_507 VGND VPWR sky130_fd_sc_hd__tapvpwrvgnd_1
XTAP_518 VGND VPWR sky130_fd_sc_hd__tapvpwrvgnd_1
XTAP_529 VGND VPWR sky130_fd_sc_hd__tapvpwrvgnd_1
XFILLER_0_88_378 VGND VGND VPWR VPWR sky130_fd_sc_hd__decap_3
XFILLER_0_69_581 VPWR VGND VPWR VGND sky130_ef_sc_hd__decap_12
X_5760_ _2564_ u_pe_array.g_pe_row\[1\].g_pe_col\[1\].u_pe.psum_out\[6\] _1728_ VGND
+ VGND VPWR VPWR _2565_ sky130_fd_sc_hd__and3_1
XTAP_1290 VGND VPWR sky130_fd_sc_hd__tapvpwrvgnd_1
XFILLER_0_8_339 VGND VGND VPWR VPWR sky130_fd_sc_hd__fill_1
X_4711_ _0938_ VGND VGND VPWR VPWR _1749_ sky130_fd_sc_hd__buf_6
X_5691_ u_pe_array.act_from_right\[5\]\[5\] u_pe_array.act_from_left\[5\]\[5\] _0963_
+ VGND VGND VPWR VPWR _2510_ sky130_fd_sc_hd__mux2_1
XFILLER_0_112_53 VPWR VGND VPWR VGND sky130_ef_sc_hd__decap_12
X_7430_ clknet_leaf_13_clk _0336_ net951 VGND VGND VPWR VPWR u_pe_array.act_from_up\[12\]\[6\]
+ sky130_fd_sc_hd__dfrtp_1
XFILLER_0_16_128 VGND VGND VPWR VPWR sky130_fd_sc_hd__fill_1
X_4642_ u_pe_array.g_pe_row\[2\].g_pe_col\[3\].u_pe.psum_out\[9\] _1427_ VGND VGND
+ VPWR VPWR _1703_ sky130_fd_sc_hd__or2_1
XFILLER_0_4_512 VPWR VGND VPWR VGND sky130_ef_sc_hd__decap_12
XFILLER_0_25_662 VGND VGND VPWR VPWR sky130_fd_sc_hd__decap_8
XFILLER_0_112_97 VPWR VGND VPWR VGND sky130_ef_sc_hd__decap_12
XFILLER_0_97_11 VGND VGND VPWR VPWR sky130_fd_sc_hd__decap_3
Xhold703 u_pe_array.g_pe_row\[0\].g_pe_col\[3\].u_pe.psum_out\[7\] VGND VGND VPWR
+ VPWR net777 sky130_fd_sc_hd__dlygate4sd3_1
XFILLER_0_4_545 VPWR VGND VPWR VGND sky130_ef_sc_hd__decap_12
X_4573_ _1632_ _1633_ _1639_ VGND VGND VPWR VPWR _1640_ sky130_fd_sc_hd__nor3_1
X_7361_ clknet_leaf_5_clk _0267_ net945 VGND VGND VPWR VPWR u_pe_array.g_pe_row\[2\].g_pe_col\[2\].u_pe.move_reg\[6\]
+ sky130_fd_sc_hd__dfrtp_1
Xhold725 u_pe_array.g_pe_row\[2\].g_pe_col\[0\].u_pe.psum_out\[2\] VGND VGND VPWR
+ VPWR net799 sky130_fd_sc_hd__dlygate4sd3_1
X_6312_ net335 _0866_ _0940_ u_pe_array.g_pe_row\[0\].g_pe_col\[2\].u_pe.move_reg\[12\]
+ VGND VGND VPWR VPWR _0627_ sky130_fd_sc_hd__a22o_1
Xhold736 u_pe_array.g_pe_row\[3\].g_pe_col\[3\].u_pe.act_val\[4\] VGND VGND VPWR VPWR
+ net810 sky130_fd_sc_hd__dlygate4sd3_1
X_7292_ clknet_leaf_12_clk _0198_ net951 VGND VGND VPWR VPWR u_pe_array.g_pe_row\[3\].g_pe_col\[0\].u_pe.psum_out\[6\]
+ sky130_fd_sc_hd__dfrtp_1
XFILLER_0_4_589 VPWR VGND VPWR VGND sky130_ef_sc_hd__decap_12
Xhold714 u_pe_array.u_fifo1.buffer\[8\]\[4\] VGND VGND VPWR VPWR net788 sky130_fd_sc_hd__dlygate4sd3_1
XFILLER_0_40_654 VGND VGND VPWR VPWR sky130_fd_sc_hd__fill_1
XFILLER_0_110_531 VGND VGND VPWR VPWR sky130_fd_sc_hd__fill_1
Xhold769 u_pe_array.g_pe_row\[0\].g_pe_col\[1\].u_pe.psum_out\[8\] VGND VGND VPWR
+ VPWR net843 sky130_fd_sc_hd__dlygate4sd3_1
XFILLER_0_97_77 VGND VGND VPWR VPWR sky130_fd_sc_hd__decap_3
X_6243_ _2939_ _2947_ _2948_ _2949_ VGND VGND VPWR VPWR _2950_ sky130_fd_sc_hd__a31o_1
Xhold747 u_pe_array.act_from_left\[7\]\[2\] VGND VGND VPWR VPWR net821 sky130_fd_sc_hd__dlygate4sd3_1
Xhold758 u_pe_array.act_from_left\[7\]\[0\] VGND VGND VPWR VPWR net832 sky130_fd_sc_hd__dlygate4sd3_1
XFILLER_0_12_378 VGND VGND VPWR VPWR sky130_fd_sc_hd__fill_2
XFILLER_0_40_698 VGND VGND VPWR VPWR sky130_fd_sc_hd__fill_2
X_6174_ u_pe_array.g_pe_row\[0\].g_pe_col\[3\].u_pe.psum_out\[2\] _2874_ _2886_ VGND
+ VGND VPWR VPWR _2887_ sky130_fd_sc_hd__a21oi_1
X_5125_ _2052_ _2062_ _2066_ VGND VGND VPWR VPWR _2067_ sky130_fd_sc_hd__o21a_1
XFILLER_0_34_3 VPWR VGND VPWR VGND sky130_ef_sc_hd__decap_12
XFILLER_0_98_109 VGND VGND VPWR VPWR sky130_fd_sc_hd__fill_2
X_5056_ u_pe_array.g_pe_row\[2\].g_pe_col\[0\].u_pe.act_val\[0\] _1882_ _1873_ net97
+ VGND VGND VPWR VPWR _0343_ sky130_fd_sc_hd__a22o_1
X_4007_ _1207_ _1208_ VGND VGND VPWR VPWR _1209_ sky130_fd_sc_hd__nor2_1
XFILLER_0_46_81 VGND VGND VPWR VPWR sky130_fd_sc_hd__decap_3
XFILLER_0_79_367 VGND VGND VPWR VPWR sky130_fd_sc_hd__fill_2
X_5958_ u_pe_array.u_fifo1.buffer\[0\]\[5\] _2678_ VGND VGND VPWR VPWR _2723_ sky130_fd_sc_hd__or2_1
X_4909_ u_pe_array.g_pe_row\[2\].g_pe_col\[1\].u_pe.psum_out\[1\] _1891_ _1894_ VGND
+ VGND VPWR VPWR _1895_ sky130_fd_sc_hd__a21bo_1
X_5889_ _2670_ VGND VGND VPWR VPWR _0521_ sky130_fd_sc_hd__clkbuf_1
XFILLER_0_105_314 VGND VGND VPWR VPWR sky130_fd_sc_hd__decap_6
XFILLER_0_7_361 VGND VGND VPWR VPWR sky130_fd_sc_hd__fill_1
XFILLER_0_16_640 VGND VGND VPWR VPWR sky130_fd_sc_hd__decap_4
X_7628_ clknet_leaf_76_clk _0534_ net949 VGND VGND VPWR VPWR u_pe_array.g_pe_row\[1\].g_pe_col\[0\].u_pe.act_val\[1\]
+ sky130_fd_sc_hd__dfrtp_1
XFILLER_0_105_369 VPWR VGND VPWR VGND sky130_ef_sc_hd__decap_12
X_7559_ clknet_leaf_64_clk _0465_ net946 VGND VGND VPWR VPWR u_pe_array.g_pe_row\[1\].g_pe_col\[0\].u_pe.w_out\[1\]
+ sky130_fd_sc_hd__dfrtp_1
XFILLER_0_15_150 VGND VGND VPWR VPWR sky130_fd_sc_hd__decap_8
XFILLER_0_16_673 VPWR VGND VPWR VGND sky130_ef_sc_hd__decap_12
XFILLER_0_31_654 VPWR VGND VPWR VGND sky130_ef_sc_hd__decap_12
XFILLER_0_30_197 VGND VGND VPWR VPWR sky130_fd_sc_hd__fill_2
Xhold41 _0446_ VGND VGND VPWR VPWR net115 sky130_fd_sc_hd__dlygate4sd3_1
Xhold30 u_pe_array.act_from_up\[6\]\[10\] VGND VGND VPWR VPWR net104 sky130_fd_sc_hd__dlygate4sd3_1
Xhold63 u_pe_array.act_from_right\[0\]\[9\] VGND VGND VPWR VPWR net137 sky130_fd_sc_hd__dlygate4sd3_1
Xhold74 _0586_ VGND VGND VPWR VPWR net148 sky130_fd_sc_hd__dlygate4sd3_1
Xhold52 _0221_ VGND VGND VPWR VPWR net126 sky130_fd_sc_hd__dlygate4sd3_1
XFILLER_0_98_621 VPWR VGND VPWR VGND sky130_ef_sc_hd__decap_12
Xhold85 u_pe_array.act_from_left\[13\]\[6\] VGND VGND VPWR VPWR net159 sky130_fd_sc_hd__dlygate4sd3_1
Xhold96 u_pe_array.act_from_left\[13\]\[8\] VGND VGND VPWR VPWR net170 sky130_fd_sc_hd__dlygate4sd3_1
XFILLER_0_98_676 VPWR VGND VPWR VGND sky130_ef_sc_hd__decap_12
XFILLER_0_58_507 VGND VGND VPWR VPWR sky130_fd_sc_hd__decap_4
XFILLER_0_85_337 VPWR VGND VPWR VGND sky130_ef_sc_hd__decap_12
XFILLER_0_38_231 VGND VGND VPWR VPWR sky130_fd_sc_hd__fill_1
XFILLER_0_108_141 VPWR VGND VPWR VGND sky130_ef_sc_hd__decap_12
XFILLER_0_26_437 VGND VGND VPWR VPWR sky130_fd_sc_hd__decap_8
XFILLER_0_109_697 VGND VGND VPWR VPWR sky130_fd_sc_hd__decap_8
XFILLER_0_81_554 VGND VGND VPWR VPWR sky130_fd_sc_hd__decap_6
XFILLER_0_53_245 VGND VGND VPWR VPWR sky130_fd_sc_hd__decap_6
XANTENNA_5 net9 VGND VGND VPWR VPWR sky130_fd_sc_hd__diode_2
XFILLER_0_1_559 VGND VGND VPWR VPWR sky130_fd_sc_hd__fill_1
XFILLER_0_67_47 VGND VGND VPWR VPWR sky130_fd_sc_hd__decap_6
XTAP_315 VGND VPWR sky130_fd_sc_hd__tapvpwrvgnd_1
XTAP_304 VGND VPWR sky130_fd_sc_hd__tapvpwrvgnd_1
XTAP_337 VGND VPWR sky130_fd_sc_hd__tapvpwrvgnd_1
XTAP_348 VGND VPWR sky130_fd_sc_hd__tapvpwrvgnd_1
XTAP_326 VGND VPWR sky130_fd_sc_hd__tapvpwrvgnd_1
XTAP_359 VGND VPWR sky130_fd_sc_hd__tapvpwrvgnd_1
X_6930_ _3448_ VGND VGND VPWR VPWR _0784_ sky130_fd_sc_hd__clkbuf_1
XFILLER_0_88_186 VGND VGND VPWR VPWR sky130_fd_sc_hd__fill_2
X_6861_ net575 _0920_ _3408_ VGND VGND VPWR VPWR _3410_ sky130_fd_sc_hd__mux2_1
XFILLER_0_49_518 VPWR VGND VPWR VGND sky130_ef_sc_hd__decap_12
X_5812_ _2607_ _2612_ VGND VGND VPWR VPWR _2613_ sky130_fd_sc_hd__and2_1
XFILLER_0_88_197 VGND VGND VPWR VPWR sky130_fd_sc_hd__decap_6
XFILLER_0_57_540 VGND VGND VPWR VPWR sky130_fd_sc_hd__decap_4
X_6792_ u_pe_array.u_fifo2.wr_ptr\[0\] u_pe_array.u_fifo2.wr_ptr\[1\] VGND VGND VPWR
+ VPWR _3365_ sky130_fd_sc_hd__nand2_1
X_5743_ _2548_ _2549_ VGND VGND VPWR VPWR _2550_ sky130_fd_sc_hd__nor2_1
XFILLER_0_29_297 VPWR VGND VPWR VGND sky130_ef_sc_hd__decap_12
X_5674_ net421 _2499_ _2491_ _2501_ VGND VGND VPWR VPWR _0475_ sky130_fd_sc_hd__a22o_1
XFILLER_0_115_667 VGND VGND VPWR VPWR sky130_fd_sc_hd__decap_4
XFILLER_0_114_133 VGND VGND VPWR VPWR sky130_fd_sc_hd__decap_6
X_7413_ clknet_leaf_26_clk _0319_ net943 VGND VGND VPWR VPWR u_pe_array.g_pe_row\[2\].g_pe_col\[1\].u_pe.psum_out\[4\]
+ sky130_fd_sc_hd__dfrtp_1
X_4625_ _1681_ _1687_ VGND VGND VPWR VPWR _1688_ sky130_fd_sc_hd__nand2_1
XFILLER_0_114_177 VPWR VGND VPWR VGND sky130_ef_sc_hd__decap_12
XFILLER_0_102_317 VGND VGND VPWR VPWR sky130_fd_sc_hd__fill_1
XFILLER_0_102_306 VGND VGND VPWR VPWR sky130_fd_sc_hd__fill_2
X_7344_ clknet_leaf_105_clk _0250_ net944 VGND VGND VPWR VPWR u_pe_array.act_from_up\[14\]\[2\]
+ sky130_fd_sc_hd__dfrtp_1
XFILLER_0_13_654 VPWR VGND VPWR VGND sky130_ef_sc_hd__decap_12
Xhold500 u_pe_array.u_fifo1.buffer\[5\]\[2\] VGND VGND VPWR VPWR net574 sky130_fd_sc_hd__dlygate4sd3_1
Xhold511 u_pe_array.g_pe_row\[3\].g_pe_col\[2\].u_pe.psum_out\[3\] VGND VGND VPWR
+ VPWR net585 sky130_fd_sc_hd__dlygate4sd3_1
X_4556_ u_pe_array.g_pe_row\[2\].g_pe_col\[3\].u_pe.act_val\[1\] _1427_ VGND VGND
+ VPWR VPWR _1624_ sky130_fd_sc_hd__or2b_1
Xhold533 u_pe_array.g_pe_row\[0\].g_pe_col\[1\].u_pe.psum_out\[12\] VGND VGND VPWR
+ VPWR net607 sky130_fd_sc_hd__dlygate4sd3_1
Xhold522 u_pe_array.g_pe_row\[0\].g_pe_col\[3\].u_pe.psum_out\[12\] VGND VGND VPWR
+ VPWR net596 sky130_fd_sc_hd__dlygate4sd3_1
Xhold544 u_pe_array.u_fifo1.buffer\[3\]\[1\] VGND VGND VPWR VPWR net618 sky130_fd_sc_hd__dlygate4sd3_1
Xhold555 _0127_ VGND VGND VPWR VPWR net629 sky130_fd_sc_hd__dlygate4sd3_1
Xhold577 u_pe_array.u_fifo2.buffer\[7\]\[1\] VGND VGND VPWR VPWR net651 sky130_fd_sc_hd__dlygate4sd3_1
Xhold588 u_pe_array.u_fifo2.buffer\[1\]\[4\] VGND VGND VPWR VPWR net662 sky130_fd_sc_hd__dlygate4sd3_1
Xhold566 u_pe_array.u_fifo1.buffer\[2\]\[0\] VGND VGND VPWR VPWR net640 sky130_fd_sc_hd__dlygate4sd3_1
X_7275_ clknet_leaf_95_clk _0181_ net950 VGND VGND VPWR VPWR u_pe_array.g_pe_row\[3\].g_pe_col\[0\].u_pe.act_val\[2\]
+ sky130_fd_sc_hd__dfrtp_2
X_4487_ _1585_ _1586_ VGND VGND VPWR VPWR _1587_ sky130_fd_sc_hd__or2_1
XFILLER_0_110_361 VGND VGND VPWR VPWR sky130_fd_sc_hd__decap_3
X_6226_ _2918_ _2931_ VGND VGND VPWR VPWR _2934_ sky130_fd_sc_hd__and2b_1
Xhold599 u_pe_array.g_pe_row\[3\].g_pe_col\[0\].u_pe.psum_out\[9\] VGND VGND VPWR
+ VPWR net673 sky130_fd_sc_hd__dlygate4sd3_1
X_6157_ u_pe_array.g_pe_row\[0\].g_pe_col\[3\].u_pe.act_val\[0\] _2863_ _1999_ VGND
+ VGND VPWR VPWR _2871_ sky130_fd_sc_hd__a21bo_1
XTAP_860 VGND VPWR sky130_fd_sc_hd__tapvpwrvgnd_1
XTAP_871 VGND VPWR sky130_fd_sc_hd__tapvpwrvgnd_1
X_5108_ _2050_ _1286_ u_pe_array.g_pe_row\[2\].g_pe_col\[0\].u_pe.psum_out\[4\] VGND
+ VGND VPWR VPWR _2051_ sky130_fd_sc_hd__a21oi_1
XTAP_882 VGND VPWR sky130_fd_sc_hd__tapvpwrvgnd_1
XTAP_893 VGND VPWR sky130_fd_sc_hd__tapvpwrvgnd_1
X_6088_ _2832_ _2833_ VGND VGND VPWR VPWR _2834_ sky130_fd_sc_hd__or2_1
X_5039_ u_pe_array.g_pe_row\[2\].g_pe_col\[0\].u_pe.psum_out\[5\] u_pe_array.g_pe_row\[2\].g_pe_col\[0\].u_pe.act_val\[5\]
+ _1867_ VGND VGND VPWR VPWR _2007_ sky130_fd_sc_hd__mux2_1
XFILLER_0_95_635 VPWR VGND VPWR VGND sky130_ef_sc_hd__decap_12
XFILLER_0_67_348 VGND VGND VPWR VPWR sky130_fd_sc_hd__fill_2
XFILLER_0_67_337 VGND VGND VPWR VPWR sky130_fd_sc_hd__fill_2
XFILLER_0_48_584 VGND VGND VPWR VPWR sky130_fd_sc_hd__decap_4
XFILLER_0_118_461 VPWR VGND VPWR VGND sky130_ef_sc_hd__decap_12
XFILLER_0_106_645 VPWR VGND VPWR VGND sky130_ef_sc_hd__decap_12
XFILLER_0_105_111 VGND VGND VPWR VPWR sky130_fd_sc_hd__fill_1
Xoutput42 net42 VGND VGND VPWR VPWR psum_out0[3] sky130_fd_sc_hd__clkbuf_4
Xoutput53 net53 VGND VGND VPWR VPWR psum_out1[1] sky130_fd_sc_hd__clkbuf_4
XFILLER_0_85_167 VGND VGND VPWR VPWR sky130_fd_sc_hd__fill_1
XFILLER_0_85_189 VGND VGND VPWR VPWR sky130_fd_sc_hd__fill_1
XPHY_170 VGND VGND VPWR VPWR sky130_fd_sc_hd__decap_3
XFILLER_0_39_573 VGND VGND VPWR VPWR sky130_fd_sc_hd__fill_1
XPHY_192 VGND VGND VPWR VPWR sky130_fd_sc_hd__decap_3
XPHY_181 VGND VGND VPWR VPWR sky130_fd_sc_hd__decap_3
Xclkbuf_leaf_105_clk clknet_3_0__leaf_clk VGND VGND VPWR VPWR clknet_leaf_105_clk
+ sky130_fd_sc_hd__clkbuf_16
XFILLER_0_14_429 VPWR VGND VPWR VGND sky130_ef_sc_hd__decap_12
XFILLER_0_26_289 VPWR VGND VPWR VGND sky130_ef_sc_hd__decap_12
XFILLER_0_112_626 VPWR VGND VPWR VGND sky130_ef_sc_hd__decap_12
X_4410_ u_pe_array.g_pe_row\[3\].g_pe_col\[0\].u_pe.act_val\[3\] _1287_ VGND VGND
+ VPWR VPWR _1517_ sky130_fd_sc_hd__and2b_1
XFILLER_0_111_125 VGND VGND VPWR VPWR sky130_fd_sc_hd__fill_2
X_5390_ _2278_ _1112_ VGND VGND VPWR VPWR _2279_ sky130_fd_sc_hd__nand2_1
XFILLER_0_111_169 VGND VGND VPWR VPWR sky130_fd_sc_hd__decap_3
X_4341_ _1443_ net890 _1158_ VGND VGND VPWR VPWR _1474_ sky130_fd_sc_hd__mux2_1
X_4272_ u_pe_array.g_pe_row\[2\].g_pe_col\[3\].u_pe.w_out\[0\] VGND VGND VPWR VPWR
+ _1424_ sky130_fd_sc_hd__buf_4
XFILLER_0_10_657 VPWR VGND VPWR VGND sky130_ef_sc_hd__decap_12
X_7060_ net695 _3360_ _3521_ VGND VGND VPWR VPWR _3526_ sky130_fd_sc_hd__mux2_1
XFILLER_0_94_23 VGND VGND VPWR VPWR sky130_fd_sc_hd__decap_4
X_6011_ u_pe_array.g_pe_row\[1\].g_pe_col\[0\].u_pe.act_val\[4\] u_pe_array.g_pe_row\[1\].g_pe_col\[0\].u_pe.w_out\[0\]
+ VGND VGND VPWR VPWR _2764_ sky130_fd_sc_hd__nand2_1
XFILLER_0_118_41 VPWR VGND VPWR VGND sky130_ef_sc_hd__decap_12
XFILLER_0_118_85 VPWR VGND VPWR VGND sky130_ef_sc_hd__decap_12
X_6913_ _3438_ VGND VGND VPWR VPWR _3439_ sky130_fd_sc_hd__buf_2
X_7893_ clknet_leaf_79_clk _0798_ net13 VGND VGND VPWR VPWR u_pe_array.u_fifo1.rd_ptr\[3\]
+ sky130_fd_sc_hd__dfrtp_4
XFILLER_0_49_326 VGND VGND VPWR VPWR sky130_fd_sc_hd__fill_1
X_6844_ _3399_ VGND VGND VPWR VPWR _3400_ sky130_fd_sc_hd__buf_2
X_3987_ _1189_ _1190_ VGND VGND VPWR VPWR _1191_ sky130_fd_sc_hd__xor2_1
X_6775_ u_pe_array.act_from_up\[12\]\[1\] _0869_ _0854_ VGND VGND VPWR VPWR _3354_
+ sky130_fd_sc_hd__and3_4
X_5726_ u_pe_array.g_pe_row\[1\].g_pe_col\[1\].u_pe.act_val\[3\] u_pe_array.g_pe_row\[1\].g_pe_col\[1\].u_pe.w_out\[0\]
+ _1728_ _2533_ VGND VGND VPWR VPWR _2534_ sky130_fd_sc_hd__a22o_1
XFILLER_0_45_554 VGND VGND VPWR VPWR sky130_fd_sc_hd__decap_6
XFILLER_0_115_442 VGND VGND VPWR VPWR sky130_fd_sc_hd__decap_3
XFILLER_0_72_362 VGND VGND VPWR VPWR sky130_fd_sc_hd__fill_2
XFILLER_0_115_475 VGND VGND VPWR VPWR sky130_fd_sc_hd__decap_8
X_5657_ net175 _2143_ _2491_ _2492_ VGND VGND VPWR VPWR _0467_ sky130_fd_sc_hd__a22o_1
XFILLER_0_5_673 VGND VGND VPWR VPWR sky130_fd_sc_hd__decap_4
XFILLER_0_5_651 VPWR VGND VPWR VGND sky130_ef_sc_hd__decap_12
XFILLER_0_32_259 VPWR VGND VPWR VGND sky130_ef_sc_hd__decap_12
X_5588_ u_pe_array.g_pe_row\[1\].g_pe_col\[2\].u_pe.act_val\[4\] _2433_ _2424_ _2422_
+ VGND VGND VPWR VPWR _2434_ sky130_fd_sc_hd__o22ai_1
X_4608_ _1670_ _1427_ u_pe_array.g_pe_row\[2\].g_pe_col\[3\].u_pe.psum_out\[6\] VGND
+ VGND VPWR VPWR _1672_ sky130_fd_sc_hd__a21o_1
Xhold352 _0577_ VGND VGND VPWR VPWR net426 sky130_fd_sc_hd__dlygate4sd3_1
X_4539_ net441 _1310_ _1483_ u_pe_array.g_pe_row\[2\].g_pe_col\[3\].u_pe.move_reg\[7\]
+ VGND VGND VPWR VPWR _0227_ sky130_fd_sc_hd__a22o_1
X_7327_ clknet_leaf_108_clk _0233_ net944 VGND VGND VPWR VPWR u_pe_array.g_pe_row\[2\].g_pe_col\[3\].u_pe.psum_out\[0\]
+ sky130_fd_sc_hd__dfrtp_1
Xhold341 u_pe_array.act_from_up\[6\]\[1\] VGND VGND VPWR VPWR net415 sky130_fd_sc_hd__dlygate4sd3_1
Xhold330 u_pe_array.g_pe_row\[2\].g_pe_col\[2\].u_pe.psum_out\[11\] VGND VGND VPWR
+ VPWR net404 sky130_fd_sc_hd__dlygate4sd3_1
Xhold396 _0656_ VGND VGND VPWR VPWR net470 sky130_fd_sc_hd__dlygate4sd3_1
Xhold363 u_pe_array.act_from_down\[9\]\[9\] VGND VGND VPWR VPWR net437 sky130_fd_sc_hd__dlygate4sd3_1
Xhold385 u_pe_array.act_from_right\[2\]\[11\] VGND VGND VPWR VPWR net459 sky130_fd_sc_hd__dlygate4sd3_1
Xhold374 _0341_ VGND VGND VPWR VPWR net448 sky130_fd_sc_hd__dlygate4sd3_1
XFILLER_0_7_93 VPWR VGND VPWR VGND sky130_ef_sc_hd__decap_12
X_7258_ clknet_leaf_88_clk _0164_ net948 VGND VGND VPWR VPWR net51 sky130_fd_sc_hd__dfrtp_1
XFILLER_0_110_180 VGND VGND VPWR VPWR sky130_fd_sc_hd__decap_4
X_6209_ _2880_ _2889_ _2888_ VGND VGND VPWR VPWR _2919_ sky130_fd_sc_hd__a21o_1
X_7189_ clknet_leaf_8_clk net90 net950 VGND VGND VPWR VPWR u_pe_array.g_pe_row\[3\].g_pe_col\[2\].u_pe.move_reg\[11\]
+ sky130_fd_sc_hd__dfrtp_1
XFILLER_0_99_215 VGND VGND VPWR VPWR sky130_fd_sc_hd__fill_1
XTAP_690 VGND VPWR sky130_fd_sc_hd__tapvpwrvgnd_1
Xclkbuf_3_6__f_clk clknet_0_clk VGND VGND VPWR VPWR clknet_3_6__leaf_clk sky130_fd_sc_hd__clkbuf_16
XFILLER_0_68_668 VGND VGND VPWR VPWR sky130_fd_sc_hd__decap_6
XFILLER_0_36_554 VGND VGND VPWR VPWR sky130_fd_sc_hd__fill_2
XFILLER_0_63_373 VPWR VGND VPWR VGND sky130_ef_sc_hd__decap_12
XFILLER_0_63_362 VGND VGND VPWR VPWR sky130_fd_sc_hd__decap_8
XFILLER_0_2_109 VPWR VGND VPWR VGND sky130_ef_sc_hd__decap_12
XFILLER_0_23_237 VPWR VGND VPWR VGND sky130_ef_sc_hd__decap_12
XFILLER_0_102_681 VPWR VGND VPWR VGND sky130_ef_sc_hd__decap_12
XFILLER_0_31_281 VGND VGND VPWR VPWR sky130_fd_sc_hd__decap_3
XFILLER_0_98_281 VGND VGND VPWR VPWR sky130_fd_sc_hd__decap_4
X_4890_ u_pe_array.act_from_down\[9\]\[8\] _1750_ _1483_ net306 VGND VGND VPWR VPWR
+ _0310_ sky130_fd_sc_hd__a22o_1
XFILLER_0_58_156 VGND VGND VPWR VPWR sky130_fd_sc_hd__decap_4
XFILLER_0_58_145 VGND VGND VPWR VPWR sky130_fd_sc_hd__fill_2
XFILLER_0_58_134 VGND VGND VPWR VPWR sky130_fd_sc_hd__decap_6
X_3910_ u_pe_array.g_pe_row\[3\].g_pe_col\[2\].u_pe.move_reg\[9\] _1118_ VGND VGND
+ VPWR VPWR _1146_ sky130_fd_sc_hd__or2_1
X_3841_ _1085_ _1090_ VGND VGND VPWR VPWR _1091_ sky130_fd_sc_hd__and2_1
X_6560_ _3186_ u_pe_array.g_pe_row\[0\].g_pe_col\[1\].u_pe.psum_out\[7\] _3169_ VGND
+ VGND VPWR VPWR _3187_ sky130_fd_sc_hd__mux2_1
XFILLER_0_104_65 VPWR VGND VPWR VGND sky130_ef_sc_hd__decap_12
X_3772_ _1026_ _1027_ VGND VGND VPWR VPWR _1028_ sky130_fd_sc_hd__nor2_1
XFILLER_0_54_340 VGND VGND VPWR VPWR sky130_fd_sc_hd__fill_1
X_5511_ _2320_ _2370_ _2371_ _2343_ net686 VGND VGND VPWR VPWR _0442_ sky130_fd_sc_hd__a32o_1
X_6491_ u_pe_array.g_pe_row\[0\].g_pe_col\[1\].u_pe.psum_out\[1\] _3122_ VGND VGND
+ VPWR VPWR _3124_ sky130_fd_sc_hd__nand2_1
XFILLER_0_14_248 VGND VGND VPWR VPWR sky130_fd_sc_hd__decap_4
X_5442_ _2284_ net827 _1158_ VGND VGND VPWR VPWR _2317_ sky130_fd_sc_hd__mux2_1
XFILLER_0_112_467 VGND VGND VPWR VPWR sky130_fd_sc_hd__decap_8
XFILLER_0_112_445 VGND VGND VPWR VPWR sky130_fd_sc_hd__decap_6
X_5373_ net584 _1904_ _2266_ _1726_ VGND VGND VPWR VPWR _0409_ sky130_fd_sc_hd__a22o_1
XFILLER_0_2_643 VGND VGND VPWR VPWR sky130_fd_sc_hd__fill_1
X_7112_ clknet_leaf_4_clk _0018_ net945 VGND VGND VPWR VPWR u_pe_array.act_from_down\[11\]\[1\]
+ sky130_fd_sc_hd__dfrtp_1
X_4324_ _1463_ VGND VGND VPWR VPWR _0163_ sky130_fd_sc_hd__clkbuf_1
X_7043_ net592 _3356_ _3514_ VGND VGND VPWR VPWR _3517_ sky130_fd_sc_hd__mux2_1
X_4255_ u_pe_array.g_pe_row\[3\].g_pe_col\[1\].u_pe.psum_out\[10\] _1409_ _1399_ VGND
+ VGND VPWR VPWR _1410_ sky130_fd_sc_hd__mux2_1
X_4186_ _1345_ _1346_ VGND VGND VPWR VPWR _1347_ sky130_fd_sc_hd__nor2_1
XFILLER_0_38_93 VGND VGND VPWR VPWR sky130_fd_sc_hd__fill_1
XFILLER_0_96_218 VGND VGND VPWR VPWR sky130_fd_sc_hd__decap_3
XFILLER_0_89_281 VPWR VGND VPWR VGND sky130_ef_sc_hd__decap_12
XTAP_1119 VGND VPWR sky130_fd_sc_hd__tapvpwrvgnd_1
XTAP_1108 VGND VPWR sky130_fd_sc_hd__tapvpwrvgnd_1
X_7945_ clknet_leaf_82_clk _0850_ VGND VGND VPWR VPWR u_pe_array.u_fifo1.buffer\[7\]\[5\]
+ sky130_fd_sc_hd__dfxtp_1
XFILLER_0_77_465 VGND VGND VPWR VPWR sky130_fd_sc_hd__decap_3
X_7876_ clknet_leaf_102_clk _0781_ VGND VGND VPWR VPWR u_pe_array.u_fifo2.buffer\[6\]\[4\]
+ sky130_fd_sc_hd__dfxtp_1
XFILLER_0_92_413 VGND VGND VPWR VPWR sky130_fd_sc_hd__decap_6
X_6827_ _3388_ _3389_ _3379_ VGND VGND VPWR VPWR _3390_ sky130_fd_sc_hd__a21oi_1
XFILLER_0_49_167 VGND VGND VPWR VPWR sky130_fd_sc_hd__fill_1
XFILLER_0_49_189 VGND VGND VPWR VPWR sky130_fd_sc_hd__decap_6
XFILLER_0_80_608 VGND VGND VPWR VPWR sky130_fd_sc_hd__decap_6
X_6758_ _3338_ _3339_ VGND VGND VPWR VPWR _3340_ sky130_fd_sc_hd__or2_1
XFILLER_0_73_671 VGND VGND VPWR VPWR sky130_fd_sc_hd__fill_1
XFILLER_0_18_587 VGND VGND VPWR VPWR sky130_fd_sc_hd__fill_1
XFILLER_0_33_513 VGND VGND VPWR VPWR sky130_fd_sc_hd__fill_1
XFILLER_0_45_340 VPWR VGND VPWR VGND sky130_ef_sc_hd__decap_12
X_5709_ u_pe_array.g_pe_row\[1\].g_pe_col\[1\].u_pe.psum_out\[1\] _2518_ VGND VGND
+ VPWR VPWR _2519_ sky130_fd_sc_hd__or2_1
X_6689_ u_pe_array.g_pe_row\[0\].g_pe_col\[0\].u_pe.act_val\[3\] _3246_ _3276_ _3277_
+ VGND VGND VPWR VPWR _3278_ sky130_fd_sc_hd__nor4_1
XFILLER_0_18_598 VPWR VGND VPWR VGND sky130_ef_sc_hd__decap_12
XFILLER_0_115_261 VPWR VGND VPWR VGND sky130_ef_sc_hd__decap_12
XFILLER_0_103_401 VGND VGND VPWR VPWR sky130_fd_sc_hd__decap_4
Xhold160 u_pe_array.act_from_right\[0\]\[0\] VGND VGND VPWR VPWR net234 sky130_fd_sc_hd__dlygate4sd3_1
Xhold171 _0666_ VGND VGND VPWR VPWR net245 sky130_fd_sc_hd__dlygate4sd3_1
XFILLER_0_13_281 VGND VGND VPWR VPWR sky130_fd_sc_hd__decap_4
Xhold193 u_pe_array.g_pe_row\[0\].g_pe_col\[3\].u_pe.move_reg\[6\] VGND VGND VPWR
+ VPWR net267 sky130_fd_sc_hd__dlygate4sd3_1
Xhold182 _0134_ VGND VGND VPWR VPWR net256 sky130_fd_sc_hd__dlygate4sd3_1
XFILLER_0_68_421 VPWR VGND VPWR VGND sky130_ef_sc_hd__decap_12
XFILLER_0_34_29 VGND VGND VPWR VPWR sky130_fd_sc_hd__decap_8
XTAP_1642 VGND VPWR sky130_fd_sc_hd__tapvpwrvgnd_1
XTAP_1631 VGND VPWR sky130_fd_sc_hd__tapvpwrvgnd_1
XTAP_1620 VGND VPWR sky130_fd_sc_hd__tapvpwrvgnd_1
XTAP_1675 VGND VPWR sky130_fd_sc_hd__tapvpwrvgnd_1
XTAP_1653 VGND VPWR sky130_fd_sc_hd__tapvpwrvgnd_1
XTAP_1664 VGND VPWR sky130_fd_sc_hd__tapvpwrvgnd_1
XFILLER_0_28_307 VGND VGND VPWR VPWR sky130_fd_sc_hd__fill_1
XFILLER_0_28_318 VGND VGND VPWR VPWR sky130_fd_sc_hd__decap_3
XTAP_1697 VGND VPWR sky130_fd_sc_hd__tapvpwrvgnd_1
XTAP_1686 VGND VPWR sky130_fd_sc_hd__tapvpwrvgnd_1
XFILLER_0_83_457 VGND VGND VPWR VPWR sky130_fd_sc_hd__decap_4
XFILLER_0_55_137 VGND VGND VPWR VPWR sky130_fd_sc_hd__decap_8
XFILLER_0_64_671 VGND VGND VPWR VPWR sky130_fd_sc_hd__fill_2
XFILLER_0_113_209 VPWR VGND VPWR VGND sky130_ef_sc_hd__decap_12
XFILLER_0_36_373 VGND VGND VPWR VPWR sky130_fd_sc_hd__fill_1
XFILLER_0_3_429 VPWR VGND VPWR VGND sky130_ef_sc_hd__decap_12
X_4040_ u_pe_array.g_pe_row\[3\].g_pe_col\[2\].u_pe.psum_out\[7\] VGND VGND VPWR VPWR
+ _1239_ sky130_fd_sc_hd__inv_2
XFILLER_0_91_57 VGND VGND VPWR VPWR sky130_fd_sc_hd__decap_8
X_5991_ u_pe_array.g_pe_row\[1\].g_pe_col\[0\].u_pe.psum_out\[2\] _2745_ VGND VGND
+ VPWR VPWR _2746_ sky130_fd_sc_hd__xnor2_1
XFILLER_0_115_53 VGND VGND VPWR VPWR sky130_fd_sc_hd__decap_3
X_4942_ _1924_ _1925_ VGND VGND VPWR VPWR _1926_ sky130_fd_sc_hd__or2_1
XFILLER_0_24_40 VGND VGND VPWR VPWR sky130_fd_sc_hd__decap_3
X_7730_ clknet_leaf_73_clk _0636_ net13 VGND VGND VPWR VPWR u_pe_array.g_pe_row\[0\].g_pe_col\[2\].u_pe.psum_out\[8\]
+ sky130_fd_sc_hd__dfrtp_2
XFILLER_0_86_262 VGND VGND VPWR VPWR sky130_fd_sc_hd__decap_8
XFILLER_0_74_424 VGND VGND VPWR VPWR sky130_fd_sc_hd__decap_8
X_7661_ clknet_leaf_62_clk _0567_ net74 VGND VGND VPWR VPWR u_pe_array.act_from_right\[2\]\[6\]
+ sky130_fd_sc_hd__dfrtp_1
XFILLER_0_59_487 VGND VGND VPWR VPWR sky130_fd_sc_hd__decap_6
X_4873_ u_pe_array.g_pe_row\[2\].g_pe_col\[1\].u_pe.psum_out\[9\] u_pe_array.g_pe_row\[2\].g_pe_col\[1\].u_pe.move_reg\[9\]
+ _1867_ VGND VGND VPWR VPWR _1878_ sky130_fd_sc_hd__mux2_1
X_6612_ net272 _1731_ _2009_ _3230_ VGND VGND VPWR VPWR _0684_ sky130_fd_sc_hd__a22o_1
X_7592_ clknet_leaf_47_clk _0498_ net73 VGND VGND VPWR VPWR u_pe_array.g_pe_row\[1\].g_pe_col\[1\].u_pe.psum_out\[6\]
+ sky130_fd_sc_hd__dfrtp_1
X_3824_ _1067_ _1069_ _1074_ VGND VGND VPWR VPWR _1076_ sky130_fd_sc_hd__o21a_1
XFILLER_0_15_502 VGND VGND VPWR VPWR sky130_fd_sc_hd__fill_2
X_6543_ _3169_ _3170_ VGND VGND VPWR VPWR _3171_ sky130_fd_sc_hd__or2_1
X_3755_ _1010_ u_pe_array.g_pe_row\[3\].g_pe_col\[3\].u_pe.act_val\[3\] u_pe_array.g_pe_row\[3\].g_pe_col\[3\].u_pe.w_out\[0\]
+ _0988_ VGND VGND VPWR VPWR _1012_ sky130_fd_sc_hd__nand4_1
XFILLER_0_15_513 VGND VGND VPWR VPWR sky130_fd_sc_hd__decap_3
XFILLER_0_15_546 VPWR VGND VPWR VGND sky130_ef_sc_hd__decap_12
XFILLER_0_42_321 VGND VGND VPWR VPWR sky130_fd_sc_hd__decap_4
X_6474_ u_pe_array.g_pe_row\[0\].g_pe_col\[1\].u_pe.act_val\[5\] _2343_ _2320_ net283
+ VGND VGND VPWR VPWR _0661_ sky130_fd_sc_hd__a22o_1
X_3686_ net439 _0949_ _0944_ _0960_ VGND VGND VPWR VPWR _0028_ sky130_fd_sc_hd__a22o_1
XFILLER_0_40_83 VGND VGND VPWR VPWR sky130_fd_sc_hd__fill_1
XFILLER_0_42_365 VPWR VGND VPWR VGND sky130_ef_sc_hd__decap_12
X_5425_ u_pe_array.g_pe_row\[1\].g_pe_col\[2\].u_pe.psum_out\[10\] _1108_ _1110_ _2305_
+ VGND VGND VPWR VPWR _2306_ sky130_fd_sc_hd__o211a_1
XFILLER_0_112_253 VGND VGND VPWR VPWR sky130_fd_sc_hd__decap_8
XFILLER_0_64_3 VGND VGND VPWR VPWR sky130_fd_sc_hd__fill_2
X_5356_ u_pe_array.g_pe_row\[1\].g_pe_col\[3\].u_pe.psum_out\[10\] _1426_ VGND VGND
+ VPWR VPWR _2252_ sky130_fd_sc_hd__or2_1
XFILLER_0_10_251 VGND VGND VPWR VPWR sky130_fd_sc_hd__fill_1
X_4307_ net859 _1450_ _1116_ VGND VGND VPWR VPWR _1451_ sky130_fd_sc_hd__mux2_1
X_5287_ _2188_ _2189_ VGND VGND VPWR VPWR _2190_ sky130_fd_sc_hd__or2_1
X_4238_ u_pe_array.g_pe_row\[3\].g_pe_col\[1\].u_pe.psum_out\[8\] _1380_ VGND VGND
+ VPWR VPWR _1395_ sky130_fd_sc_hd__nor2_1
X_7026_ _3507_ VGND VGND VPWR VPWR _0821_ sky130_fd_sc_hd__clkbuf_1
XFILLER_0_4_83 VGND VGND VPWR VPWR sky130_fd_sc_hd__fill_1
XFILLER_0_97_505 VPWR VGND VPWR VGND sky130_ef_sc_hd__decap_12
X_4169_ u_pe_array.g_pe_row\[3\].g_pe_col\[1\].u_pe.act_val\[2\] VGND VGND VPWR VPWR
+ _1331_ sky130_fd_sc_hd__inv_2
Xclkbuf_leaf_94_clk clknet_3_1__leaf_clk VGND VGND VPWR VPWR clknet_leaf_94_clk sky130_fd_sc_hd__clkbuf_16
X_7928_ clknet_leaf_77_clk _0833_ VGND VGND VPWR VPWR u_pe_array.u_fifo1.buffer\[5\]\[0\]
+ sky130_fd_sc_hd__dfxtp_1
XFILLER_0_38_605 VGND VGND VPWR VPWR sky130_fd_sc_hd__fill_1
XFILLER_0_65_402 VGND VGND VPWR VPWR sky130_fd_sc_hd__decap_3
X_7859_ clknet_leaf_86_clk _0764_ VGND VGND VPWR VPWR u_pe_array.u_fifo2.buffer\[3\]\[5\]
+ sky130_fd_sc_hd__dfxtp_1
XFILLER_0_108_559 VGND VGND VPWR VPWR sky130_fd_sc_hd__fill_1
XFILLER_0_37_159 VGND VGND VPWR VPWR sky130_fd_sc_hd__decap_8
XFILLER_0_103_231 VGND VGND VPWR VPWR sky130_fd_sc_hd__fill_1
XFILLER_0_60_162 VGND VGND VPWR VPWR sky130_fd_sc_hd__decap_4
XFILLER_0_103_275 VGND VGND VPWR VPWR sky130_fd_sc_hd__fill_2
XFILLER_0_60_195 VGND VGND VPWR VPWR sky130_fd_sc_hd__fill_1
Xclkbuf_leaf_85_clk clknet_3_4__leaf_clk VGND VGND VPWR VPWR clknet_leaf_85_clk sky130_fd_sc_hd__clkbuf_16
XFILLER_0_0_19 VGND VGND VPWR VPWR sky130_fd_sc_hd__decap_8
XTAP_1450 VGND VPWR sky130_fd_sc_hd__tapvpwrvgnd_1
XFILLER_0_68_262 VGND VGND VPWR VPWR sky130_fd_sc_hd__decap_6
XFILLER_0_68_251 VGND VGND VPWR VPWR sky130_fd_sc_hd__fill_1
XTAP_1483 VGND VPWR sky130_fd_sc_hd__tapvpwrvgnd_1
XTAP_1472 VGND VPWR sky130_fd_sc_hd__tapvpwrvgnd_1
XTAP_1461 VGND VPWR sky130_fd_sc_hd__tapvpwrvgnd_1
XTAP_1494 VGND VPWR sky130_fd_sc_hd__tapvpwrvgnd_1
XFILLER_0_37_671 VGND VGND VPWR VPWR sky130_fd_sc_hd__fill_1
XFILLER_0_9_39 VPWR VGND VPWR VGND sky130_ef_sc_hd__decap_12
XFILLER_0_107_581 VGND VGND VPWR VPWR sky130_fd_sc_hd__decap_6
XFILLER_0_101_55 VGND VGND VPWR VPWR sky130_fd_sc_hd__fill_1
XFILLER_0_10_53 VPWR VGND VPWR VGND sky130_ef_sc_hd__decap_12
XFILLER_0_3_237 VPWR VGND VPWR VGND sky130_ef_sc_hd__decap_12
XFILLER_0_24_365 VGND VGND VPWR VPWR sky130_fd_sc_hd__decap_3
XFILLER_0_51_173 VGND VGND VPWR VPWR sky130_fd_sc_hd__fill_1
X_5210_ u_pe_array.g_pe_row\[1\].g_pe_col\[3\].u_pe.psum_out\[4\] u_pe_array.g_pe_row\[1\].g_pe_col\[3\].u_pe.act_val\[4\]
+ _2133_ VGND VGND VPWR VPWR _2138_ sky130_fd_sc_hd__mux2_1
XFILLER_0_10_97 VPWR VGND VPWR VGND sky130_ef_sc_hd__decap_12
X_6190_ _2892_ _2900_ _1003_ VGND VGND VPWR VPWR _2902_ sky130_fd_sc_hd__a21o_1
X_5141_ _2079_ _2081_ VGND VGND VPWR VPWR _2082_ sky130_fd_sc_hd__xnor2_1
X_5072_ _1884_ _2017_ _2018_ _1803_ net534 VGND VGND VPWR VPWR _0356_ sky130_fd_sc_hd__a32o_1
XFILLER_0_19_51 VGND VGND VPWR VPWR sky130_fd_sc_hd__decap_4
X_4023_ _1208_ _1218_ _1222_ VGND VGND VPWR VPWR _1224_ sky130_fd_sc_hd__nor3_1
XFILLER_0_79_505 VGND VGND VPWR VPWR sky130_fd_sc_hd__decap_4
Xclkbuf_leaf_76_clk clknet_3_5__leaf_clk VGND VGND VPWR VPWR clknet_leaf_76_clk sky130_fd_sc_hd__clkbuf_16
X_7713_ clknet_leaf_60_clk net260 net74 VGND VGND VPWR VPWR u_pe_array.g_pe_row\[0\].g_pe_col\[2\].u_pe.act_val\[4\]
+ sky130_fd_sc_hd__dfrtp_4
X_5974_ u_pe_array.g_pe_row\[1\].g_pe_col\[0\].u_pe.act_val\[0\] u_pe_array.g_pe_row\[1\].g_pe_col\[0\].u_pe.w_out\[0\]
+ u_pe_array.g_pe_row\[1\].g_pe_col\[0\].u_pe.psum_out\[0\] VGND VGND VPWR VPWR _2731_
+ sky130_fd_sc_hd__a21o_1
X_4925_ _1908_ _1909_ VGND VGND VPWR VPWR _1910_ sky130_fd_sc_hd__nand2_1
XFILLER_0_74_221 VGND VGND VPWR VPWR sky130_fd_sc_hd__decap_6
XFILLER_0_19_126 VGND VGND VPWR VPWR sky130_fd_sc_hd__fill_2
XFILLER_0_117_312 VPWR VGND VPWR VGND sky130_ef_sc_hd__decap_12
X_4856_ u_pe_array.g_pe_row\[2\].g_pe_col\[1\].u_pe.psum_out\[1\] u_pe_array.g_pe_row\[2\].g_pe_col\[1\].u_pe.act_val\[1\]
+ _1867_ VGND VGND VPWR VPWR _1869_ sky130_fd_sc_hd__mux2_1
XFILLER_0_62_416 VGND VGND VPWR VPWR sky130_fd_sc_hd__decap_4
X_7644_ clknet_leaf_71_clk _0550_ net949 VGND VGND VPWR VPWR u_pe_array.g_pe_row\[1\].g_pe_col\[0\].u_pe.psum_out\[4\]
+ sky130_fd_sc_hd__dfrtp_2
X_7575_ clknet_leaf_33_clk _0481_ net947 VGND VGND VPWR VPWR u_pe_array.g_pe_row\[1\].g_pe_col\[1\].u_pe.act_val\[2\]
+ sky130_fd_sc_hd__dfrtp_2
X_3807_ u_pe_array.g_pe_row\[3\].g_pe_col\[3\].u_pe.psum_out\[7\] _0988_ VGND VGND
+ VPWR VPWR _1060_ sky130_fd_sc_hd__or2_1
X_6526_ _3154_ _3155_ VGND VGND VPWR VPWR _3156_ sky130_fd_sc_hd__or2_1
X_4787_ _1807_ _1809_ VGND VGND VPWR VPWR _1810_ sky130_fd_sc_hd__xnor2_1
XFILLER_0_43_663 VGND VGND VPWR VPWR sky130_fd_sc_hd__fill_1
X_3738_ u_pe_array.g_pe_row\[3\].g_pe_col\[3\].u_pe.act_val\[0\] _0987_ _0988_ VGND
+ VGND VPWR VPWR _0996_ sky130_fd_sc_hd__a21bo_1
XFILLER_0_42_173 VGND VGND VPWR VPWR sky130_fd_sc_hd__decap_8
X_6457_ u_pe_array.g_pe_row\[0\].g_pe_col\[1\].u_pe.psum_out\[7\] u_pe_array.g_pe_row\[0\].g_pe_col\[1\].u_pe.move_reg\[7\]
+ _3102_ VGND VGND VPWR VPWR _3110_ sky130_fd_sc_hd__mux2_1
X_3669_ u_pe_array.g_pe_row\[3\].g_pe_col\[3\].u_pe.psum_out\[3\] u_pe_array.g_pe_row\[3\].g_pe_col\[3\].u_pe.act_val\[3\]
+ _0947_ VGND VGND VPWR VPWR _0952_ sky130_fd_sc_hd__mux2_1
XFILLER_0_100_212 VPWR VGND VPWR VGND sky130_ef_sc_hd__decap_12
X_5408_ u_pe_array.g_pe_row\[1\].g_pe_col\[2\].u_pe.move_reg\[6\] net62 VGND VGND
+ VPWR VPWR _2293_ sky130_fd_sc_hd__or2_1
X_6388_ u_pe_array.g_pe_row\[0\].g_pe_col\[2\].u_pe.psum_out\[7\] _2130_ VGND VGND
+ VPWR VPWR _3056_ sky130_fd_sc_hd__nand2_1
X_5339_ u_pe_array.g_pe_row\[1\].g_pe_col\[3\].u_pe.psum_out\[8\] _1426_ VGND VGND
+ VPWR VPWR _2237_ sky130_fd_sc_hd__nand2_1
Xclkbuf_leaf_67_clk clknet_3_6__leaf_clk VGND VGND VPWR VPWR clknet_leaf_67_clk sky130_fd_sc_hd__clkbuf_16
X_7009_ _3497_ VGND VGND VPWR VPWR _0814_ sky130_fd_sc_hd__clkbuf_1
XFILLER_0_108_301 VGND VGND VPWR VPWR sky130_fd_sc_hd__decap_6
XFILLER_0_93_541 VGND VGND VPWR VPWR sky130_fd_sc_hd__fill_1
XFILLER_0_38_446 VGND VGND VPWR VPWR sky130_fd_sc_hd__fill_2
XFILLER_0_19_693 VPWR VGND VPWR VGND sky130_ef_sc_hd__decap_12
XFILLER_0_53_449 VGND VGND VPWR VPWR sky130_fd_sc_hd__decap_4
XFILLER_0_18_181 VGND VGND VPWR VPWR sky130_fd_sc_hd__decap_8
XFILLER_0_33_151 VPWR VGND VPWR VGND sky130_ef_sc_hd__decap_12
XFILLER_0_21_335 VGND VGND VPWR VPWR sky130_fd_sc_hd__fill_1
XFILLER_0_33_195 VGND VGND VPWR VPWR sky130_fd_sc_hd__fill_1
XFILLER_0_21_357 VGND VGND VPWR VPWR sky130_fd_sc_hd__decap_8
XTAP_508 VGND VPWR sky130_fd_sc_hd__tapvpwrvgnd_1
XTAP_519 VGND VPWR sky130_fd_sc_hd__tapvpwrvgnd_1
Xclkbuf_leaf_58_clk clknet_3_7__leaf_clk VGND VGND VPWR VPWR clknet_leaf_58_clk sky130_fd_sc_hd__clkbuf_16
XFILLER_0_29_413 VPWR VGND VPWR VGND sky130_ef_sc_hd__decap_12
XFILLER_0_69_593 VGND VGND VPWR VPWR sky130_fd_sc_hd__decap_3
XFILLER_0_8_307 VGND VGND VPWR VPWR sky130_fd_sc_hd__fill_1
XFILLER_0_29_446 VGND VGND VPWR VPWR sky130_fd_sc_hd__fill_2
X_5690_ net920 _2499_ _2491_ _2509_ VGND VGND VPWR VPWR _0483_ sky130_fd_sc_hd__a22o_1
XTAP_1291 VGND VPWR sky130_fd_sc_hd__tapvpwrvgnd_1
XTAP_1280 VGND VPWR sky130_fd_sc_hd__tapvpwrvgnd_1
X_4710_ u_pe_array.g_pe_row\[2\].g_pe_col\[2\].u_pe.act_val\[3\] _1605_ _1611_ net257
+ VGND VGND VPWR VPWR _0264_ sky130_fd_sc_hd__a22o_1
X_4641_ u_pe_array.g_pe_row\[2\].g_pe_col\[3\].u_pe.psum_out\[9\] _1427_ VGND VGND
+ VPWR VPWR _1702_ sky130_fd_sc_hd__nand2_1
XFILLER_0_112_65 VPWR VGND VPWR VGND sky130_ef_sc_hd__decap_12
XFILLER_0_4_524 VGND VGND VPWR VPWR sky130_fd_sc_hd__decap_8
XFILLER_0_114_337 VGND VGND VPWR VPWR sky130_fd_sc_hd__fill_2
XFILLER_0_4_557 VPWR VGND VPWR VGND sky130_ef_sc_hd__decap_12
X_4572_ _1634_ _1638_ VGND VGND VPWR VPWR _1639_ sky130_fd_sc_hd__xnor2_1
X_7360_ clknet_leaf_0_clk net124 net944 VGND VGND VPWR VPWR u_pe_array.g_pe_row\[2\].g_pe_col\[2\].u_pe.act_val\[5\]
+ sky130_fd_sc_hd__dfrtp_2
Xhold726 net39 VGND VGND VPWR VPWR net800 sky130_fd_sc_hd__dlygate4sd3_1
Xhold704 u_pe_array.g_pe_row\[1\].g_pe_col\[1\].u_pe.psum_out\[9\] VGND VGND VPWR
+ VPWR net778 sky130_fd_sc_hd__dlygate4sd3_1
Xhold715 u_pe_array.g_pe_row\[3\].g_pe_col\[3\].u_pe.psum_out\[9\] VGND VGND VPWR
+ VPWR net789 sky130_fd_sc_hd__dlygate4sd3_1
X_6311_ net459 _2730_ _0940_ u_pe_array.g_pe_row\[0\].g_pe_col\[2\].u_pe.move_reg\[11\]
+ VGND VGND VPWR VPWR _0626_ sky130_fd_sc_hd__a22o_1
Xhold737 u_pe_array.act_from_left\[15\]\[0\] VGND VGND VPWR VPWR net811 sky130_fd_sc_hd__dlygate4sd3_1
X_7291_ clknet_leaf_10_clk _0197_ net950 VGND VGND VPWR VPWR u_pe_array.g_pe_row\[3\].g_pe_col\[0\].u_pe.psum_out\[5\]
+ sky130_fd_sc_hd__dfrtp_2
X_6242_ u_pe_array.g_pe_row\[0\].g_pe_col\[3\].u_pe.psum_out\[8\] u_pe_array.g_pe_row\[0\].g_pe_col\[3\].u_pe.psum_out\[9\]
+ _1999_ VGND VGND VPWR VPWR _2949_ sky130_fd_sc_hd__and3_1
Xhold748 _0386_ VGND VGND VPWR VPWR net822 sky130_fd_sc_hd__dlygate4sd3_1
Xhold759 u_pe_array.g_pe_row\[3\].g_pe_col\[2\].u_pe.act_val\[2\] VGND VGND VPWR VPWR
+ net833 sky130_fd_sc_hd__dlygate4sd3_1
X_6173_ u_pe_array.g_pe_row\[0\].g_pe_col\[3\].u_pe.act_val\[2\] u_pe_array.g_pe_row\[0\].g_pe_col\[3\].u_pe.w_out\[0\]
+ _2872_ VGND VGND VPWR VPWR _2886_ sky130_fd_sc_hd__and3_1
X_5124_ _2063_ _2065_ VGND VGND VPWR VPWR _2066_ sky130_fd_sc_hd__xor2_1
Xclkbuf_leaf_49_clk clknet_3_6__leaf_clk VGND VGND VPWR VPWR clknet_leaf_49_clk sky130_fd_sc_hd__clkbuf_16
X_5055_ net357 _2006_ _2009_ _2015_ VGND VGND VPWR VPWR _0342_ sky130_fd_sc_hd__a22o_1
XFILLER_0_46_60 VGND VGND VPWR VPWR sky130_fd_sc_hd__fill_1
X_4006_ _1126_ u_pe_array.g_pe_row\[3\].g_pe_col\[2\].u_pe.psum_out\[4\] _0934_ VGND
+ VGND VPWR VPWR _1208_ sky130_fd_sc_hd__and3_1
XFILLER_0_27_3 VGND VGND VPWR VPWR sky130_fd_sc_hd__decap_6
XFILLER_0_46_93 VGND VGND VPWR VPWR sky130_fd_sc_hd__decap_6
XFILLER_0_79_335 VGND VGND VPWR VPWR sky130_fd_sc_hd__fill_1
XFILLER_0_1_51 VGND VGND VPWR VPWR sky130_fd_sc_hd__decap_4
XFILLER_0_62_70 VGND VGND VPWR VPWR sky130_fd_sc_hd__decap_6
X_5957_ _2320_ _2721_ _2722_ _2343_ net633 VGND VGND VPWR VPWR _0537_ sky130_fd_sc_hd__a32o_1
X_4908_ _1886_ _1890_ VGND VGND VPWR VPWR _1894_ sky130_fd_sc_hd__nand2_1
XFILLER_0_90_533 VPWR VGND VPWR VGND sky130_ef_sc_hd__decap_12
X_7627_ clknet_leaf_72_clk _0533_ net949 VGND VGND VPWR VPWR u_pe_array.g_pe_row\[1\].g_pe_col\[0\].u_pe.act_val\[0\]
+ sky130_fd_sc_hd__dfrtp_2
X_5888_ _2632_ net862 _1158_ VGND VGND VPWR VPWR _2670_ sky130_fd_sc_hd__mux2_1
XFILLER_0_118_698 VGND VGND VPWR VPWR sky130_fd_sc_hd__fill_2
X_4839_ u_pe_array.g_pe_row\[2\].g_pe_col\[2\].u_pe.psum_out\[11\] _1856_ _1847_ VGND
+ VGND VPWR VPWR _1857_ sky130_fd_sc_hd__mux2_1
XFILLER_0_35_449 VGND VGND VPWR VPWR sky130_fd_sc_hd__decap_8
X_7558_ clknet_leaf_56_clk _0464_ net946 VGND VGND VPWR VPWR u_pe_array.g_pe_row\[1\].g_pe_col\[0\].u_pe.w_out\[0\]
+ sky130_fd_sc_hd__dfrtp_4
XFILLER_0_15_140 VGND VGND VPWR VPWR sky130_fd_sc_hd__decap_6
XFILLER_0_16_685 VPWR VGND VPWR VGND sky130_ef_sc_hd__decap_12
XFILLER_0_50_408 VGND VGND VPWR VPWR sky130_fd_sc_hd__decap_3
XFILLER_0_50_419 VGND VGND VPWR VPWR sky130_fd_sc_hd__fill_1
X_6509_ _3138_ _3139_ VGND VGND VPWR VPWR _3140_ sky130_fd_sc_hd__nand2_1
X_7489_ clknet_leaf_42_clk _0395_ net946 VGND VGND VPWR VPWR u_pe_array.g_pe_row\[1\].g_pe_col\[3\].u_pe.move_reg\[11\]
+ sky130_fd_sc_hd__dfrtp_1
XFILLER_0_31_633 VGND VGND VPWR VPWR sky130_fd_sc_hd__fill_1
XFILLER_0_31_666 VGND VGND VPWR VPWR sky130_fd_sc_hd__decap_6
Xhold31 _0448_ VGND VGND VPWR VPWR net105 sky130_fd_sc_hd__dlygate4sd3_1
Xhold20 _0273_ VGND VGND VPWR VPWR net94 sky130_fd_sc_hd__dlygate4sd3_1
Xhold64 _0706_ VGND VGND VPWR VPWR net138 sky130_fd_sc_hd__dlygate4sd3_1
Xhold42 u_pe_array.act_from_left\[15\]\[8\] VGND VGND VPWR VPWR net116 sky130_fd_sc_hd__dlygate4sd3_1
Xhold53 u_pe_array.act_from_left\[15\]\[12\] VGND VGND VPWR VPWR net127 sky130_fd_sc_hd__dlygate4sd3_1
XFILLER_0_98_633 VGND VGND VPWR VPWR sky130_fd_sc_hd__decap_3
XFILLER_0_97_110 VGND VGND VPWR VPWR sky130_fd_sc_hd__fill_2
Xhold97 u_pe_array.act_from_down\[3\]\[1\] VGND VGND VPWR VPWR net171 sky130_fd_sc_hd__buf_1
Xhold86 u_pe_array.act_from_left\[13\]\[7\] VGND VGND VPWR VPWR net160 sky130_fd_sc_hd__dlygate4sd3_1
Xhold75 u_pe_array.act_from_left\[7\]\[12\] VGND VGND VPWR VPWR net149 sky130_fd_sc_hd__dlygate4sd3_1
XFILLER_0_98_688 VPWR VGND VPWR VGND sky130_ef_sc_hd__decap_12
XFILLER_0_97_176 VGND VGND VPWR VPWR sky130_fd_sc_hd__decap_4
XFILLER_0_85_349 VGND VGND VPWR VPWR sky130_fd_sc_hd__decap_6
XFILLER_0_38_210 VGND VGND VPWR VPWR sky130_fd_sc_hd__fill_1
XFILLER_0_66_541 VGND VGND VPWR VPWR sky130_fd_sc_hd__fill_1
XFILLER_0_38_265 VGND VGND VPWR VPWR sky130_fd_sc_hd__fill_1
XFILLER_0_93_393 VGND VGND VPWR VPWR sky130_fd_sc_hd__decap_8
XFILLER_0_108_197 VGND VGND VPWR VPWR sky130_fd_sc_hd__fill_2
XFILLER_0_81_577 VGND VGND VPWR VPWR sky130_fd_sc_hd__fill_1
XFILLER_0_1_505 VPWR VGND VPWR VGND sky130_ef_sc_hd__decap_12
XFILLER_0_22_633 VGND VGND VPWR VPWR sky130_fd_sc_hd__decap_3
XANTENNA_6 net9 VGND VGND VPWR VPWR sky130_fd_sc_hd__diode_2
XFILLER_0_6_29 VPWR VGND VPWR VGND sky130_ef_sc_hd__decap_12
XTAP_305 VGND VPWR sky130_fd_sc_hd__tapvpwrvgnd_1
XFILLER_0_22_699 VGND VGND VPWR VPWR sky130_fd_sc_hd__fill_1
XTAP_349 VGND VPWR sky130_fd_sc_hd__tapvpwrvgnd_1
XTAP_327 VGND VPWR sky130_fd_sc_hd__tapvpwrvgnd_1
XTAP_338 VGND VPWR sky130_fd_sc_hd__tapvpwrvgnd_1
XTAP_316 VGND VPWR sky130_fd_sc_hd__tapvpwrvgnd_1
XFILLER_0_88_132 VGND VGND VPWR VPWR sky130_fd_sc_hd__fill_1
XFILLER_0_16_41 VPWR VGND VPWR VGND sky130_ef_sc_hd__decap_12
X_6860_ _3409_ VGND VGND VPWR VPWR _0753_ sky130_fd_sc_hd__clkbuf_1
X_5811_ _2600_ _2610_ _2611_ VGND VGND VPWR VPWR _2612_ sky130_fd_sc_hd__a21oi_1
X_6791_ net746 _0914_ _3364_ VGND VGND VPWR VPWR _0729_ sky130_fd_sc_hd__a21oi_1
X_5742_ u_pe_array.g_pe_row\[1\].g_pe_col\[1\].u_pe.psum_out\[3\] _2534_ _2535_ VGND
+ VGND VPWR VPWR _2549_ sky130_fd_sc_hd__a21boi_2
XFILLER_0_72_500 VGND VGND VPWR VPWR sky130_fd_sc_hd__decap_4
XFILLER_0_115_613 VGND VGND VPWR VPWR sky130_fd_sc_hd__decap_3
XFILLER_0_115_602 VGND VGND VPWR VPWR sky130_fd_sc_hd__decap_3
X_5673_ u_pe_array.g_pe_row\[1\].g_pe_col\[1\].u_pe.psum_out\[9\] u_pe_array.g_pe_row\[1\].g_pe_col\[1\].u_pe.move_reg\[9\]
+ _2133_ VGND VGND VPWR VPWR _2501_ sky130_fd_sc_hd__mux2_1
XFILLER_0_72_533 VGND VGND VPWR VPWR sky130_fd_sc_hd__decap_3
X_7412_ clknet_leaf_28_clk _0318_ net71 VGND VGND VPWR VPWR u_pe_array.g_pe_row\[2\].g_pe_col\[1\].u_pe.psum_out\[3\]
+ sky130_fd_sc_hd__dfrtp_1
XFILLER_0_32_419 VGND VGND VPWR VPWR sky130_fd_sc_hd__fill_1
X_4624_ _1682_ _1686_ _1671_ VGND VGND VPWR VPWR _1687_ sky130_fd_sc_hd__mux2_1
XFILLER_0_44_279 VGND VGND VPWR VPWR sky130_fd_sc_hd__fill_2
XFILLER_0_12_110 VGND VGND VPWR VPWR sky130_fd_sc_hd__decap_4
X_7343_ clknet_leaf_105_clk _0249_ net944 VGND VGND VPWR VPWR u_pe_array.act_from_up\[14\]\[1\]
+ sky130_fd_sc_hd__dfrtp_1
Xhold501 u_pe_array.u_fifo2.buffer\[2\]\[1\] VGND VGND VPWR VPWR net575 sky130_fd_sc_hd__dlygate4sd3_1
XFILLER_0_4_354 VGND VGND VPWR VPWR sky130_fd_sc_hd__fill_1
X_4555_ u_pe_array.g_pe_row\[2\].g_pe_col\[3\].u_pe.act_val\[2\] _1424_ VGND VGND
+ VPWR VPWR _1623_ sky130_fd_sc_hd__nand2_1
XFILLER_0_114_189 VGND VGND VPWR VPWR sky130_fd_sc_hd__decap_6
XFILLER_0_13_666 VGND VGND VPWR VPWR sky130_fd_sc_hd__decap_6
Xhold534 u_pe_array.u_fifo1.buffer\[5\]\[1\] VGND VGND VPWR VPWR net608 sky130_fd_sc_hd__dlygate4sd3_1
Xhold545 u_pe_array.u_fifo1.buffer\[2\]\[2\] VGND VGND VPWR VPWR net619 sky130_fd_sc_hd__dlygate4sd3_1
Xhold512 u_pe_array.u_fifo1.buffer\[7\]\[1\] VGND VGND VPWR VPWR net586 sky130_fd_sc_hd__dlygate4sd3_1
Xhold523 u_pe_array.u_fifo1.buffer\[3\]\[4\] VGND VGND VPWR VPWR net597 sky130_fd_sc_hd__dlygate4sd3_1
X_7274_ clknet_leaf_13_clk _0180_ net942 VGND VGND VPWR VPWR u_pe_array.g_pe_row\[3\].g_pe_col\[0\].u_pe.act_val\[1\]
+ sky130_fd_sc_hd__dfrtp_1
Xhold567 u_pe_array.act_from_right\[13\]\[4\] VGND VGND VPWR VPWR net641 sky130_fd_sc_hd__dlygate4sd3_1
Xhold556 u_pe_array.u_fifo2.buffer\[8\]\[2\] VGND VGND VPWR VPWR net630 sky130_fd_sc_hd__dlygate4sd3_1
Xhold578 u_pe_array.u_fifo1.buffer\[2\]\[5\] VGND VGND VPWR VPWR net652 sky130_fd_sc_hd__dlygate4sd3_1
XFILLER_0_40_485 VGND VGND VPWR VPWR sky130_fd_sc_hd__decap_3
X_4486_ _1287_ u_pe_array.g_pe_row\[3\].g_pe_col\[0\].u_pe.psum_out\[11\] VGND VGND
+ VPWR VPWR _1586_ sky130_fd_sc_hd__and2b_1
XFILLER_0_110_373 VGND VGND VPWR VPWR sky130_fd_sc_hd__fill_1
X_6225_ _2795_ _2932_ _2933_ _2621_ net777 VGND VGND VPWR VPWR _0594_ sky130_fd_sc_hd__a32o_1
Xhold589 u_pe_array.u_fifo1.buffer\[1\]\[2\] VGND VGND VPWR VPWR net663 sky130_fd_sc_hd__dlygate4sd3_1
X_6156_ u_pe_array.g_pe_row\[0\].g_pe_col\[3\].u_pe.psum_out\[1\] _2866_ _2869_ VGND
+ VGND VPWR VPWR _2870_ sky130_fd_sc_hd__a21bo_1
XTAP_850 VGND VPWR sky130_fd_sc_hd__tapvpwrvgnd_1
XTAP_861 VGND VPWR sky130_fd_sc_hd__tapvpwrvgnd_1
X_5107_ u_pe_array.g_pe_row\[2\].g_pe_col\[0\].u_pe.act_val\[3\] VGND VGND VPWR VPWR
+ _2050_ sky130_fd_sc_hd__inv_2
XTAP_872 VGND VPWR sky130_fd_sc_hd__tapvpwrvgnd_1
XTAP_883 VGND VPWR sky130_fd_sc_hd__tapvpwrvgnd_1
XTAP_894 VGND VPWR sky130_fd_sc_hd__tapvpwrvgnd_1
X_6087_ _1865_ u_pe_array.g_pe_row\[1\].g_pe_col\[0\].u_pe.psum_out\[11\] VGND VGND
+ VPWR VPWR _2833_ sky130_fd_sc_hd__and2b_1
X_5038_ _1730_ VGND VGND VPWR VPWR _2006_ sky130_fd_sc_hd__buf_6
XFILLER_0_95_625 VGND VGND VPWR VPWR sky130_fd_sc_hd__fill_1
X_6989_ net562 _3356_ _3484_ VGND VGND VPWR VPWR _3487_ sky130_fd_sc_hd__mux2_1
XFILLER_0_48_596 VGND VGND VPWR VPWR sky130_fd_sc_hd__fill_2
XFILLER_0_118_473 VGND VGND VPWR VPWR sky130_fd_sc_hd__decap_3
XFILLER_0_75_393 VGND VGND VPWR VPWR sky130_fd_sc_hd__decap_4
XFILLER_0_106_657 VPWR VGND VPWR VGND sky130_ef_sc_hd__decap_12
XFILLER_0_90_352 VPWR VGND VPWR VGND sky130_ef_sc_hd__decap_12
XFILLER_0_7_181 VPWR VGND VPWR VGND sky130_ef_sc_hd__decap_12
XFILLER_0_35_279 VGND VGND VPWR VPWR sky130_fd_sc_hd__fill_1
XFILLER_0_105_145 VGND VGND VPWR VPWR sky130_fd_sc_hd__fill_1
XFILLER_0_50_249 VGND VGND VPWR VPWR sky130_fd_sc_hd__decap_3
Xoutput43 net43 VGND VGND VPWR VPWR psum_out0[4] sky130_fd_sc_hd__clkbuf_4
XFILLER_0_101_362 VGND VGND VPWR VPWR sky130_fd_sc_hd__decap_3
Xoutput54 net54 VGND VGND VPWR VPWR psum_out1[2] sky130_fd_sc_hd__clkbuf_4
XFILLER_0_98_452 VGND VGND VPWR VPWR sky130_fd_sc_hd__decap_3
XFILLER_0_94_691 VGND VGND VPWR VPWR sky130_fd_sc_hd__decap_8
XPHY_160 VGND VGND VPWR VPWR sky130_fd_sc_hd__decap_3
XPHY_193 VGND VGND VPWR VPWR sky130_fd_sc_hd__decap_3
XPHY_182 VGND VGND VPWR VPWR sky130_fd_sc_hd__decap_3
XPHY_171 VGND VGND VPWR VPWR sky130_fd_sc_hd__decap_3
XFILLER_0_26_246 VGND VGND VPWR VPWR sky130_fd_sc_hd__decap_6
XFILLER_0_54_577 VGND VGND VPWR VPWR sky130_fd_sc_hd__decap_8
XFILLER_0_112_638 VGND VGND VPWR VPWR sky130_fd_sc_hd__decap_6
XFILLER_0_1_313 VGND VGND VPWR VPWR sky130_fd_sc_hd__fill_2
XFILLER_0_10_636 VGND VGND VPWR VPWR sky130_fd_sc_hd__decap_8
XFILLER_0_1_346 VGND VGND VPWR VPWR sky130_fd_sc_hd__decap_6
X_4340_ _1473_ VGND VGND VPWR VPWR _0169_ sky130_fd_sc_hd__clkbuf_1
X_4271_ u_pe_array.g_pe_row\[1\].g_pe_col\[3\].u_pe.w_out\[0\] VGND VGND VPWR VPWR
+ _1423_ sky130_fd_sc_hd__buf_4
XFILLER_0_10_669 VPWR VGND VPWR VGND sky130_ef_sc_hd__decap_12
X_6010_ u_pe_array.g_pe_row\[1\].g_pe_col\[0\].u_pe.act_val\[3\] _1865_ VGND VGND
+ VPWR VPWR _2763_ sky130_fd_sc_hd__and2b_1
XFILLER_0_118_53 VGND VGND VPWR VPWR sky130_fd_sc_hd__decap_3
XFILLER_0_118_97 VGND VGND VPWR VPWR sky130_fd_sc_hd__decap_8
X_6912_ _3422_ u_pe_array.u_fifo2.wr_ptr\[0\] u_pe_array.u_fifo2.wr_ptr\[1\] VGND
+ VGND VPWR VPWR _3438_ sky130_fd_sc_hd__or3b_1
X_7892_ clknet_leaf_79_clk _0797_ net13 VGND VGND VPWR VPWR u_pe_array.u_fifo1.rd_ptr\[2\]
+ sky130_fd_sc_hd__dfrtp_4
XFILLER_0_76_124 VGND VGND VPWR VPWR sky130_fd_sc_hd__decap_6
X_6843_ u_pe_array.u_fifo2.wr_ptr\[1\] _3391_ u_pe_array.u_fifo2.wr_ptr\[0\] VGND
+ VGND VPWR VPWR _3399_ sky130_fd_sc_hd__and3b_1
X_3986_ _1181_ _1182_ VGND VGND VPWR VPWR _1190_ sky130_fd_sc_hd__and2_1
X_6774_ _3353_ VGND VGND VPWR VPWR _0723_ sky130_fd_sc_hd__clkbuf_1
X_5725_ u_pe_array.g_pe_row\[1\].g_pe_col\[1\].u_pe.act_val\[2\] VGND VGND VPWR VPWR
+ _2533_ sky130_fd_sc_hd__inv_2
XFILLER_0_57_393 VGND VGND VPWR VPWR sky130_fd_sc_hd__fill_1
XFILLER_0_17_235 VPWR VGND VPWR VGND sky130_ef_sc_hd__decap_12
XFILLER_0_45_533 VGND VGND VPWR VPWR sky130_fd_sc_hd__decap_4
X_5656_ u_pe_array.g_pe_row\[1\].g_pe_col\[1\].u_pe.psum_out\[1\] u_pe_array.g_pe_row\[1\].g_pe_col\[1\].u_pe.act_val\[1\]
+ _2133_ VGND VGND VPWR VPWR _2492_ sky130_fd_sc_hd__mux2_1
XFILLER_0_72_374 VPWR VGND VPWR VGND sky130_ef_sc_hd__decap_12
XFILLER_0_60_503 VGND VGND VPWR VPWR sky130_fd_sc_hd__fill_2
XFILLER_0_17_279 VGND VGND VPWR VPWR sky130_fd_sc_hd__fill_1
XFILLER_0_5_663 VGND VGND VPWR VPWR sky130_fd_sc_hd__decap_8
X_4607_ _1670_ u_pe_array.g_pe_row\[2\].g_pe_col\[3\].u_pe.psum_out\[6\] _1427_ VGND
+ VGND VPWR VPWR _1671_ sky130_fd_sc_hd__nand3_1
Xhold320 u_pe_array.g_pe_row\[3\].g_pe_col\[2\].u_pe.move_reg\[9\] VGND VGND VPWR
+ VPWR net394 sky130_fd_sc_hd__dlygate4sd3_1
X_5587_ u_pe_array.g_pe_row\[1\].g_pe_col\[2\].u_pe.psum_out\[5\] _1597_ VGND VGND
+ VPWR VPWR _2433_ sky130_fd_sc_hd__nand2_1
XFILLER_0_102_137 VGND VGND VPWR VPWR sky130_fd_sc_hd__decap_3
Xhold342 u_pe_array.act_from_down\[1\]\[12\] VGND VGND VPWR VPWR net416 sky130_fd_sc_hd__dlygate4sd3_1
Xhold331 u_pe_array.act_from_down\[9\]\[8\] VGND VGND VPWR VPWR net405 sky130_fd_sc_hd__dlygate4sd3_1
Xhold353 u_pe_array.g_pe_row\[2\].g_pe_col\[0\].u_pe.move_reg\[12\] VGND VGND VPWR
+ VPWR net427 sky130_fd_sc_hd__dlygate4sd3_1
X_7326_ clknet_leaf_17_clk net311 net945 VGND VGND VPWR VPWR u_pe_array.g_pe_row\[2\].g_pe_col\[3\].u_pe.move_reg\[12\]
+ sky130_fd_sc_hd__dfrtp_1
XFILLER_0_4_195 VGND VGND VPWR VPWR sky130_fd_sc_hd__fill_1
X_4538_ u_pe_array.act_from_down\[11\]\[6\] _1310_ _1483_ net285 VGND VGND VPWR VPWR
+ _0226_ sky130_fd_sc_hd__a22o_1
Xhold364 u_pe_array.g_pe_row\[3\].g_pe_col\[3\].u_pe.psum_out\[5\] VGND VGND VPWR
+ VPWR net438 sky130_fd_sc_hd__dlygate4sd3_1
Xhold386 _0626_ VGND VGND VPWR VPWR net460 sky130_fd_sc_hd__dlygate4sd3_1
X_7257_ clknet_leaf_79_clk _0163_ net948 VGND VGND VPWR VPWR net50 sky130_fd_sc_hd__dfrtp_1
Xhold375 u_pe_array.act_from_up\[14\]\[12\] VGND VGND VPWR VPWR net449 sky130_fd_sc_hd__dlygate4sd3_1
X_4469_ u_pe_array.g_pe_row\[3\].g_pe_col\[0\].u_pe.psum_out\[9\] _1287_ VGND VGND
+ VPWR VPWR _1571_ sky130_fd_sc_hd__or2_1
XFILLER_0_110_170 VGND VGND VPWR VPWR sky130_fd_sc_hd__fill_1
X_6208_ _2915_ _2917_ VGND VGND VPWR VPWR _2918_ sky130_fd_sc_hd__xnor2_1
Xhold397 u_pe_array.g_pe_row\[2\].g_pe_col\[3\].u_pe.move_reg\[9\] VGND VGND VPWR
+ VPWR net471 sky130_fd_sc_hd__dlygate4sd3_1
X_7188_ clknet_leaf_8_clk net88 net950 VGND VGND VPWR VPWR u_pe_array.g_pe_row\[3\].g_pe_col\[2\].u_pe.move_reg\[10\]
+ sky130_fd_sc_hd__dfrtp_1
X_6139_ net151 _2730_ _2511_ u_pe_array.g_pe_row\[0\].g_pe_col\[3\].u_pe.move_reg\[8\]
+ VGND VGND VPWR VPWR _0582_ sky130_fd_sc_hd__a22o_1
XTAP_680 VGND VPWR sky130_fd_sc_hd__tapvpwrvgnd_1
XTAP_691 VGND VPWR sky130_fd_sc_hd__tapvpwrvgnd_1
XFILLER_0_68_625 VGND VGND VPWR VPWR sky130_fd_sc_hd__decap_8
XFILLER_0_83_617 VGND VGND VPWR VPWR sky130_fd_sc_hd__fill_1
XFILLER_0_82_105 VGND VGND VPWR VPWR sky130_fd_sc_hd__fill_1
XFILLER_0_67_179 VGND VGND VPWR VPWR sky130_fd_sc_hd__decap_6
XFILLER_0_48_371 VGND VGND VPWR VPWR sky130_fd_sc_hd__fill_1
XFILLER_0_36_522 VGND VGND VPWR VPWR sky130_fd_sc_hd__fill_1
XFILLER_0_36_533 VGND VGND VPWR VPWR sky130_fd_sc_hd__fill_2
XFILLER_0_118_281 VPWR VGND VPWR VGND sky130_ef_sc_hd__decap_12
XFILLER_0_106_410 VGND VGND VPWR VPWR sky130_fd_sc_hd__fill_1
XFILLER_0_63_385 VGND VGND VPWR VPWR sky130_fd_sc_hd__decap_3
XFILLER_0_23_249 VGND VGND VPWR VPWR sky130_fd_sc_hd__decap_6
XFILLER_0_102_693 VGND VGND VPWR VPWR sky130_fd_sc_hd__decap_6
XFILLER_0_59_614 VGND VGND VPWR VPWR sky130_fd_sc_hd__fill_2
XFILLER_0_86_411 VGND VGND VPWR VPWR sky130_fd_sc_hd__decap_8
XFILLER_0_59_636 VGND VGND VPWR VPWR sky130_fd_sc_hd__decap_8
XFILLER_0_59_625 VGND VGND VPWR VPWR sky130_fd_sc_hd__fill_2
XFILLER_0_86_444 VGND VGND VPWR VPWR sky130_fd_sc_hd__decap_3
X_3840_ _1078_ _1088_ _1089_ VGND VGND VPWR VPWR _1090_ sky130_fd_sc_hd__a21oi_1
XFILLER_0_86_477 VGND VGND VPWR VPWR sky130_fd_sc_hd__fill_2
XFILLER_0_73_116 VPWR VGND VPWR VGND sky130_ef_sc_hd__decap_12
XFILLER_0_39_371 VGND VGND VPWR VPWR sky130_fd_sc_hd__fill_1
XFILLER_0_104_77 VGND VGND VPWR VPWR sky130_fd_sc_hd__decap_6
X_3771_ u_pe_array.g_pe_row\[3\].g_pe_col\[3\].u_pe.psum_out\[3\] _1011_ _1012_ VGND
+ VGND VPWR VPWR _1027_ sky130_fd_sc_hd__a21boi_1
XFILLER_0_82_650 VGND VGND VPWR VPWR sky130_fd_sc_hd__decap_8
XFILLER_0_6_427 VGND VGND VPWR VPWR sky130_fd_sc_hd__fill_1
X_5510_ u_pe_array.act_from_up\[6\]\[4\] _2341_ VGND VGND VPWR VPWR _2371_ sky130_fd_sc_hd__or2_1
X_6490_ u_pe_array.g_pe_row\[0\].g_pe_col\[1\].u_pe.psum_out\[1\] _3122_ VGND VGND
+ VPWR VPWR _3123_ sky130_fd_sc_hd__or2_1
XFILLER_0_89_57 VGND VGND VPWR VPWR sky130_fd_sc_hd__decap_8
X_5441_ _2316_ VGND VGND VPWR VPWR _0427_ sky130_fd_sc_hd__clkbuf_1
X_5372_ _2264_ _2265_ VGND VGND VPWR VPWR _2266_ sky130_fd_sc_hd__xnor2_1
X_7111_ clknet_leaf_18_clk _0017_ net945 VGND VGND VPWR VPWR u_pe_array.act_from_down\[11\]\[0\]
+ sky130_fd_sc_hd__dfrtp_1
X_4323_ net868 _1462_ _1116_ VGND VGND VPWR VPWR _1463_ sky130_fd_sc_hd__mux2_1
XFILLER_0_2_699 VGND VGND VPWR VPWR sky130_fd_sc_hd__fill_1
X_7042_ _3516_ VGND VGND VPWR VPWR _0828_ sky130_fd_sc_hd__clkbuf_1
X_4254_ _1407_ _1408_ VGND VGND VPWR VPWR _1409_ sky130_fd_sc_hd__and2_1
X_4185_ _1344_ u_pe_array.g_pe_row\[3\].g_pe_col\[1\].u_pe.psum_out\[4\] _1106_ VGND
+ VGND VPWR VPWR _1346_ sky130_fd_sc_hd__and3_1
X_7944_ clknet_leaf_81_clk _0849_ VGND VGND VPWR VPWR u_pe_array.u_fifo1.buffer\[7\]\[4\]
+ sky130_fd_sc_hd__dfxtp_1
XFILLER_0_89_293 VPWR VGND VPWR VGND sky130_ef_sc_hd__decap_12
XFILLER_0_77_411 VGND VGND VPWR VPWR sky130_fd_sc_hd__decap_3
XTAP_1109 VGND VPWR sky130_fd_sc_hd__tapvpwrvgnd_1
XFILLER_0_54_93 VGND VGND VPWR VPWR sky130_fd_sc_hd__decap_3
X_7875_ clknet_leaf_102_clk _0780_ VGND VGND VPWR VPWR u_pe_array.u_fifo2.buffer\[6\]\[3\]
+ sky130_fd_sc_hd__dfxtp_1
X_6826_ u_pe_array.u_fifo2.count\[3\] _3386_ VGND VGND VPWR VPWR _3389_ sky130_fd_sc_hd__or2_1
X_6757_ u_pe_array.g_pe_row\[0\].g_pe_col\[0\].u_pe.psum_out\[11\] _3246_ VGND VGND
+ VPWR VPWR _3339_ sky130_fd_sc_hd__and2_1
XFILLER_0_70_70 VPWR VGND VPWR VGND sky130_ef_sc_hd__decap_12
X_5708_ _2514_ _2517_ VGND VGND VPWR VPWR _2518_ sky130_fd_sc_hd__xnor2_1
XFILLER_0_73_661 VGND VGND VPWR VPWR sky130_fd_sc_hd__fill_1
XFILLER_0_9_287 VGND VGND VPWR VPWR sky130_fd_sc_hd__fill_1
XFILLER_0_33_503 VGND VGND VPWR VPWR sky130_fd_sc_hd__fill_1
X_3969_ u_pe_array.act_from_up\[14\]\[12\] u_fsm.psum_shift_en _1175_ net261 VGND
+ VGND VPWR VPWR _0096_ sky130_fd_sc_hd__a22o_1
X_6688_ u_pe_array.g_pe_row\[0\].g_pe_col\[0\].u_pe.psum_out\[4\] u_pe_array.g_pe_row\[0\].g_pe_col\[0\].u_pe.act_val\[4\]
+ _2486_ VGND VGND VPWR VPWR _3277_ sky130_fd_sc_hd__and3_1
XFILLER_0_73_683 VGND VGND VPWR VPWR sky130_fd_sc_hd__fill_2
XFILLER_0_115_273 VGND VGND VPWR VPWR sky130_fd_sc_hd__decap_6
X_5639_ u_pe_array.g_pe_row\[1\].g_pe_col\[2\].u_pe.psum_out\[11\] _2479_ _2470_ VGND
+ VGND VPWR VPWR _2480_ sky130_fd_sc_hd__mux2_1
XFILLER_0_103_457 VGND VGND VPWR VPWR sky130_fd_sc_hd__decap_8
XFILLER_0_103_479 VGND VGND VPWR VPWR sky130_fd_sc_hd__decap_4
Xhold161 _0697_ VGND VGND VPWR VPWR net235 sky130_fd_sc_hd__dlygate4sd3_1
Xhold150 u_pe_array.g_pe_row\[1\].g_pe_col\[0\].u_pe.move_reg\[10\] VGND VGND VPWR
+ VPWR net224 sky130_fd_sc_hd__dlygate4sd3_1
XFILLER_0_13_271 VGND VGND VPWR VPWR sky130_fd_sc_hd__decap_8
X_7309_ clknet_leaf_7_clk _0215_ net944 VGND VGND VPWR VPWR u_pe_array.act_from_right\[10\]\[8\]
+ sky130_fd_sc_hd__dfrtp_1
Xhold172 u_pe_array.act_from_right\[0\]\[5\] VGND VGND VPWR VPWR net246 sky130_fd_sc_hd__dlygate4sd3_1
Xhold194 _0580_ VGND VGND VPWR VPWR net268 sky130_fd_sc_hd__dlygate4sd3_1
Xhold183 u_pe_array.act_from_right\[10\]\[3\] VGND VGND VPWR VPWR net257 sky130_fd_sc_hd__dlygate4sd3_1
XTAP_1632 VGND VPWR sky130_fd_sc_hd__tapvpwrvgnd_1
XTAP_1621 VGND VPWR sky130_fd_sc_hd__tapvpwrvgnd_1
XTAP_1610 VGND VPWR sky130_fd_sc_hd__tapvpwrvgnd_1
XFILLER_0_68_433 VGND VGND VPWR VPWR sky130_fd_sc_hd__decap_3
XTAP_1676 VGND VPWR sky130_fd_sc_hd__tapvpwrvgnd_1
XTAP_1654 VGND VPWR sky130_fd_sc_hd__tapvpwrvgnd_1
XTAP_1665 VGND VPWR sky130_fd_sc_hd__tapvpwrvgnd_1
XTAP_1643 VGND VPWR sky130_fd_sc_hd__tapvpwrvgnd_1
XFILLER_0_68_499 VGND VGND VPWR VPWR sky130_fd_sc_hd__decap_3
XFILLER_0_68_477 VGND VGND VPWR VPWR sky130_fd_sc_hd__fill_2
XTAP_1698 VGND VPWR sky130_fd_sc_hd__tapvpwrvgnd_1
XTAP_1687 VGND VPWR sky130_fd_sc_hd__tapvpwrvgnd_1
XFILLER_0_50_29 VGND VGND VPWR VPWR sky130_fd_sc_hd__decap_6
XFILLER_0_83_469 VGND VGND VPWR VPWR sky130_fd_sc_hd__fill_1
XFILLER_0_51_333 VGND VGND VPWR VPWR sky130_fd_sc_hd__decap_3
XFILLER_0_115_21 VPWR VGND VPWR VGND sky130_ef_sc_hd__decap_12
XFILLER_0_99_591 VGND VGND VPWR VPWR sky130_fd_sc_hd__decap_8
XFILLER_0_99_580 VGND VGND VPWR VPWR sky130_fd_sc_hd__decap_4
X_5990_ _2743_ _2744_ VGND VGND VPWR VPWR _2745_ sky130_fd_sc_hd__xnor2_1
X_4941_ _1922_ _1923_ VGND VGND VPWR VPWR _1925_ sky130_fd_sc_hd__and2_1
XFILLER_0_59_444 VGND VGND VPWR VPWR sky130_fd_sc_hd__decap_4
XFILLER_0_59_433 VGND VGND VPWR VPWR sky130_fd_sc_hd__decap_3
X_4872_ net462 _1749_ _1873_ _1877_ VGND VGND VPWR VPWR _0297_ sky130_fd_sc_hd__a22o_1
X_7660_ clknet_leaf_60_clk _0566_ net74 VGND VGND VPWR VPWR u_pe_array.act_from_right\[2\]\[5\]
+ sky130_fd_sc_hd__dfrtp_1
X_6611_ u_pe_array.g_pe_row\[0\].g_pe_col\[0\].u_pe.psum_out\[0\] u_pe_array.g_pe_row\[0\].g_pe_col\[0\].u_pe.act_val\[0\]
+ _3102_ VGND VGND VPWR VPWR _3230_ sky130_fd_sc_hd__mux2_1
X_3823_ _1067_ _1069_ _1074_ VGND VGND VPWR VPWR _1075_ sky130_fd_sc_hd__or3_1
XFILLER_0_46_149 VGND VGND VPWR VPWR sky130_fd_sc_hd__decap_4
X_7591_ clknet_leaf_47_clk _0497_ net73 VGND VGND VPWR VPWR u_pe_array.g_pe_row\[1\].g_pe_col\[1\].u_pe.psum_out\[5\]
+ sky130_fd_sc_hd__dfrtp_2
X_6542_ _3168_ _2268_ u_pe_array.g_pe_row\[0\].g_pe_col\[1\].u_pe.psum_out\[6\] VGND
+ VGND VPWR VPWR _3170_ sky130_fd_sc_hd__a21oi_1
X_3754_ u_pe_array.g_pe_row\[3\].g_pe_col\[3\].u_pe.act_val\[3\] u_pe_array.g_pe_row\[3\].g_pe_col\[3\].u_pe.w_out\[0\]
+ _0988_ _1010_ VGND VGND VPWR VPWR _1011_ sky130_fd_sc_hd__a22o_1
X_6473_ u_pe_array.g_pe_row\[0\].g_pe_col\[1\].u_pe.act_val\[4\] _3101_ _2320_ net253
+ VGND VGND VPWR VPWR _0660_ sky130_fd_sc_hd__a22o_1
X_3685_ u_pe_array.g_pe_row\[3\].g_pe_col\[3\].u_pe.psum_out\[11\] u_pe_array.g_pe_row\[3\].g_pe_col\[3\].u_pe.move_reg\[11\]
+ _0947_ VGND VGND VPWR VPWR _0960_ sky130_fd_sc_hd__mux2_1
XFILLER_0_70_664 VGND VGND VPWR VPWR sky130_fd_sc_hd__fill_2
XFILLER_0_15_558 VGND VGND VPWR VPWR sky130_fd_sc_hd__fill_2
XFILLER_0_112_221 VGND VGND VPWR VPWR sky130_fd_sc_hd__fill_1
X_5424_ u_pe_array.g_pe_row\[1\].g_pe_col\[2\].u_pe.move_reg\[10\] net62 VGND VGND
+ VPWR VPWR _2305_ sky130_fd_sc_hd__or2_1
XFILLER_0_30_528 VGND VGND VPWR VPWR sky130_fd_sc_hd__decap_4
XFILLER_0_112_287 VPWR VGND VPWR VGND sky130_ef_sc_hd__decap_12
XFILLER_0_100_438 VGND VGND VPWR VPWR sky130_fd_sc_hd__fill_2
X_5355_ u_pe_array.g_pe_row\[1\].g_pe_col\[3\].u_pe.psum_out\[10\] _1426_ VGND VGND
+ VPWR VPWR _2251_ sky130_fd_sc_hd__nand2_1
XFILLER_0_57_3 VGND VGND VPWR VPWR sky130_fd_sc_hd__decap_3
X_5286_ _2176_ net941 _2186_ _2187_ VGND VGND VPWR VPWR _2189_ sky130_fd_sc_hd__o211a_1
X_4306_ u_pe_array.g_pe_row\[3\].g_pe_col\[0\].u_pe.psum_out\[6\] _1108_ _1110_ _1449_
+ VGND VGND VPWR VPWR _1450_ sky130_fd_sc_hd__o211a_2
XFILLER_0_10_296 VGND VGND VPWR VPWR sky130_fd_sc_hd__decap_4
X_4237_ _1392_ _1393_ VGND VGND VPWR VPWR _1394_ sky130_fd_sc_hd__nand2_1
X_7025_ net610 _3347_ _3506_ VGND VGND VPWR VPWR _3507_ sky130_fd_sc_hd__mux2_1
XFILLER_0_97_517 VPWR VGND VPWR VGND sky130_ef_sc_hd__decap_12
X_4168_ u_pe_array.g_pe_row\[3\].g_pe_col\[1\].u_pe.act_val\[3\] u_pe_array.g_pe_row\[3\].g_pe_col\[1\].u_pe.w_out\[0\]
+ VGND VGND VPWR VPWR _1330_ sky130_fd_sc_hd__nand2_1
X_4099_ net340 _1167_ _1169_ _1289_ VGND VGND VPWR VPWR _0112_ sky130_fd_sc_hd__a22o_1
XFILLER_0_69_219 VGND VGND VPWR VPWR sky130_fd_sc_hd__decap_4
X_7927_ clknet_leaf_76_clk _0832_ VGND VGND VPWR VPWR u_pe_array.u_fifo1.buffer\[4\]\[5\]
+ sky130_fd_sc_hd__dfxtp_1
X_7858_ clknet_leaf_101_clk _0763_ VGND VGND VPWR VPWR u_pe_array.u_fifo2.buffer\[3\]\[4\]
+ sky130_fd_sc_hd__dfxtp_1
XFILLER_0_92_222 VGND VGND VPWR VPWR sky130_fd_sc_hd__fill_2
X_6809_ u_pe_array.u_fifo2.rd_ptr\[2\] _3374_ VGND VGND VPWR VPWR _3377_ sky130_fd_sc_hd__nor2_1
XFILLER_0_80_417 VGND VGND VPWR VPWR sky130_fd_sc_hd__decap_3
X_7789_ clknet_leaf_65_clk _0695_ net946 VGND VGND VPWR VPWR u_pe_array.act_from_up\[4\]\[11\]
+ sky130_fd_sc_hd__dfrtp_1
XFILLER_0_60_141 VGND VGND VPWR VPWR sky130_fd_sc_hd__decap_4
XFILLER_0_60_185 VGND VGND VPWR VPWR sky130_fd_sc_hd__decap_6
XFILLER_0_103_298 VPWR VGND VPWR VGND sky130_ef_sc_hd__decap_12
XFILLER_0_88_528 VGND VGND VPWR VPWR sky130_fd_sc_hd__decap_4
XTAP_1451 VGND VPWR sky130_fd_sc_hd__tapvpwrvgnd_1
XTAP_1440 VGND VPWR sky130_fd_sc_hd__tapvpwrvgnd_1
XFILLER_0_84_701 VGND VGND VPWR VPWR sky130_fd_sc_hd__decap_4
XTAP_1484 VGND VPWR sky130_fd_sc_hd__tapvpwrvgnd_1
XTAP_1473 VGND VPWR sky130_fd_sc_hd__tapvpwrvgnd_1
XTAP_1462 VGND VPWR sky130_fd_sc_hd__tapvpwrvgnd_1
XFILLER_0_28_138 VGND VGND VPWR VPWR sky130_fd_sc_hd__fill_2
XTAP_1495 VGND VPWR sky130_fd_sc_hd__tapvpwrvgnd_1
XFILLER_0_71_406 VPWR VGND VPWR VGND sky130_ef_sc_hd__decap_12
XFILLER_0_83_299 VGND VGND VPWR VPWR sky130_fd_sc_hd__decap_6
XFILLER_0_52_653 VGND VGND VPWR VPWR sky130_fd_sc_hd__fill_1
XFILLER_0_3_205 VPWR VGND VPWR VGND sky130_ef_sc_hd__decap_12
XFILLER_0_3_249 VGND VGND VPWR VPWR sky130_fd_sc_hd__decap_6
XFILLER_0_10_65 VPWR VGND VPWR VGND sky130_ef_sc_hd__decap_12
X_5140_ _2080_ _2070_ _2068_ VGND VGND VPWR VPWR _2081_ sky130_fd_sc_hd__a21oi_1
X_5071_ u_pe_array.g_pe_row\[2\].g_pe_col\[0\].u_pe.psum_out\[0\] u_pe_array.g_pe_row\[2\].g_pe_col\[0\].u_pe.act_val\[0\]
+ _1284_ VGND VGND VPWR VPWR _2018_ sky130_fd_sc_hd__nand3_1
X_4022_ _1208_ _1218_ _1222_ VGND VGND VPWR VPWR _1223_ sky130_fd_sc_hd__o21a_1
X_5973_ u_pe_array.act_from_up\[4\]\[12\] _2730_ _2511_ net303 VGND VGND VPWR VPWR
+ _0545_ sky130_fd_sc_hd__a22o_1
X_4924_ _1907_ u_pe_array.g_pe_row\[2\].g_pe_col\[1\].u_pe.act_val\[3\] u_pe_array.g_pe_row\[2\].g_pe_col\[1\].u_pe.w_out\[0\]
+ _1105_ VGND VGND VPWR VPWR _1909_ sky130_fd_sc_hd__nand4_1
XFILLER_0_87_561 VPWR VGND VPWR VGND sky130_ef_sc_hd__decap_12
X_7712_ clknet_leaf_60_clk net345 net72 VGND VGND VPWR VPWR u_pe_array.g_pe_row\[0\].g_pe_col\[2\].u_pe.act_val\[3\]
+ sky130_fd_sc_hd__dfrtp_4
XFILLER_0_87_594 VPWR VGND VPWR VGND sky130_ef_sc_hd__decap_12
XFILLER_0_117_324 VPWR VGND VPWR VGND sky130_ef_sc_hd__decap_12
X_4855_ net97 _1749_ _1611_ _1868_ VGND VGND VPWR VPWR _0289_ sky130_fd_sc_hd__a22o_1
X_7643_ clknet_leaf_72_clk _0549_ net949 VGND VGND VPWR VPWR u_pe_array.g_pe_row\[1\].g_pe_col\[0\].u_pe.psum_out\[3\]
+ sky130_fd_sc_hd__dfrtp_1
XFILLER_0_117_357 VGND VGND VPWR VPWR sky130_fd_sc_hd__decap_3
X_7574_ clknet_leaf_44_clk _0480_ net947 VGND VGND VPWR VPWR u_pe_array.g_pe_row\[1\].g_pe_col\[1\].u_pe.act_val\[1\]
+ sky130_fd_sc_hd__dfrtp_1
X_3806_ u_pe_array.g_pe_row\[3\].g_pe_col\[3\].u_pe.psum_out\[7\] _0988_ VGND VGND
+ VPWR VPWR _1059_ sky130_fd_sc_hd__nand2_1
X_4786_ u_pe_array.g_pe_row\[2\].g_pe_col\[2\].u_pe.psum_out\[5\] _1796_ _1808_ VGND
+ VGND VPWR VPWR _1809_ sky130_fd_sc_hd__a21oi_1
XFILLER_0_34_119 VGND VGND VPWR VPWR sky130_fd_sc_hd__fill_2
X_6525_ _3152_ _3153_ VGND VGND VPWR VPWR _3155_ sky130_fd_sc_hd__and2_1
X_3737_ u_pe_array.g_pe_row\[3\].g_pe_col\[3\].u_pe.psum_out\[1\] _0991_ _0994_ VGND
+ VGND VPWR VPWR _0995_ sky130_fd_sc_hd__a21bo_1
XFILLER_0_42_141 VGND VGND VPWR VPWR sky130_fd_sc_hd__decap_4
X_6456_ net368 _3101_ _2987_ _3109_ VGND VGND VPWR VPWR _0649_ sky130_fd_sc_hd__a22o_1
X_3668_ net162 _0949_ _0944_ _0951_ VGND VGND VPWR VPWR _0019_ sky130_fd_sc_hd__a22o_1
XFILLER_0_100_224 VPWR VGND VPWR VGND sky130_ef_sc_hd__decap_12
X_6387_ u_pe_array.g_pe_row\[0\].g_pe_col\[2\].u_pe.psum_out\[7\] VGND VGND VPWR VPWR
+ _3055_ sky130_fd_sc_hd__inv_2
X_3599_ u_fsm.next_state\[0\] u_fsm.next_state\[1\] VGND VGND VPWR VPWR _0898_ sky130_fd_sc_hd__nand2_1
X_5407_ _2292_ VGND VGND VPWR VPWR _0417_ sky130_fd_sc_hd__clkbuf_1
X_5338_ _2222_ _2234_ _2235_ VGND VGND VPWR VPWR _2236_ sky130_fd_sc_hd__o21ai_2
X_5269_ _1884_ _2169_ _2172_ _2173_ net577 VGND VGND VPWR VPWR _0398_ sky130_fd_sc_hd__a32o_1
X_7008_ net707 _3362_ _3491_ VGND VGND VPWR VPWR _3497_ sky130_fd_sc_hd__mux2_1
XFILLER_0_85_509 VGND VGND VPWR VPWR sky130_fd_sc_hd__fill_1
XFILLER_0_78_550 VGND VGND VPWR VPWR sky130_fd_sc_hd__decap_4
XFILLER_0_38_403 VGND VGND VPWR VPWR sky130_fd_sc_hd__fill_2
XFILLER_0_93_564 VPWR VGND VPWR VGND sky130_ef_sc_hd__decap_12
XFILLER_0_65_266 VGND VGND VPWR VPWR sky130_fd_sc_hd__fill_1
XFILLER_0_25_108 VGND VGND VPWR VPWR sky130_fd_sc_hd__decap_4
XFILLER_0_18_193 VGND VGND VPWR VPWR sky130_fd_sc_hd__decap_3
XFILLER_0_34_653 VPWR VGND VPWR VGND sky130_ef_sc_hd__decap_12
XFILLER_0_33_163 VGND VGND VPWR VPWR sky130_fd_sc_hd__decap_4
XFILLER_0_34_697 VGND VGND VPWR VPWR sky130_fd_sc_hd__decap_3
XTAP_509 VGND VPWR sky130_fd_sc_hd__tapvpwrvgnd_1
XFILLER_0_88_303 VGND VGND VPWR VPWR sky130_fd_sc_hd__decap_4
Xload_slew10 net72 VGND VGND VPWR VPWR net949 sky130_fd_sc_hd__buf_12
XFILLER_0_72_27 VGND VGND VPWR VPWR sky130_fd_sc_hd__fill_1
XFILLER_0_84_520 VGND VGND VPWR VPWR sky130_fd_sc_hd__fill_1
XFILLER_0_29_425 VGND VGND VPWR VPWR sky130_fd_sc_hd__decap_3
XTAP_1292 VGND VPWR sky130_fd_sc_hd__tapvpwrvgnd_1
XTAP_1281 VGND VPWR sky130_fd_sc_hd__tapvpwrvgnd_1
XTAP_1270 VGND VPWR sky130_fd_sc_hd__tapvpwrvgnd_1
XFILLER_0_56_266 VPWR VGND VPWR VGND sky130_ef_sc_hd__decap_12
XFILLER_0_84_586 VGND VGND VPWR VPWR sky130_fd_sc_hd__fill_2
XFILLER_0_71_225 VGND VGND VPWR VPWR sky130_fd_sc_hd__decap_4
X_4640_ _1700_ _1701_ u_pe_array.g_pe_row\[2\].g_pe_col\[3\].u_pe.psum_out\[8\] _1006_
+ VGND VGND VPWR VPWR _0241_ sky130_fd_sc_hd__a2bb2o_1
XFILLER_0_115_3 VGND VGND VPWR VPWR sky130_fd_sc_hd__decap_3
XFILLER_0_112_77 VGND VGND VPWR VPWR sky130_fd_sc_hd__decap_6
X_6310_ net407 _2730_ _0940_ u_pe_array.g_pe_row\[0\].g_pe_col\[2\].u_pe.move_reg\[10\]
+ VGND VGND VPWR VPWR _0625_ sky130_fd_sc_hd__a22o_1
XFILLER_0_24_141 VGND VGND VPWR VPWR sky130_fd_sc_hd__decap_3
X_4571_ _1636_ _1637_ VGND VGND VPWR VPWR _1638_ sky130_fd_sc_hd__nor2_1
Xhold705 net53 VGND VGND VPWR VPWR net779 sky130_fd_sc_hd__dlygate4sd3_1
Xhold716 u_pe_array.g_pe_row\[1\].g_pe_col\[3\].u_pe.act_val\[0\] VGND VGND VPWR VPWR
+ net790 sky130_fd_sc_hd__dlygate4sd3_1
Xhold727 u_pe_array.g_pe_row\[1\].g_pe_col\[3\].u_pe.act_val\[3\] VGND VGND VPWR VPWR
+ net801 sky130_fd_sc_hd__dlygate4sd3_1
XFILLER_0_4_569 VGND VGND VPWR VPWR sky130_fd_sc_hd__decap_8
X_7290_ clknet_leaf_9_clk _0196_ net950 VGND VGND VPWR VPWR u_pe_array.g_pe_row\[3\].g_pe_col\[0\].u_pe.psum_out\[4\]
+ sky130_fd_sc_hd__dfrtp_2
XFILLER_0_97_57 VPWR VGND VPWR VGND sky130_ef_sc_hd__decap_12
X_6241_ u_pe_array.g_pe_row\[0\].g_pe_col\[3\].u_pe.psum_out\[9\] _1999_ VGND VGND
+ VPWR VPWR _2948_ sky130_fd_sc_hd__or2_1
Xhold749 u_pe_array.u_fifo1.rd_ptr\[1\] VGND VGND VPWR VPWR net823 sky130_fd_sc_hd__dlygate4sd3_1
Xhold738 u_pe_array.g_pe_row\[1\].g_pe_col\[0\].u_pe.act_val\[2\] VGND VGND VPWR VPWR
+ net812 sky130_fd_sc_hd__dlygate4sd3_1
X_6172_ u_pe_array.g_pe_row\[0\].g_pe_col\[3\].u_pe.psum_out\[3\] _2884_ VGND VGND
+ VPWR VPWR _2885_ sky130_fd_sc_hd__xor2_1
X_5123_ u_pe_array.g_pe_row\[2\].g_pe_col\[0\].u_pe.psum_out\[5\] _2064_ VGND VGND
+ VPWR VPWR _2065_ sky130_fd_sc_hd__xnor2_1
X_5054_ u_pe_array.g_pe_row\[2\].g_pe_col\[0\].u_pe.psum_out\[12\] net427 _1867_ VGND
+ VGND VPWR VPWR _2015_ sky130_fd_sc_hd__mux2_1
X_4005_ _1126_ _0934_ u_pe_array.g_pe_row\[3\].g_pe_col\[2\].u_pe.psum_out\[4\] VGND
+ VGND VPWR VPWR _1207_ sky130_fd_sc_hd__a21oi_1
XFILLER_0_94_306 VGND VGND VPWR VPWR sky130_fd_sc_hd__fill_2
X_5956_ u_pe_array.act_from_up\[4\]\[4\] _2341_ VGND VGND VPWR VPWR _2722_ sky130_fd_sc_hd__or2_1
X_4907_ _1884_ _1892_ _1893_ _1803_ net690 VGND VGND VPWR VPWR _0316_ sky130_fd_sc_hd__a32o_1
XFILLER_0_63_704 VGND VGND VPWR VPWR sky130_fd_sc_hd__fill_1
X_5887_ _2669_ VGND VGND VPWR VPWR _0520_ sky130_fd_sc_hd__clkbuf_1
XFILLER_0_62_214 VPWR VGND VPWR VGND sky130_ef_sc_hd__decap_12
X_7626_ clknet_leaf_66_clk _0532_ net946 VGND VGND VPWR VPWR u_pe_array.act_from_left\[5\]\[12\]
+ sky130_fd_sc_hd__dfrtp_1
X_4838_ _1854_ _1855_ VGND VGND VPWR VPWR _1856_ sky130_fd_sc_hd__or2_1
XFILLER_0_35_417 VGND VGND VPWR VPWR sky130_fd_sc_hd__decap_4
XFILLER_0_35_428 VPWR VGND VPWR VGND sky130_ef_sc_hd__decap_12
XFILLER_0_47_299 VGND VGND VPWR VPWR sky130_fd_sc_hd__fill_1
XFILLER_0_90_545 VGND VGND VPWR VPWR sky130_fd_sc_hd__decap_8
X_7557_ clknet_leaf_68_clk _0463_ net72 VGND VGND VPWR VPWR u_pe_array.g_pe_row\[1\].g_pe_col\[2\].u_pe.psum_out\[12\]
+ sky130_fd_sc_hd__dfrtp_1
X_4769_ _1792_ _1793_ net636 _1006_ VGND VGND VPWR VPWR _0278_ sky130_fd_sc_hd__a2bb2o_1
X_6508_ _3137_ u_pe_array.g_pe_row\[0\].g_pe_col\[1\].u_pe.act_val\[3\] u_pe_array.g_pe_row\[0\].g_pe_col\[1\].u_pe.w_out\[0\]
+ _2268_ VGND VGND VPWR VPWR _3139_ sky130_fd_sc_hd__nand4_1
X_7488_ clknet_leaf_41_clk _0394_ net946 VGND VGND VPWR VPWR u_pe_array.g_pe_row\[1\].g_pe_col\[3\].u_pe.move_reg\[10\]
+ sky130_fd_sc_hd__dfrtp_1
XFILLER_0_16_697 VGND VGND VPWR VPWR sky130_fd_sc_hd__decap_3
XFILLER_0_31_623 VGND VGND VPWR VPWR sky130_fd_sc_hd__fill_1
X_6439_ net28 _2488_ _0930_ VGND VGND VPWR VPWR _3100_ sky130_fd_sc_hd__mux2_1
XFILLER_0_30_144 VGND VGND VPWR VPWR sky130_fd_sc_hd__fill_1
XFILLER_0_11_391 VGND VGND VPWR VPWR sky130_fd_sc_hd__fill_1
Xhold32 u_pe_array.act_from_down\[1\]\[7\] VGND VGND VPWR VPWR net106 sky130_fd_sc_hd__dlygate4sd3_1
Xhold10 _0485_ VGND VGND VPWR VPWR net84 sky130_fd_sc_hd__dlygate4sd3_1
Xhold21 u_pe_array.act_from_right\[5\]\[10\] VGND VGND VPWR VPWR net95 sky130_fd_sc_hd__dlygate4sd3_1
Xhold54 u_pe_array.act_from_right\[0\]\[8\] VGND VGND VPWR VPWR net128 sky130_fd_sc_hd__dlygate4sd3_1
Xhold43 u_pe_array.act_from_right\[0\]\[10\] VGND VGND VPWR VPWR net117 sky130_fd_sc_hd__dlygate4sd3_1
Xhold65 u_pe_array.act_from_left\[15\]\[10\] VGND VGND VPWR VPWR net139 sky130_fd_sc_hd__dlygate4sd3_1
XFILLER_0_97_100 VGND VGND VPWR VPWR sky130_fd_sc_hd__fill_1
Xhold98 _0575_ VGND VGND VPWR VPWR net172 sky130_fd_sc_hd__dlygate4sd3_1
Xhold87 u_pe_array.act_from_left\[7\]\[9\] VGND VGND VPWR VPWR net161 sky130_fd_sc_hd__dlygate4sd3_1
Xhold76 u_pe_array.act_from_left\[7\]\[6\] VGND VGND VPWR VPWR net150 sky130_fd_sc_hd__dlygate4sd3_1
XFILLER_0_97_122 VGND VGND VPWR VPWR sky130_fd_sc_hd__decap_8
XFILLER_0_39_701 VGND VGND VPWR VPWR sky130_fd_sc_hd__decap_4
XFILLER_0_108_121 VGND VGND VPWR VPWR sky130_fd_sc_hd__decap_4
XFILLER_0_93_372 VPWR VGND VPWR VGND sky130_ef_sc_hd__decap_12
XFILLER_0_1_517 VPWR VGND VPWR VGND sky130_ef_sc_hd__decap_12
XANTENNA_7 net9 VGND VGND VPWR VPWR sky130_fd_sc_hd__diode_2
XTAP_306 VGND VPWR sky130_fd_sc_hd__tapvpwrvgnd_1
XTAP_328 VGND VPWR sky130_fd_sc_hd__tapvpwrvgnd_1
XTAP_339 VGND VPWR sky130_fd_sc_hd__tapvpwrvgnd_1
XTAP_317 VGND VPWR sky130_fd_sc_hd__tapvpwrvgnd_1
XFILLER_0_83_15 VGND VGND VPWR VPWR sky130_fd_sc_hd__decap_4
XFILLER_0_107_55 VGND VGND VPWR VPWR sky130_fd_sc_hd__fill_1
XFILLER_0_16_53 VPWR VGND VPWR VGND sky130_ef_sc_hd__decap_12
XFILLER_0_88_166 VGND VGND VPWR VPWR sky130_fd_sc_hd__fill_1
XFILLER_0_16_75 VGND VGND VPWR VPWR sky130_fd_sc_hd__decap_4
X_5810_ u_pe_array.g_pe_row\[1\].g_pe_col\[1\].u_pe.psum_out\[10\] _2600_ VGND VGND
+ VPWR VPWR _2611_ sky130_fd_sc_hd__nor2_1
X_6790_ u_pe_array.u_fifo2.wr_ptr\[0\] _0914_ _0917_ VGND VGND VPWR VPWR _3364_ sky130_fd_sc_hd__o21ai_1
XFILLER_0_9_617 VGND VGND VPWR VPWR sky130_fd_sc_hd__decap_4
X_5741_ u_pe_array.g_pe_row\[1\].g_pe_col\[1\].u_pe.psum_out\[4\] _2547_ VGND VGND
+ VPWR VPWR _2548_ sky130_fd_sc_hd__xnor2_1
XFILLER_0_45_704 VGND VGND VPWR VPWR sky130_fd_sc_hd__fill_1
XFILLER_0_84_372 VPWR VGND VPWR VGND sky130_ef_sc_hd__decap_12
X_7411_ clknet_leaf_27_clk _0317_ net943 VGND VGND VPWR VPWR u_pe_array.g_pe_row\[2\].g_pe_col\[1\].u_pe.psum_out\[2\]
+ sky130_fd_sc_hd__dfrtp_1
X_5672_ net366 _2499_ _2491_ _2500_ VGND VGND VPWR VPWR _0474_ sky130_fd_sc_hd__a22o_1
XFILLER_0_32_85 VGND VGND VPWR VPWR sky130_fd_sc_hd__decap_6
XFILLER_0_72_589 VGND VGND VPWR VPWR sky130_fd_sc_hd__decap_4
X_4623_ _1685_ VGND VGND VPWR VPWR _1686_ sky130_fd_sc_hd__inv_2
XFILLER_0_44_258 VGND VGND VPWR VPWR sky130_fd_sc_hd__fill_1
Xhold502 u_pe_array.u_fifo1.buffer\[6\]\[2\] VGND VGND VPWR VPWR net576 sky130_fd_sc_hd__dlygate4sd3_1
X_7342_ clknet_leaf_104_clk _0248_ net944 VGND VGND VPWR VPWR u_pe_array.act_from_up\[14\]\[0\]
+ sky130_fd_sc_hd__dfrtp_2
X_4554_ _1487_ _1621_ _1622_ _1356_ net352 VGND VGND VPWR VPWR _0234_ sky130_fd_sc_hd__a32o_1
X_7273_ clknet_leaf_17_clk _0179_ net943 VGND VGND VPWR VPWR u_pe_array.g_pe_row\[3\].g_pe_col\[0\].u_pe.act_val\[0\]
+ sky130_fd_sc_hd__dfrtp_2
Xhold535 u_fsm.h_cnt\[1\] VGND VGND VPWR VPWR net609 sky130_fd_sc_hd__dlygate4sd3_1
Xhold513 u_pe_array.u_fifo1.buffer\[5\]\[3\] VGND VGND VPWR VPWR net587 sky130_fd_sc_hd__dlygate4sd3_1
Xhold524 u_pe_array.g_pe_row\[1\].g_pe_col\[0\].u_pe.act_val\[1\] VGND VGND VPWR VPWR
+ net598 sky130_fd_sc_hd__dlygate4sd3_1
XFILLER_0_40_431 VGND VGND VPWR VPWR sky130_fd_sc_hd__fill_2
X_6224_ _2927_ _2931_ VGND VGND VPWR VPWR _2933_ sky130_fd_sc_hd__nand2_1
Xhold557 u_pe_array.g_pe_row\[3\].g_pe_col\[1\].u_pe.psum_out\[12\] VGND VGND VPWR
+ VPWR net631 sky130_fd_sc_hd__dlygate4sd3_1
Xhold568 _1308_ VGND VGND VPWR VPWR net642 sky130_fd_sc_hd__dlygate4sd3_1
Xhold579 u_pe_array.u_fifo2.buffer\[1\]\[1\] VGND VGND VPWR VPWR net653 sky130_fd_sc_hd__dlygate4sd3_1
X_4485_ u_pe_array.g_pe_row\[3\].g_pe_col\[0\].u_pe.psum_out\[11\] _1287_ VGND VGND
+ VPWR VPWR _1585_ sky130_fd_sc_hd__and2b_1
Xhold546 u_pe_array.g_pe_row\[2\].g_pe_col\[3\].u_pe.psum_out\[12\] VGND VGND VPWR
+ VPWR net620 sky130_fd_sc_hd__dlygate4sd3_1
XFILLER_0_0_561 VPWR VGND VPWR VGND sky130_ef_sc_hd__decap_12
X_6155_ _2861_ _2865_ VGND VGND VPWR VPWR _2869_ sky130_fd_sc_hd__nand2_1
XTAP_840 VGND VPWR sky130_fd_sc_hd__tapvpwrvgnd_1
XTAP_851 VGND VPWR sky130_fd_sc_hd__tapvpwrvgnd_1
XTAP_862 VGND VPWR sky130_fd_sc_hd__tapvpwrvgnd_1
X_5106_ u_pe_array.g_pe_row\[2\].g_pe_col\[0\].u_pe.act_val\[4\] _1284_ VGND VGND
+ VPWR VPWR _2049_ sky130_fd_sc_hd__nand2_1
X_6086_ u_pe_array.g_pe_row\[1\].g_pe_col\[0\].u_pe.psum_out\[11\] _1865_ VGND VGND
+ VPWR VPWR _2832_ sky130_fd_sc_hd__and2b_1
XTAP_873 VGND VPWR sky130_fd_sc_hd__tapvpwrvgnd_1
XTAP_884 VGND VPWR sky130_fd_sc_hd__tapvpwrvgnd_1
XTAP_895 VGND VPWR sky130_fd_sc_hd__tapvpwrvgnd_1
X_5037_ net501 _1732_ _1735_ _2005_ VGND VGND VPWR VPWR _0334_ sky130_fd_sc_hd__a22o_1
XFILLER_0_79_166 VGND VGND VPWR VPWR sky130_fd_sc_hd__fill_2
XFILLER_0_73_81 VGND VGND VPWR VPWR sky130_fd_sc_hd__fill_1
XFILLER_0_48_520 VGND VGND VPWR VPWR sky130_fd_sc_hd__fill_1
X_6988_ _3486_ VGND VGND VPWR VPWR _0804_ sky130_fd_sc_hd__clkbuf_1
XFILLER_0_48_531 VGND VGND VPWR VPWR sky130_fd_sc_hd__fill_1
X_5939_ u_pe_array.u_fifo1.buffer\[8\]\[2\] _2676_ _2702_ _2706_ _0857_ VGND VGND
+ VPWR VPWR _2707_ sky130_fd_sc_hd__a221o_1
XFILLER_0_105_113 VPWR VGND VPWR VGND sky130_ef_sc_hd__decap_12
XFILLER_0_7_193 VPWR VGND VPWR VGND sky130_ef_sc_hd__decap_12
X_7609_ clknet_leaf_84_clk _0515_ net948 VGND VGND VPWR VPWR net47 sky130_fd_sc_hd__dfrtp_1
XFILLER_0_106_669 VPWR VGND VPWR VGND sky130_ef_sc_hd__decap_12
XFILLER_0_105_157 VGND VGND VPWR VPWR sky130_fd_sc_hd__decap_8
XFILLER_0_101_374 VPWR VGND VPWR VGND sky130_ef_sc_hd__decap_12
XFILLER_0_9_3 VPWR VGND VPWR VGND sky130_ef_sc_hd__decap_12
Xoutput44 net44 VGND VGND VPWR VPWR psum_out0[5] sky130_fd_sc_hd__clkbuf_4
Xoutput55 net55 VGND VGND VPWR VPWR psum_out1[3] sky130_fd_sc_hd__clkbuf_4
XFILLER_0_53_18 VPWR VGND VPWR VGND sky130_ef_sc_hd__decap_12
XPHY_161 VGND VGND VPWR VPWR sky130_fd_sc_hd__decap_3
XPHY_150 VGND VGND VPWR VPWR sky130_fd_sc_hd__decap_3
XFILLER_0_54_512 VGND VGND VPWR VPWR sky130_fd_sc_hd__decap_4
XFILLER_0_27_704 VGND VGND VPWR VPWR sky130_fd_sc_hd__fill_1
XPHY_194 VGND VGND VPWR VPWR sky130_fd_sc_hd__decap_3
XPHY_183 VGND VGND VPWR VPWR sky130_fd_sc_hd__decap_3
XPHY_172 VGND VGND VPWR VPWR sky130_fd_sc_hd__decap_3
XFILLER_0_54_589 VPWR VGND VPWR VGND sky130_ef_sc_hd__decap_12
XFILLER_0_111_105 VGND VGND VPWR VPWR sky130_fd_sc_hd__decap_6
XFILLER_0_78_37 VGND VGND VPWR VPWR sky130_fd_sc_hd__fill_1
XFILLER_0_10_604 VGND VGND VPWR VPWR sky130_fd_sc_hd__fill_2
X_4270_ net631 _1273_ _1422_ _1021_ VGND VGND VPWR VPWR _0150_ sky130_fd_sc_hd__a22o_1
XFILLER_0_118_21 VGND VGND VPWR VPWR sky130_fd_sc_hd__decap_6
XFILLER_0_118_65 VGND VGND VPWR VPWR sky130_fd_sc_hd__fill_1
XFILLER_0_27_52 VGND VGND VPWR VPWR sky130_fd_sc_hd__decap_4
XFILLER_0_77_615 VGND VGND VPWR VPWR sky130_fd_sc_hd__fill_1
X_7891_ clknet_leaf_79_clk _0796_ net13 VGND VGND VPWR VPWR u_pe_array.u_fifo1.rd_ptr\[1\]
+ sky130_fd_sc_hd__dfrtp_2
X_6911_ _3437_ VGND VGND VPWR VPWR _0776_ sky130_fd_sc_hd__clkbuf_1
XFILLER_0_77_648 VGND VGND VPWR VPWR sky130_fd_sc_hd__decap_3
X_6842_ _3398_ VGND VGND VPWR VPWR _0746_ sky130_fd_sc_hd__clkbuf_1
XFILLER_0_85_681 VPWR VGND VPWR VGND sky130_ef_sc_hd__decap_12
XFILLER_0_64_309 VGND VGND VPWR VPWR sky130_fd_sc_hd__fill_2
X_3985_ _1187_ _1188_ VGND VGND VPWR VPWR _1189_ sky130_fd_sc_hd__xnor2_1
X_6773_ _3347_ net771 _3352_ VGND VGND VPWR VPWR _3353_ sky130_fd_sc_hd__mux2_1
X_5724_ _2522_ _2528_ _2531_ VGND VGND VPWR VPWR _2532_ sky130_fd_sc_hd__a21o_1
XFILLER_0_91_128 VGND VGND VPWR VPWR sky130_fd_sc_hd__decap_4
XFILLER_0_17_247 VPWR VGND VPWR VGND sky130_ef_sc_hd__decap_12
X_5655_ _0943_ VGND VGND VPWR VPWR _2491_ sky130_fd_sc_hd__buf_6
XFILLER_0_72_386 VGND VGND VPWR VPWR sky130_fd_sc_hd__fill_1
XFILLER_0_4_141 VPWR VGND VPWR VGND sky130_ef_sc_hd__decap_12
X_4606_ u_pe_array.g_pe_row\[2\].g_pe_col\[3\].u_pe.act_val\[5\] VGND VGND VPWR VPWR
+ _1670_ sky130_fd_sc_hd__inv_2
XFILLER_0_103_639 VPWR VGND VPWR VGND sky130_ef_sc_hd__decap_12
Xhold310 _0348_ VGND VGND VPWR VPWR net384 sky130_fd_sc_hd__dlygate4sd3_1
X_7325_ clknet_leaf_18_clk _0231_ net943 VGND VGND VPWR VPWR u_pe_array.g_pe_row\[2\].g_pe_col\[3\].u_pe.move_reg\[11\]
+ sky130_fd_sc_hd__dfrtp_1
XFILLER_0_5_686 VGND VGND VPWR VPWR sky130_fd_sc_hd__fill_2
XFILLER_0_25_291 VGND VGND VPWR VPWR sky130_fd_sc_hd__decap_4
X_5586_ _2289_ _1597_ u_pe_array.g_pe_row\[1\].g_pe_col\[2\].u_pe.psum_out\[6\] VGND
+ VGND VPWR VPWR _2432_ sky130_fd_sc_hd__a21o_1
Xhold343 u_pe_array.g_pe_row\[0\].g_pe_col\[1\].u_pe.psum_out\[3\] VGND VGND VPWR
+ VPWR net417 sky130_fd_sc_hd__dlygate4sd3_1
Xhold332 _0120_ VGND VGND VPWR VPWR net406 sky130_fd_sc_hd__dlygate4sd3_1
XFILLER_0_7_51 VGND VGND VPWR VPWR sky130_fd_sc_hd__decap_4
Xhold321 _0093_ VGND VGND VPWR VPWR net395 sky130_fd_sc_hd__dlygate4sd3_1
X_4537_ u_pe_array.g_pe_row\[2\].g_pe_col\[3\].u_pe.act_val\[5\] _1605_ _1611_ net155
+ VGND VGND VPWR VPWR _0225_ sky130_fd_sc_hd__a22o_1
X_7256_ clknet_leaf_47_clk _0162_ net73 VGND VGND VPWR VPWR net61 sky130_fd_sc_hd__dfrtp_1
Xhold387 u_pe_array.g_pe_row\[3\].g_pe_col\[1\].u_pe.psum_out\[3\] VGND VGND VPWR
+ VPWR net461 sky130_fd_sc_hd__dlygate4sd3_1
Xhold365 u_pe_array.act_from_down\[11\]\[11\] VGND VGND VPWR VPWR net439 sky130_fd_sc_hd__dlygate4sd3_1
Xhold376 _0260_ VGND VGND VPWR VPWR net450 sky130_fd_sc_hd__dlygate4sd3_1
Xhold354 u_pe_array.act_from_up\[4\]\[2\] VGND VGND VPWR VPWR net428 sky130_fd_sc_hd__dlygate4sd3_1
X_4468_ u_pe_array.g_pe_row\[3\].g_pe_col\[0\].u_pe.psum_out\[9\] _1287_ VGND VGND
+ VPWR VPWR _1570_ sky130_fd_sc_hd__nand2_1
X_6207_ u_pe_array.g_pe_row\[0\].g_pe_col\[3\].u_pe.psum_out\[5\] _2905_ _2916_ VGND
+ VGND VPWR VPWR _2917_ sky130_fd_sc_hd__a21oi_1
Xhold398 u_pe_array.g_pe_row\[3\].g_pe_col\[1\].u_pe.psum_out\[5\] VGND VGND VPWR
+ VPWR net472 sky130_fd_sc_hd__dlygate4sd3_1
X_7187_ clknet_leaf_8_clk net395 net950 VGND VGND VPWR VPWR u_pe_array.g_pe_row\[3\].g_pe_col\[2\].u_pe.move_reg\[9\]
+ sky130_fd_sc_hd__dfrtp_1
X_6138_ u_pe_array.act_from_down\[3\]\[7\] _2730_ _2511_ net312 VGND VGND VPWR VPWR
+ _0581_ sky130_fd_sc_hd__a22o_1
X_4399_ _1435_ u_pe_array.g_pe_row\[3\].g_pe_col\[0\].u_pe.act_val\[3\] u_pe_array.g_pe_row\[3\].g_pe_col\[0\].u_pe.w_out\[0\]
+ _1287_ VGND VGND VPWR VPWR _1507_ sky130_fd_sc_hd__nand4_1
XTAP_670 VGND VPWR sky130_fd_sc_hd__tapvpwrvgnd_1
XTAP_681 VGND VPWR sky130_fd_sc_hd__tapvpwrvgnd_1
XTAP_692 VGND VPWR sky130_fd_sc_hd__tapvpwrvgnd_1
X_6069_ u_pe_array.g_pe_row\[1\].g_pe_col\[0\].u_pe.psum_out\[9\] _1865_ VGND VGND
+ VPWR VPWR _2817_ sky130_fd_sc_hd__nand2_1
XFILLER_0_95_401 VGND VGND VPWR VPWR sky130_fd_sc_hd__fill_2
XFILLER_0_67_169 VGND VGND VPWR VPWR sky130_fd_sc_hd__fill_2
XFILLER_0_91_673 VPWR VGND VPWR VGND sky130_ef_sc_hd__decap_12
XFILLER_0_118_293 VGND VGND VPWR VPWR sky130_fd_sc_hd__decap_4
XFILLER_0_51_537 VGND VGND VPWR VPWR sky130_fd_sc_hd__fill_1
XFILLER_0_106_477 VGND VGND VPWR VPWR sky130_fd_sc_hd__fill_2
XFILLER_0_16_291 VGND VGND VPWR VPWR sky130_fd_sc_hd__fill_1
XFILLER_0_51_559 VGND VGND VPWR VPWR sky130_fd_sc_hd__fill_1
XFILLER_0_59_604 VGND VGND VPWR VPWR sky130_fd_sc_hd__fill_2
XFILLER_0_67_670 VGND VGND VPWR VPWR sky130_fd_sc_hd__fill_2
XFILLER_0_82_640 VGND VGND VPWR VPWR sky130_fd_sc_hd__decap_4
XFILLER_0_73_128 VGND VGND VPWR VPWR sky130_fd_sc_hd__decap_4
X_3770_ u_pe_array.g_pe_row\[3\].g_pe_col\[3\].u_pe.psum_out\[4\] _1025_ VGND VGND
+ VPWR VPWR _1026_ sky130_fd_sc_hd__xnor2_1
XFILLER_0_13_87 VGND VGND VPWR VPWR sky130_fd_sc_hd__fill_2
XFILLER_0_42_504 VGND VGND VPWR VPWR sky130_fd_sc_hd__decap_8
X_5440_ _2280_ net821 _1158_ VGND VGND VPWR VPWR _2316_ sky130_fd_sc_hd__mux2_1
XFILLER_0_2_601 VPWR VGND VPWR VGND sky130_ef_sc_hd__decap_12
XFILLER_0_42_548 VGND VGND VPWR VPWR sky130_fd_sc_hd__fill_1
X_5371_ u_pe_array.g_pe_row\[1\].g_pe_col\[3\].u_pe.psum_out\[12\] _2258_ VGND VGND
+ VPWR VPWR _2265_ sky130_fd_sc_hd__xnor2_1
XFILLER_0_1_111 VGND VGND VPWR VPWR sky130_fd_sc_hd__fill_1
XFILLER_0_2_645 VPWR VGND VPWR VGND sky130_ef_sc_hd__decap_12
X_7110_ clknet_leaf_102_clk _0016_ net944 VGND VGND VPWR VPWR u_pe_array.g_pe_row\[3\].g_pe_col\[2\].u_pe.w_out\[1\]
+ sky130_fd_sc_hd__dfrtp_1
X_4322_ u_pe_array.g_pe_row\[3\].g_pe_col\[0\].u_pe.psum_out\[10\] _1108_ _1110_ _1461_
+ VGND VGND VPWR VPWR _1462_ sky130_fd_sc_hd__o211a_2
X_4253_ u_pe_array.g_pe_row\[3\].g_pe_col\[1\].u_pe.psum_out\[10\] _1106_ VGND VGND
+ VPWR VPWR _1408_ sky130_fd_sc_hd__or2_1
X_7041_ net715 _3354_ _3514_ VGND VGND VPWR VPWR _3516_ sky130_fd_sc_hd__mux2_1
X_4184_ _1344_ _1106_ u_pe_array.g_pe_row\[3\].g_pe_col\[1\].u_pe.psum_out\[4\] VGND
+ VGND VPWR VPWR _1345_ sky130_fd_sc_hd__a21oi_1
X_7943_ clknet_leaf_81_clk _0848_ VGND VGND VPWR VPWR u_pe_array.u_fifo1.buffer\[7\]\[3\]
+ sky130_fd_sc_hd__dfxtp_1
X_7874_ clknet_leaf_102_clk _0779_ VGND VGND VPWR VPWR u_pe_array.u_fifo2.buffer\[6\]\[2\]
+ sky130_fd_sc_hd__dfxtp_1
XFILLER_0_49_136 VPWR VGND VPWR VGND sky130_ef_sc_hd__decap_12
X_6825_ u_pe_array.u_fifo2.count\[3\] _3386_ VGND VGND VPWR VPWR _3388_ sky130_fd_sc_hd__nand2_1
XFILLER_0_18_501 VPWR VGND VPWR VGND sky130_ef_sc_hd__decap_12
XFILLER_0_92_448 VGND VGND VPWR VPWR sky130_fd_sc_hd__decap_3
X_6756_ u_pe_array.g_pe_row\[0\].g_pe_col\[0\].u_pe.psum_out\[11\] _3246_ VGND VGND
+ VPWR VPWR _3338_ sky130_fd_sc_hd__nor2_1
X_3968_ net89 u_fsm.psum_shift_en _1175_ u_pe_array.g_pe_row\[3\].g_pe_col\[2\].u_pe.move_reg\[11\]
+ VGND VGND VPWR VPWR _0095_ sky130_fd_sc_hd__a22o_1
X_5707_ _2515_ _2516_ VGND VGND VPWR VPWR _2517_ sky130_fd_sc_hd__xor2_1
XFILLER_0_70_82 VGND VGND VPWR VPWR sky130_fd_sc_hd__fill_2
XFILLER_0_57_191 VPWR VGND VPWR VGND sky130_ef_sc_hd__decap_12
XFILLER_0_45_331 VGND VGND VPWR VPWR sky130_fd_sc_hd__decap_4
X_6687_ u_pe_array.g_pe_row\[0\].g_pe_col\[0\].u_pe.act_val\[4\] _2486_ u_pe_array.g_pe_row\[0\].g_pe_col\[0\].u_pe.psum_out\[4\]
+ VGND VGND VPWR VPWR _3276_ sky130_fd_sc_hd__a21oi_1
XFILLER_0_72_172 VGND VGND VPWR VPWR sky130_fd_sc_hd__decap_4
XFILLER_0_60_323 VGND VGND VPWR VPWR sky130_fd_sc_hd__fill_1
XFILLER_0_18_589 VGND VGND VPWR VPWR sky130_fd_sc_hd__decap_6
X_3899_ u_pe_array.g_pe_row\[3\].g_pe_col\[2\].u_pe.psum_out\[6\] _1112_ _1109_ _1137_
+ VGND VGND VPWR VPWR _1138_ sky130_fd_sc_hd__o211a_1
XFILLER_0_33_559 VGND VGND VPWR VPWR sky130_fd_sc_hd__fill_1
X_5638_ _2477_ _2478_ VGND VGND VPWR VPWR _2479_ sky130_fd_sc_hd__or2_1
X_5569_ _2415_ _2416_ VGND VGND VPWR VPWR _2417_ sky130_fd_sc_hd__or2_1
Xhold162 u_pe_array.g_pe_row\[0\].g_pe_col\[1\].u_pe.move_reg\[9\] VGND VGND VPWR
+ VPWR net236 sky130_fd_sc_hd__dlygate4sd3_1
Xhold140 u_pe_array.act_from_down\[9\]\[3\] VGND VGND VPWR VPWR net214 sky130_fd_sc_hd__dlygate4sd3_1
Xhold151 _0543_ VGND VGND VPWR VPWR net225 sky130_fd_sc_hd__dlygate4sd3_1
X_7308_ clknet_leaf_1_clk _0214_ net944 VGND VGND VPWR VPWR u_pe_array.act_from_right\[10\]\[7\]
+ sky130_fd_sc_hd__dfrtp_1
Xhold173 _0702_ VGND VGND VPWR VPWR net247 sky130_fd_sc_hd__dlygate4sd3_1
Xhold195 u_pe_array.act_from_right\[5\]\[7\] VGND VGND VPWR VPWR net269 sky130_fd_sc_hd__dlygate4sd3_1
XFILLER_0_0_7 VPWR VGND VPWR VGND sky130_ef_sc_hd__decap_12
Xhold184 _0264_ VGND VGND VPWR VPWR net258 sky130_fd_sc_hd__dlygate4sd3_1
X_7239_ clknet_leaf_14_clk _0145_ net942 VGND VGND VPWR VPWR u_pe_array.g_pe_row\[3\].g_pe_col\[1\].u_pe.psum_out\[7\]
+ sky130_fd_sc_hd__dfrtp_2
XTAP_1600 VGND VPWR sky130_fd_sc_hd__tapvpwrvgnd_1
XTAP_1633 VGND VPWR sky130_fd_sc_hd__tapvpwrvgnd_1
XTAP_1622 VGND VPWR sky130_fd_sc_hd__tapvpwrvgnd_1
XTAP_1611 VGND VPWR sky130_fd_sc_hd__tapvpwrvgnd_1
XTAP_1655 VGND VPWR sky130_fd_sc_hd__tapvpwrvgnd_1
XTAP_1666 VGND VPWR sky130_fd_sc_hd__tapvpwrvgnd_1
XTAP_1644 VGND VPWR sky130_fd_sc_hd__tapvpwrvgnd_1
XFILLER_0_83_415 VGND VGND VPWR VPWR sky130_fd_sc_hd__fill_1
XTAP_1699 VGND VPWR sky130_fd_sc_hd__tapvpwrvgnd_1
XTAP_1688 VGND VPWR sky130_fd_sc_hd__tapvpwrvgnd_1
XTAP_1677 VGND VPWR sky130_fd_sc_hd__tapvpwrvgnd_1
XFILLER_0_83_437 VGND VGND VPWR VPWR sky130_fd_sc_hd__decap_8
XFILLER_0_64_640 VGND VGND VPWR VPWR sky130_fd_sc_hd__decap_4
XFILLER_0_91_15 VGND VGND VPWR VPWR sky130_fd_sc_hd__fill_2
XFILLER_0_78_209 VGND VGND VPWR VPWR sky130_fd_sc_hd__decap_3
XFILLER_0_91_37 VPWR VGND VPWR VGND sky130_ef_sc_hd__decap_12
XFILLER_0_115_33 VPWR VGND VPWR VGND sky130_ef_sc_hd__decap_12
X_4940_ _1922_ _1923_ VGND VGND VPWR VPWR _1924_ sky130_fd_sc_hd__nor2_1
XFILLER_0_24_20 VGND VGND VPWR VPWR sky130_fd_sc_hd__decap_8
X_4871_ u_pe_array.g_pe_row\[2\].g_pe_col\[1\].u_pe.psum_out\[8\] u_pe_array.g_pe_row\[2\].g_pe_col\[1\].u_pe.move_reg\[8\]
+ _1867_ VGND VGND VPWR VPWR _1877_ sky130_fd_sc_hd__mux2_1
X_7590_ clknet_leaf_32_clk _0496_ net71 VGND VGND VPWR VPWR u_pe_array.g_pe_row\[1\].g_pe_col\[1\].u_pe.psum_out\[4\]
+ sky130_fd_sc_hd__dfrtp_1
X_3822_ _1059_ _1072_ _1073_ VGND VGND VPWR VPWR _1074_ sky130_fd_sc_hd__a21oi_1
X_6610_ _1092_ _0871_ _3229_ _0862_ net422 VGND VGND VPWR VPWR _0683_ sky130_fd_sc_hd__a32o_1
XFILLER_0_46_139 VGND VGND VPWR VPWR sky130_fd_sc_hd__fill_1
XFILLER_0_117_528 VGND VGND VPWR VPWR sky130_fd_sc_hd__fill_2
X_6541_ _3168_ u_pe_array.g_pe_row\[0\].g_pe_col\[1\].u_pe.psum_out\[6\] _2268_ VGND
+ VGND VPWR VPWR _3169_ sky130_fd_sc_hd__and3_1
XFILLER_0_27_353 VGND VGND VPWR VPWR sky130_fd_sc_hd__fill_1
XFILLER_0_70_610 VGND VGND VPWR VPWR sky130_fd_sc_hd__decap_8
X_3753_ u_pe_array.g_pe_row\[3\].g_pe_col\[3\].u_pe.act_val\[2\] VGND VGND VPWR VPWR
+ _1010_ sky130_fd_sc_hd__inv_2
XFILLER_0_54_161 VGND VGND VPWR VPWR sky130_fd_sc_hd__decap_6
X_6472_ u_pe_array.g_pe_row\[0\].g_pe_col\[1\].u_pe.act_val\[3\] _3101_ _2987_ net301
+ VGND VGND VPWR VPWR _0659_ sky130_fd_sc_hd__a22o_1
XFILLER_0_70_643 VGND VGND VPWR VPWR sky130_fd_sc_hd__fill_1
X_3684_ net337 _0949_ _0944_ _0959_ VGND VGND VPWR VPWR _0027_ sky130_fd_sc_hd__a22o_1
XFILLER_0_40_85 VPWR VGND VPWR VGND sky130_ef_sc_hd__decap_12
XFILLER_0_42_345 VGND VGND VPWR VPWR sky130_fd_sc_hd__decap_8
X_5423_ _2304_ VGND VGND VPWR VPWR _0421_ sky130_fd_sc_hd__clkbuf_1
XFILLER_0_100_406 VGND VGND VPWR VPWR sky130_fd_sc_hd__fill_2
X_5354_ _2236_ _2240_ _2247_ _2249_ VGND VGND VPWR VPWR _2250_ sky130_fd_sc_hd__a31o_1
XFILLER_0_2_475 VGND VGND VPWR VPWR sky130_fd_sc_hd__fill_1
XFILLER_0_23_570 VGND VGND VPWR VPWR sky130_fd_sc_hd__decap_6
XFILLER_0_112_299 VGND VGND VPWR VPWR sky130_fd_sc_hd__fill_2
X_4305_ u_pe_array.g_pe_row\[3\].g_pe_col\[0\].u_pe.move_reg\[6\] net62 VGND VGND
+ VPWR VPWR _1449_ sky130_fd_sc_hd__or2_1
XFILLER_0_10_253 VGND VGND VPWR VPWR sky130_fd_sc_hd__decap_3
X_5285_ _2186_ _2187_ _2176_ net941 VGND VGND VPWR VPWR _2188_ sky130_fd_sc_hd__a211oi_1
X_4236_ u_pe_array.g_pe_row\[3\].g_pe_col\[1\].u_pe.psum_out\[8\] _1106_ VGND VGND
+ VPWR VPWR _1393_ sky130_fd_sc_hd__or2_1
XFILLER_0_4_41 VPWR VGND VPWR VGND sky130_ef_sc_hd__decap_12
X_7024_ u_pe_array.u_fifo1.wr_ptr\[0\] u_pe_array.u_fifo1.wr_ptr\[1\] _3483_ VGND
+ VGND VPWR VPWR _3506_ sky130_fd_sc_hd__and3_2
X_4167_ u_pe_array.g_pe_row\[3\].g_pe_col\[1\].u_pe.act_val\[2\] u_pe_array.g_pe_row\[3\].g_pe_col\[1\].u_pe.w_out\[0\]
+ _1321_ VGND VGND VPWR VPWR _1329_ sky130_fd_sc_hd__and3_1
XFILLER_0_4_85 VPWR VGND VPWR VGND sky130_ef_sc_hd__decap_12
X_4098_ u_pe_array.g_pe_row\[3\].g_pe_col\[1\].u_pe.psum_out\[0\] u_pe_array.g_pe_row\[3\].g_pe_col\[1\].u_pe.act_val\[0\]
+ _0947_ VGND VGND VPWR VPWR _1289_ sky130_fd_sc_hd__mux2_1
X_7926_ clknet_leaf_81_clk _0831_ VGND VGND VPWR VPWR u_pe_array.u_fifo1.buffer\[4\]\[4\]
+ sky130_fd_sc_hd__dfxtp_1
X_7857_ clknet_leaf_86_clk _0762_ VGND VGND VPWR VPWR u_pe_array.u_fifo2.buffer\[3\]\[3\]
+ sky130_fd_sc_hd__dfxtp_1
X_6808_ u_pe_array.u_fifo2.rd_ptr\[2\] _3374_ VGND VGND VPWR VPWR _3376_ sky130_fd_sc_hd__and2_1
X_7788_ clknet_leaf_63_clk _0694_ net74 VGND VGND VPWR VPWR u_pe_array.act_from_up\[4\]\[10\]
+ sky130_fd_sc_hd__dfrtp_1
XFILLER_0_46_662 VGND VGND VPWR VPWR sky130_fd_sc_hd__fill_1
X_6739_ _3320_ _3316_ _3307_ u_pe_array.g_pe_row\[0\].g_pe_col\[0\].u_pe.psum_out\[8\]
+ VGND VGND VPWR VPWR _3323_ sky130_fd_sc_hd__o2bb2a_1
XFILLER_0_18_375 VGND VGND VPWR VPWR sky130_fd_sc_hd__fill_2
XFILLER_0_45_172 VGND VGND VPWR VPWR sky130_fd_sc_hd__fill_2
XFILLER_0_46_673 VGND VGND VPWR VPWR sky130_fd_sc_hd__decap_8
XFILLER_0_104_701 VGND VGND VPWR VPWR sky130_fd_sc_hd__decap_4
XFILLER_0_45_183 VGND VGND VPWR VPWR sky130_fd_sc_hd__fill_2
XFILLER_0_33_378 VPWR VGND VPWR VGND sky130_ef_sc_hd__decap_12
XFILLER_0_103_266 VGND VGND VPWR VPWR sky130_fd_sc_hd__fill_1
XFILLER_0_60_197 VGND VGND VPWR VPWR sky130_fd_sc_hd__decap_8
XTAP_1441 VGND VPWR sky130_fd_sc_hd__tapvpwrvgnd_1
XTAP_1430 VGND VPWR sky130_fd_sc_hd__tapvpwrvgnd_1
XTAP_1474 VGND VPWR sky130_fd_sc_hd__tapvpwrvgnd_1
XTAP_1463 VGND VPWR sky130_fd_sc_hd__tapvpwrvgnd_1
XFILLER_0_96_584 VGND VGND VPWR VPWR sky130_fd_sc_hd__decap_4
XTAP_1452 VGND VPWR sky130_fd_sc_hd__tapvpwrvgnd_1
XFILLER_0_83_234 VGND VGND VPWR VPWR sky130_fd_sc_hd__decap_4
XFILLER_0_68_286 VPWR VGND VPWR VGND sky130_ef_sc_hd__decap_12
XTAP_1496 VGND VPWR sky130_fd_sc_hd__tapvpwrvgnd_1
XTAP_1485 VGND VPWR sky130_fd_sc_hd__tapvpwrvgnd_1
XFILLER_0_64_470 VGND VGND VPWR VPWR sky130_fd_sc_hd__decap_6
XFILLER_0_43_109 VGND VGND VPWR VPWR sky130_fd_sc_hd__decap_3
XFILLER_0_107_550 VGND VGND VPWR VPWR sky130_fd_sc_hd__decap_6
XFILLER_0_3_217 VGND VGND VPWR VPWR sky130_fd_sc_hd__decap_6
XFILLER_0_101_57 VPWR VGND VPWR VGND sky130_ef_sc_hd__decap_12
XFILLER_0_10_77 VGND VGND VPWR VPWR sky130_fd_sc_hd__decap_6
XFILLER_0_86_15 VPWR VGND VPWR VGND sky130_ef_sc_hd__decap_12
X_5070_ u_pe_array.g_pe_row\[2\].g_pe_col\[0\].u_pe.act_val\[0\] _1284_ u_pe_array.g_pe_row\[2\].g_pe_col\[0\].u_pe.psum_out\[0\]
+ VGND VGND VPWR VPWR _2017_ sky130_fd_sc_hd__a21o_1
X_4021_ _1219_ _1221_ VGND VGND VPWR VPWR _1222_ sky130_fd_sc_hd__xor2_1
X_5972_ u_pe_array.act_from_up\[4\]\[11\] _2730_ _2511_ net208 VGND VGND VPWR VPWR
+ _0544_ sky130_fd_sc_hd__a22o_1
X_4923_ u_pe_array.g_pe_row\[2\].g_pe_col\[1\].u_pe.act_val\[3\] u_pe_array.g_pe_row\[2\].g_pe_col\[1\].u_pe.w_out\[0\]
+ _1105_ _1907_ VGND VGND VPWR VPWR _1908_ sky130_fd_sc_hd__a22o_1
XFILLER_0_87_573 VGND VGND VPWR VPWR sky130_fd_sc_hd__fill_1
XFILLER_0_87_551 VGND VGND VPWR VPWR sky130_fd_sc_hd__decap_8
XFILLER_0_75_702 VGND VGND VPWR VPWR sky130_fd_sc_hd__decap_3
X_7711_ clknet_leaf_59_clk net219 net74 VGND VGND VPWR VPWR u_pe_array.g_pe_row\[0\].g_pe_col\[2\].u_pe.act_val\[2\]
+ sky130_fd_sc_hd__dfrtp_4
XFILLER_0_19_117 VGND VGND VPWR VPWR sky130_fd_sc_hd__fill_1
XFILLER_0_47_415 VGND VGND VPWR VPWR sky130_fd_sc_hd__decap_3
X_4854_ u_pe_array.g_pe_row\[2\].g_pe_col\[1\].u_pe.psum_out\[0\] u_pe_array.g_pe_row\[2\].g_pe_col\[1\].u_pe.act_val\[0\]
+ _1867_ VGND VGND VPWR VPWR _1868_ sky130_fd_sc_hd__mux2_1
XFILLER_0_7_501 VGND VGND VPWR VPWR sky130_fd_sc_hd__decap_3
X_7642_ clknet_leaf_90_clk _0548_ net949 VGND VGND VPWR VPWR u_pe_array.g_pe_row\[1\].g_pe_col\[0\].u_pe.psum_out\[2\]
+ sky130_fd_sc_hd__dfrtp_1
X_7573_ clknet_leaf_33_clk _0479_ net71 VGND VGND VPWR VPWR u_pe_array.g_pe_row\[1\].g_pe_col\[1\].u_pe.act_val\[0\]
+ sky130_fd_sc_hd__dfrtp_2
X_3805_ _1049_ _1054_ _1057_ VGND VGND VPWR VPWR _1058_ sky130_fd_sc_hd__o21bai_1
X_4785_ u_pe_array.g_pe_row\[2\].g_pe_col\[2\].u_pe.act_val\[5\] u_pe_array.g_pe_row\[2\].g_pe_col\[2\].u_pe.w_out\[0\]
+ _1795_ VGND VGND VPWR VPWR _1808_ sky130_fd_sc_hd__and3_1
X_6524_ _3152_ _3153_ VGND VGND VPWR VPWR _3154_ sky130_fd_sc_hd__nor2_1
X_3736_ _0980_ _0990_ VGND VGND VPWR VPWR _0994_ sky130_fd_sc_hd__nand2_1
XFILLER_0_70_473 VGND VGND VPWR VPWR sky130_fd_sc_hd__decap_3
XFILLER_0_15_367 VGND VGND VPWR VPWR sky130_fd_sc_hd__fill_1
XFILLER_0_30_304 VGND VGND VPWR VPWR sky130_fd_sc_hd__decap_4
X_6455_ u_pe_array.g_pe_row\[0\].g_pe_col\[1\].u_pe.psum_out\[6\] u_pe_array.g_pe_row\[0\].g_pe_col\[1\].u_pe.move_reg\[6\]
+ _3102_ VGND VGND VPWR VPWR _3109_ sky130_fd_sc_hd__mux2_1
X_3667_ u_pe_array.g_pe_row\[3\].g_pe_col\[3\].u_pe.psum_out\[2\] u_pe_array.g_pe_row\[3\].g_pe_col\[3\].u_pe.act_val\[2\]
+ _0947_ VGND VGND VPWR VPWR _0951_ sky130_fd_sc_hd__mux2_1
XFILLER_0_113_597 VGND VGND VPWR VPWR sky130_fd_sc_hd__decap_4
X_6386_ _3049_ _3052_ _3048_ VGND VGND VPWR VPWR _3054_ sky130_fd_sc_hd__a21oi_1
X_3598_ _0897_ VGND VGND VPWR VPWR u_fsm.next_state\[1\] sky130_fd_sc_hd__buf_1
X_5406_ net831 _2291_ _2273_ VGND VGND VPWR VPWR _2292_ sky130_fd_sc_hd__mux2_1
XFILLER_0_100_236 VGND VGND VPWR VPWR sky130_fd_sc_hd__decap_4
X_5337_ _2218_ _2228_ u_pe_array.g_pe_row\[1\].g_pe_col\[3\].u_pe.psum_out\[7\] _2229_
+ VGND VGND VPWR VPWR _2235_ sky130_fd_sc_hd__o2bb2a_1
X_5268_ _0985_ VGND VGND VPWR VPWR _2173_ sky130_fd_sc_hd__buf_8
X_4219_ net594 _1273_ _1377_ _1021_ VGND VGND VPWR VPWR _0144_ sky130_fd_sc_hd__a22o_1
X_7007_ _3496_ VGND VGND VPWR VPWR _0813_ sky130_fd_sc_hd__clkbuf_1
X_5199_ _2131_ VGND VGND VPWR VPWR _0370_ sky130_fd_sc_hd__clkbuf_1
XFILLER_0_97_337 VGND VGND VPWR VPWR sky130_fd_sc_hd__fill_1
X_7909_ clknet_leaf_82_clk _0814_ VGND VGND VPWR VPWR u_pe_array.u_fifo1.buffer\[1\]\[5\]
+ sky130_fd_sc_hd__dfxtp_1
XFILLER_0_108_347 VPWR VGND VPWR VGND sky130_ef_sc_hd__decap_12
XFILLER_0_93_576 VPWR VGND VPWR VGND sky130_ef_sc_hd__decap_12
XFILLER_0_46_470 VGND VGND VPWR VPWR sky130_fd_sc_hd__decap_3
XFILLER_0_34_665 VPWR VGND VPWR VGND sky130_ef_sc_hd__decap_12
XFILLER_0_104_542 VGND VGND VPWR VPWR sky130_fd_sc_hd__decap_6
XFILLER_0_0_209 VGND VGND VPWR VPWR sky130_fd_sc_hd__decap_8
XFILLER_0_56_29 VGND VGND VPWR VPWR sky130_fd_sc_hd__decap_4
Xload_slew11 net951 VGND VGND VPWR VPWR net950 sky130_fd_sc_hd__buf_12
XFILLER_0_8_309 VGND VGND VPWR VPWR sky130_fd_sc_hd__decap_4
XTAP_1293 VGND VPWR sky130_fd_sc_hd__tapvpwrvgnd_1
XTAP_1282 VGND VPWR sky130_fd_sc_hd__tapvpwrvgnd_1
XTAP_1271 VGND VPWR sky130_fd_sc_hd__tapvpwrvgnd_1
XTAP_1260 VGND VPWR sky130_fd_sc_hd__tapvpwrvgnd_1
XFILLER_0_56_245 VGND VGND VPWR VPWR sky130_fd_sc_hd__decap_6
XFILLER_0_56_278 VGND VGND VPWR VPWR sky130_fd_sc_hd__decap_8
XFILLER_0_114_317 VPWR VGND VPWR VGND sky130_ef_sc_hd__decap_12
X_4570_ _1635_ u_pe_array.g_pe_row\[2\].g_pe_col\[3\].u_pe.psum_out\[3\] _1427_ VGND
+ VGND VPWR VPWR _1637_ sky130_fd_sc_hd__and3_1
XFILLER_0_108_3 VPWR VGND VPWR VGND sky130_ef_sc_hd__decap_12
XFILLER_0_107_380 VGND VGND VPWR VPWR sky130_fd_sc_hd__decap_4
Xhold706 u_pe_array.g_pe_row\[0\].g_pe_col\[3\].u_pe.psum_out\[8\] VGND VGND VPWR
+ VPWR net780 sky130_fd_sc_hd__dlygate4sd3_1
Xhold728 _0387_ VGND VGND VPWR VPWR net802 sky130_fd_sc_hd__dlygate4sd3_1
XFILLER_0_24_186 VGND VGND VPWR VPWR sky130_fd_sc_hd__decap_4
Xhold717 u_pe_array.g_pe_row\[1\].g_pe_col\[0\].u_pe.act_val\[5\] VGND VGND VPWR VPWR
+ net791 sky130_fd_sc_hd__dlygate4sd3_1
XFILLER_0_97_69 VGND VGND VPWR VPWR sky130_fd_sc_hd__decap_8
X_6240_ u_pe_array.g_pe_row\[0\].g_pe_col\[3\].u_pe.psum_out\[9\] _1999_ VGND VGND
+ VPWR VPWR _2947_ sky130_fd_sc_hd__nand2_1
Xhold739 u_pe_array.g_pe_row\[2\].g_pe_col\[2\].u_pe.psum_out\[2\] VGND VGND VPWR
+ VPWR net813 sky130_fd_sc_hd__dlygate4sd3_1
X_6171_ _2882_ _2883_ VGND VGND VPWR VPWR _2884_ sky130_fd_sc_hd__nand2_1
XFILLER_0_110_589 VGND VGND VPWR VPWR sky130_fd_sc_hd__decap_4
X_5122_ u_pe_array.g_pe_row\[2\].g_pe_col\[0\].u_pe.act_val\[4\] _1286_ VGND VGND
+ VPWR VPWR _2064_ sky130_fd_sc_hd__and2b_1
XFILLER_0_20_381 VGND VGND VPWR VPWR sky130_fd_sc_hd__fill_1
X_5053_ net447 _2006_ _2009_ _2014_ VGND VGND VPWR VPWR _0341_ sky130_fd_sc_hd__a22o_1
XFILLER_0_79_315 VGND VGND VPWR VPWR sky130_fd_sc_hd__fill_2
X_4004_ u_pe_array.g_pe_row\[3\].g_pe_col\[2\].u_pe.act_val\[4\] u_pe_array.g_pe_row\[3\].g_pe_col\[2\].u_pe.w_out\[0\]
+ VGND VGND VPWR VPWR _1206_ sky130_fd_sc_hd__nand2_1
XFILLER_0_79_348 VGND VGND VPWR VPWR sky130_fd_sc_hd__decap_8
XFILLER_0_79_337 VGND VGND VPWR VPWR sky130_fd_sc_hd__decap_8
X_5955_ u_pe_array.u_fifo1.buffer\[8\]\[4\] _2676_ _2716_ _2720_ _0857_ VGND VGND
+ VPWR VPWR _2721_ sky130_fd_sc_hd__a221o_1
XFILLER_0_118_601 VGND VGND VPWR VPWR sky130_fd_sc_hd__decap_4
X_4906_ u_pe_array.g_pe_row\[2\].g_pe_col\[1\].u_pe.psum_out\[1\] _1891_ VGND VGND
+ VPWR VPWR _1893_ sky130_fd_sc_hd__nand2_1
XFILLER_0_62_83 VGND VGND VPWR VPWR sky130_fd_sc_hd__fill_1
X_5886_ _2629_ u_pe_array.act_from_left\[5\]\[0\] _1158_ VGND VGND VPWR VPWR _2669_
+ sky130_fd_sc_hd__mux2_1
XFILLER_0_118_645 VPWR VGND VPWR VGND sky130_ef_sc_hd__decap_12
XFILLER_0_75_576 VGND VGND VPWR VPWR sky130_fd_sc_hd__fill_1
X_7625_ clknet_leaf_90_clk _0531_ net949 VGND VGND VPWR VPWR u_pe_array.act_from_left\[5\]\[11\]
+ sky130_fd_sc_hd__dfrtp_1
X_4837_ _0933_ u_pe_array.g_pe_row\[2\].g_pe_col\[2\].u_pe.psum_out\[11\] VGND VGND
+ VPWR VPWR _1855_ sky130_fd_sc_hd__and2b_1
XFILLER_0_118_678 VPWR VGND VPWR VGND sky130_ef_sc_hd__decap_12
XFILLER_0_117_177 VPWR VGND VPWR VGND sky130_ef_sc_hd__decap_12
XFILLER_0_62_226 VPWR VGND VPWR VGND sky130_ef_sc_hd__decap_12
XFILLER_0_28_481 VGND VGND VPWR VPWR sky130_fd_sc_hd__fill_1
XFILLER_0_90_568 VPWR VGND VPWR VGND sky130_ef_sc_hd__decap_12
XFILLER_0_7_397 VGND VGND VPWR VPWR sky130_fd_sc_hd__decap_4
X_4768_ _1783_ _1791_ _1003_ VGND VGND VPWR VPWR _1793_ sky130_fd_sc_hd__a21o_1
XFILLER_0_16_654 VGND VGND VPWR VPWR sky130_fd_sc_hd__fill_2
X_7556_ clknet_leaf_69_clk _0462_ net72 VGND VGND VPWR VPWR u_pe_array.g_pe_row\[1\].g_pe_col\[2\].u_pe.psum_out\[11\]
+ sky130_fd_sc_hd__dfrtp_1
X_6507_ u_pe_array.g_pe_row\[0\].g_pe_col\[1\].u_pe.act_val\[3\] u_pe_array.g_pe_row\[0\].g_pe_col\[1\].u_pe.w_out\[0\]
+ _2268_ _3137_ VGND VGND VPWR VPWR _3138_ sky130_fd_sc_hd__a22o_1
X_7487_ clknet_leaf_41_clk _0393_ net947 VGND VGND VPWR VPWR u_pe_array.g_pe_row\[1\].g_pe_col\[3\].u_pe.move_reg\[9\]
+ sky130_fd_sc_hd__dfrtp_1
X_3719_ u_pe_array.g_pe_row\[3\].g_pe_col\[3\].u_pe.act_val\[0\] u_pe_array.g_pe_row\[3\].g_pe_col\[3\].u_pe.w_out\[0\]
+ u_pe_array.g_pe_row\[3\].g_pe_col\[3\].u_pe.psum_out\[0\] VGND VGND VPWR VPWR _0979_
+ sky130_fd_sc_hd__a21o_1
XFILLER_0_31_613 VGND VGND VPWR VPWR sky130_fd_sc_hd__decap_3
X_4699_ u_pe_array.g_pe_row\[2\].g_pe_col\[2\].u_pe.psum_out\[9\] u_pe_array.g_pe_row\[2\].g_pe_col\[2\].u_pe.move_reg\[9\]
+ _1599_ VGND VGND VPWR VPWR _1745_ sky130_fd_sc_hd__mux2_1
X_6438_ _3099_ VGND VGND VPWR VPWR _0641_ sky130_fd_sc_hd__clkbuf_1
X_6369_ _3023_ _3033_ _3037_ VGND VGND VPWR VPWR _3039_ sky130_fd_sc_hd__nor3_1
Xhold11 u_pe_array.act_from_down\[9\]\[4\] VGND VGND VPWR VPWR net85 sky130_fd_sc_hd__dlygate4sd3_1
Xhold22 _0489_ VGND VGND VPWR VPWR net96 sky130_fd_sc_hd__dlygate4sd3_1
Xhold33 _0663_ VGND VGND VPWR VPWR net107 sky130_fd_sc_hd__dlygate4sd3_1
Xhold55 _0705_ VGND VGND VPWR VPWR net129 sky130_fd_sc_hd__dlygate4sd3_1
Xhold44 _0707_ VGND VGND VPWR VPWR net118 sky130_fd_sc_hd__dlygate4sd3_1
Xhold77 u_pe_array.act_from_down\[3\]\[8\] VGND VGND VPWR VPWR net151 sky130_fd_sc_hd__dlygate4sd3_1
Xhold66 u_pe_array.act_from_left\[7\]\[10\] VGND VGND VPWR VPWR net140 sky130_fd_sc_hd__dlygate4sd3_1
Xhold99 u_pe_array.act_from_right\[10\]\[2\] VGND VGND VPWR VPWR net173 sky130_fd_sc_hd__dlygate4sd3_1
Xhold88 u_pe_array.act_from_down\[11\]\[2\] VGND VGND VPWR VPWR net162 sky130_fd_sc_hd__dlygate4sd3_1
XFILLER_0_97_167 VGND VGND VPWR VPWR sky130_fd_sc_hd__fill_1
XFILLER_0_93_384 VGND VGND VPWR VPWR sky130_fd_sc_hd__decap_8
XFILLER_0_66_587 VGND VGND VPWR VPWR sky130_fd_sc_hd__fill_1
XFILLER_0_26_418 VGND VGND VPWR VPWR sky130_fd_sc_hd__fill_2
XFILLER_0_53_204 VGND VGND VPWR VPWR sky130_fd_sc_hd__decap_4
XFILLER_0_61_281 VGND VGND VPWR VPWR sky130_fd_sc_hd__decap_8
XANTENNA_8 net9 VGND VGND VPWR VPWR sky130_fd_sc_hd__diode_2
XFILLER_0_1_529 VPWR VGND VPWR VGND sky130_ef_sc_hd__decap_12
XFILLER_0_104_394 VGND VGND VPWR VPWR sky130_fd_sc_hd__decap_8
XFILLER_0_67_39 VGND VGND VPWR VPWR sky130_fd_sc_hd__fill_1
XFILLER_0_21_167 VGND VGND VPWR VPWR sky130_fd_sc_hd__fill_1
XTAP_329 VGND VPWR sky130_fd_sc_hd__tapvpwrvgnd_1
XTAP_318 VGND VPWR sky130_fd_sc_hd__tapvpwrvgnd_1
XTAP_307 VGND VPWR sky130_fd_sc_hd__tapvpwrvgnd_1
XFILLER_0_83_38 VGND VGND VPWR VPWR sky130_fd_sc_hd__fill_1
XFILLER_0_76_307 VGND VGND VPWR VPWR sky130_fd_sc_hd__fill_1
XFILLER_0_16_65 VGND VGND VPWR VPWR sky130_fd_sc_hd__fill_2
XFILLER_0_16_98 VPWR VGND VPWR VGND sky130_ef_sc_hd__decap_12
X_5740_ _2545_ _2546_ VGND VGND VPWR VPWR _2547_ sky130_fd_sc_hd__xnor2_1
Xclkbuf_leaf_108_clk clknet_3_0__leaf_clk VGND VGND VPWR VPWR clknet_leaf_108_clk
+ sky130_fd_sc_hd__clkbuf_16
XFILLER_0_29_245 VPWR VGND VPWR VGND sky130_ef_sc_hd__decap_12
XTAP_1090 VGND VPWR sky130_fd_sc_hd__tapvpwrvgnd_1
XFILLER_0_8_139 VGND VGND VPWR VPWR sky130_fd_sc_hd__fill_1
XFILLER_0_32_53 VGND VGND VPWR VPWR sky130_fd_sc_hd__decap_4
X_7410_ clknet_leaf_23_clk _0316_ net943 VGND VGND VPWR VPWR u_pe_array.g_pe_row\[2\].g_pe_col\[1\].u_pe.psum_out\[1\]
+ sky130_fd_sc_hd__dfrtp_1
X_5671_ u_pe_array.g_pe_row\[1\].g_pe_col\[1\].u_pe.psum_out\[8\] u_pe_array.g_pe_row\[1\].g_pe_col\[1\].u_pe.move_reg\[8\]
+ _2133_ VGND VGND VPWR VPWR _2500_ sky130_fd_sc_hd__mux2_1
XFILLER_0_84_384 VGND VGND VPWR VPWR sky130_fd_sc_hd__decap_6
XFILLER_0_4_323 VPWR VGND VPWR VGND sky130_ef_sc_hd__decap_12
X_4622_ _1683_ _1684_ VGND VGND VPWR VPWR _1685_ sky130_fd_sc_hd__and2_1
X_7341_ clknet_leaf_30_clk _0247_ net942 VGND VGND VPWR VPWR u_pe_array.g_pe_row\[2\].g_pe_col\[1\].u_pe.w_out\[1\]
+ sky130_fd_sc_hd__dfrtp_1
XFILLER_0_102_309 VGND VGND VPWR VPWR sky130_fd_sc_hd__decap_8
X_4553_ u_pe_array.g_pe_row\[2\].g_pe_col\[3\].u_pe.act_val\[1\] _1424_ _1619_ _1620_
+ VGND VGND VPWR VPWR _1622_ sky130_fd_sc_hd__a22o_1
XFILLER_0_40_421 VGND VGND VPWR VPWR sky130_fd_sc_hd__fill_2
Xhold503 u_pe_array.g_pe_row\[1\].g_pe_col\[3\].u_pe.psum_out\[1\] VGND VGND VPWR
+ VPWR net577 sky130_fd_sc_hd__dlygate4sd3_1
XFILLER_0_12_123 VGND VGND VPWR VPWR sky130_fd_sc_hd__decap_8
Xhold525 u_pe_array.u_fifo2.buffer\[3\]\[1\] VGND VGND VPWR VPWR net599 sky130_fd_sc_hd__dlygate4sd3_1
Xhold514 u_pe_array.u_fifo1.buffer\[3\]\[2\] VGND VGND VPWR VPWR net588 sky130_fd_sc_hd__dlygate4sd3_1
Xhold536 u_pe_array.u_fifo1.buffer\[3\]\[0\] VGND VGND VPWR VPWR net610 sky130_fd_sc_hd__dlygate4sd3_1
X_7272_ clknet_leaf_98_clk _0178_ net951 VGND VGND VPWR VPWR u_pe_array.act_from_left\[13\]\[12\]
+ sky130_fd_sc_hd__dfrtp_1
XFILLER_0_40_443 VPWR VGND VPWR VGND sky130_ef_sc_hd__decap_12
X_4484_ _1583_ _1584_ u_pe_array.g_pe_row\[3\].g_pe_col\[0\].u_pe.psum_out\[10\] _1006_
+ VGND VGND VPWR VPWR _0202_ sky130_fd_sc_hd__a2bb2o_1
X_6223_ _2927_ _2931_ VGND VGND VPWR VPWR _2932_ sky130_fd_sc_hd__or2_1
Xhold569 _0129_ VGND VGND VPWR VPWR net643 sky130_fd_sc_hd__dlygate4sd3_1
Xhold547 u_pe_array.u_fifo2.buffer\[1\]\[2\] VGND VGND VPWR VPWR net621 sky130_fd_sc_hd__dlygate4sd3_1
Xhold558 u_pe_array.u_fifo2.buffer\[8\]\[3\] VGND VGND VPWR VPWR net632 sky130_fd_sc_hd__dlygate4sd3_1
XFILLER_0_0_573 VPWR VGND VPWR VGND sky130_ef_sc_hd__decap_12
X_6154_ _2795_ _2867_ _2868_ _2621_ net645 VGND VGND VPWR VPWR _0588_ sky130_fd_sc_hd__a32o_1
XTAP_841 VGND VPWR sky130_fd_sc_hd__tapvpwrvgnd_1
XTAP_830 VGND VPWR sky130_fd_sc_hd__tapvpwrvgnd_1
XTAP_852 VGND VPWR sky130_fd_sc_hd__tapvpwrvgnd_1
X_5105_ _1884_ _2047_ _2048_ _1803_ net529 VGND VGND VPWR VPWR _0359_ sky130_fd_sc_hd__a32o_1
X_6085_ _2830_ _2831_ u_pe_array.g_pe_row\[1\].g_pe_col\[0\].u_pe.psum_out\[10\] _1007_
+ VGND VGND VPWR VPWR _0556_ sky130_fd_sc_hd__a2bb2o_1
XTAP_863 VGND VPWR sky130_fd_sc_hd__tapvpwrvgnd_1
XTAP_874 VGND VPWR sky130_fd_sc_hd__tapvpwrvgnd_1
XTAP_885 VGND VPWR sky130_fd_sc_hd__tapvpwrvgnd_1
X_5036_ u_pe_array.g_pe_row\[2\].g_pe_col\[0\].u_pe.psum_out\[4\] u_pe_array.g_pe_row\[2\].g_pe_col\[0\].u_pe.act_val\[4\]
+ _1867_ VGND VGND VPWR VPWR _2005_ sky130_fd_sc_hd__mux2_2
XTAP_896 VGND VPWR sky130_fd_sc_hd__tapvpwrvgnd_1
XFILLER_0_94_115 VGND VGND VPWR VPWR sky130_fd_sc_hd__decap_8
XFILLER_0_73_93 VGND VGND VPWR VPWR sky130_fd_sc_hd__fill_2
XFILLER_0_67_329 VGND VGND VPWR VPWR sky130_fd_sc_hd__decap_6
X_6987_ net548 _3354_ _3484_ VGND VGND VPWR VPWR _3486_ sky130_fd_sc_hd__mux2_1
X_5938_ u_pe_array.u_fifo1.buffer\[4\]\[2\] _2680_ _2703_ _2705_ VGND VGND VPWR VPWR
+ _2706_ sky130_fd_sc_hd__a211o_1
XFILLER_0_63_557 VGND VGND VPWR VPWR sky130_fd_sc_hd__decap_3
X_5869_ _2656_ VGND VGND VPWR VPWR _0515_ sky130_fd_sc_hd__clkbuf_1
XFILLER_0_105_125 VPWR VGND VPWR VGND sky130_ef_sc_hd__decap_12
X_7608_ clknet_leaf_58_clk _0514_ net946 VGND VGND VPWR VPWR net46 sky130_fd_sc_hd__dfrtp_1
X_7539_ clknet_leaf_68_clk net186 net72 VGND VGND VPWR VPWR u_pe_array.g_pe_row\[1\].g_pe_col\[2\].u_pe.move_reg\[7\]
+ sky130_fd_sc_hd__dfrtp_1
XFILLER_0_43_270 VGND VGND VPWR VPWR sky130_fd_sc_hd__decap_8
XFILLER_0_114_681 VPWR VGND VPWR VGND sky130_ef_sc_hd__decap_12
Xoutput56 net56 VGND VGND VPWR VPWR psum_out1[4] sky130_fd_sc_hd__clkbuf_4
Xoutput45 net45 VGND VGND VPWR VPWR psum_out0[6] sky130_fd_sc_hd__clkbuf_4
XFILLER_0_101_386 VGND VGND VPWR VPWR sky130_fd_sc_hd__decap_6
XFILLER_0_98_421 VGND VGND VPWR VPWR sky130_fd_sc_hd__decap_3
XFILLER_0_58_307 VGND VGND VPWR VPWR sky130_fd_sc_hd__fill_1
XFILLER_0_85_104 VGND VGND VPWR VPWR sky130_fd_sc_hd__fill_2
XPHY_151 VGND VGND VPWR VPWR sky130_fd_sc_hd__decap_3
XPHY_140 VGND VGND VPWR VPWR sky130_fd_sc_hd__decap_3
XPHY_184 VGND VGND VPWR VPWR sky130_fd_sc_hd__decap_3
XPHY_173 VGND VGND VPWR VPWR sky130_fd_sc_hd__decap_3
XPHY_162 VGND VGND VPWR VPWR sky130_fd_sc_hd__decap_3
XPHY_195 VGND VGND VPWR VPWR sky130_fd_sc_hd__decap_3
XFILLER_0_78_49 VGND VGND VPWR VPWR sky130_fd_sc_hd__fill_1
XFILLER_0_22_421 VPWR VGND VPWR VGND sky130_ef_sc_hd__decap_12
XFILLER_0_34_292 VGND VGND VPWR VPWR sky130_fd_sc_hd__decap_4
X_7890_ clknet_leaf_80_clk _0795_ net13 VGND VGND VPWR VPWR u_pe_array.u_fifo1.rd_ptr\[0\]
+ sky130_fd_sc_hd__dfrtp_4
X_6910_ _0928_ net626 _3431_ VGND VGND VPWR VPWR _3437_ sky130_fd_sc_hd__mux2_1
XFILLER_0_77_638 VGND VGND VPWR VPWR sky130_fd_sc_hd__fill_1
X_6841_ net556 _0928_ _3392_ VGND VGND VPWR VPWR _3398_ sky130_fd_sc_hd__mux2_1
XFILLER_0_43_41 VGND VGND VPWR VPWR sky130_fd_sc_hd__decap_4
XFILLER_0_76_159 VGND VGND VPWR VPWR sky130_fd_sc_hd__fill_1
XFILLER_0_85_671 VGND VGND VPWR VPWR sky130_fd_sc_hd__fill_1
XFILLER_0_57_362 VGND VGND VPWR VPWR sky130_fd_sc_hd__decap_3
X_6772_ _0912_ _3351_ VGND VGND VPWR VPWR _3352_ sky130_fd_sc_hd__or2_2
X_3984_ _1111_ u_pe_array.g_pe_row\[3\].g_pe_col\[2\].u_pe.psum_out\[1\] _0934_ VGND
+ VGND VPWR VPWR _1188_ sky130_fd_sc_hd__o21a_1
XFILLER_0_45_502 VGND VGND VPWR VPWR sky130_fd_sc_hd__fill_2
X_5723_ _2523_ _2527_ VGND VGND VPWR VPWR _2531_ sky130_fd_sc_hd__nor2_1
XFILLER_0_85_693 VPWR VGND VPWR VGND sky130_ef_sc_hd__decap_12
XFILLER_0_115_401 VGND VGND VPWR VPWR sky130_fd_sc_hd__fill_1
X_5654_ net469 _2143_ _2132_ _2490_ VGND VGND VPWR VPWR _0466_ sky130_fd_sc_hd__a22o_1
XFILLER_0_84_192 VGND VGND VPWR VPWR sky130_fd_sc_hd__decap_4
XFILLER_0_17_259 VPWR VGND VPWR VGND sky130_ef_sc_hd__decap_12
X_4605_ net396 _1273_ _1669_ _1021_ VGND VGND VPWR VPWR _0238_ sky130_fd_sc_hd__a22o_1
Xhold311 u_pe_array.g_pe_row\[2\].g_pe_col\[1\].u_pe.move_reg\[10\] VGND VGND VPWR
+ VPWR net385 sky130_fd_sc_hd__dlygate4sd3_1
X_7324_ clknet_leaf_17_clk net338 net943 VGND VGND VPWR VPWR u_pe_array.g_pe_row\[2\].g_pe_col\[3\].u_pe.move_reg\[10\]
+ sky130_fd_sc_hd__dfrtp_1
XFILLER_0_5_698 VGND VGND VPWR VPWR sky130_fd_sc_hd__decap_6
XFILLER_0_4_153 VPWR VGND VPWR VGND sky130_ef_sc_hd__decap_12
X_5585_ _2289_ u_pe_array.g_pe_row\[1\].g_pe_col\[2\].u_pe.psum_out\[6\] _1597_ VGND
+ VGND VPWR VPWR _2431_ sky130_fd_sc_hd__nand3_2
Xhold300 u_pe_array.g_pe_row\[2\].g_pe_col\[2\].u_pe.move_reg\[6\] VGND VGND VPWR
+ VPWR net374 sky130_fd_sc_hd__dlygate4sd3_1
XFILLER_0_111_640 VPWR VGND VPWR VGND sky130_ef_sc_hd__decap_12
Xhold333 u_pe_array.act_from_right\[2\]\[10\] VGND VGND VPWR VPWR net407 sky130_fd_sc_hd__dlygate4sd3_1
XFILLER_0_4_197 VPWR VGND VPWR VGND sky130_ef_sc_hd__decap_12
Xhold322 u_pe_array.g_pe_row\[2\].g_pe_col\[3\].u_pe.psum_out\[5\] VGND VGND VPWR
+ VPWR net396 sky130_fd_sc_hd__dlygate4sd3_1
XFILLER_0_40_251 VGND VGND VPWR VPWR sky130_fd_sc_hd__fill_1
X_4536_ u_pe_array.g_pe_row\[2\].g_pe_col\[3\].u_pe.act_val\[4\] _1605_ _1611_ net119
+ VGND VGND VPWR VPWR _0224_ sky130_fd_sc_hd__a22o_1
Xhold344 u_pe_array.act_from_up\[4\]\[3\] VGND VGND VPWR VPWR net418 sky130_fd_sc_hd__dlygate4sd3_1
XFILLER_0_111_673 VPWR VGND VPWR VGND sky130_ef_sc_hd__decap_12
X_7255_ clknet_leaf_55_clk _0161_ net946 VGND VGND VPWR VPWR net60 sky130_fd_sc_hd__dfrtp_1
Xhold366 _0028_ VGND VGND VPWR VPWR net440 sky130_fd_sc_hd__dlygate4sd3_1
X_4467_ net866 _1273_ _1567_ _1569_ VGND VGND VPWR VPWR _0200_ sky130_fd_sc_hd__a22o_1
Xhold355 u_pe_array.act_from_up\[14\]\[9\] VGND VGND VPWR VPWR net429 sky130_fd_sc_hd__dlygate4sd3_1
Xhold377 u_pe_array.act_from_right\[10\]\[9\] VGND VGND VPWR VPWR net451 sky130_fd_sc_hd__dlygate4sd3_1
Xhold388 u_pe_array.act_from_right\[8\]\[8\] VGND VGND VPWR VPWR net462 sky130_fd_sc_hd__dlygate4sd3_1
Xhold399 u_pe_array.g_pe_row\[3\].g_pe_col\[1\].u_pe.psum_out\[2\] VGND VGND VPWR
+ VPWR net473 sky130_fd_sc_hd__dlygate4sd3_1
X_6206_ u_pe_array.g_pe_row\[0\].g_pe_col\[3\].u_pe.act_val\[5\] u_pe_array.g_pe_row\[0\].g_pe_col\[3\].u_pe.w_out\[0\]
+ _2903_ VGND VGND VPWR VPWR _2916_ sky130_fd_sc_hd__and3_1
X_4398_ u_pe_array.g_pe_row\[3\].g_pe_col\[0\].u_pe.act_val\[3\] u_pe_array.g_pe_row\[3\].g_pe_col\[0\].u_pe.w_out\[0\]
+ _1287_ _1435_ VGND VGND VPWR VPWR _1506_ sky130_fd_sc_hd__a22o_1
X_7186_ clknet_leaf_97_clk net99 net944 VGND VGND VPWR VPWR u_pe_array.g_pe_row\[3\].g_pe_col\[2\].u_pe.move_reg\[8\]
+ sky130_fd_sc_hd__dfrtp_1
X_6137_ u_pe_array.act_from_down\[3\]\[6\] _2730_ _2511_ net267 VGND VGND VPWR VPWR
+ _0580_ sky130_fd_sc_hd__a22o_1
XTAP_660 VGND VPWR sky130_fd_sc_hd__tapvpwrvgnd_1
XFILLER_0_99_207 VGND VGND VPWR VPWR sky130_fd_sc_hd__fill_1
XTAP_682 VGND VPWR sky130_fd_sc_hd__tapvpwrvgnd_1
XTAP_671 VGND VPWR sky130_fd_sc_hd__tapvpwrvgnd_1
XTAP_693 VGND VPWR sky130_fd_sc_hd__tapvpwrvgnd_1
X_6068_ net883 _2586_ _2814_ _2816_ VGND VGND VPWR VPWR _0554_ sky130_fd_sc_hd__a22o_1
X_5019_ _1980_ _1985_ _1991_ _1994_ _1990_ VGND VGND VPWR VPWR _1995_ sky130_fd_sc_hd__a32o_1
XFILLER_0_76_671 VGND VGND VPWR VPWR sky130_fd_sc_hd__decap_6
XFILLER_0_36_502 VPWR VGND VPWR VGND sky130_ef_sc_hd__decap_12
XFILLER_0_48_384 VGND VGND VPWR VPWR sky130_fd_sc_hd__fill_1
XFILLER_0_8_481 VGND VGND VPWR VPWR sky130_fd_sc_hd__fill_1
XFILLER_0_106_456 VGND VGND VPWR VPWR sky130_fd_sc_hd__decap_4
XFILLER_0_91_685 VPWR VGND VPWR VGND sky130_ef_sc_hd__decap_12
XFILLER_0_23_229 VGND VGND VPWR VPWR sky130_fd_sc_hd__fill_1
XFILLER_0_106_467 VGND VGND VPWR VPWR sky130_fd_sc_hd__fill_1
XFILLER_0_48_19 VGND VGND VPWR VPWR sky130_fd_sc_hd__fill_1
XFILLER_0_101_183 VGND VGND VPWR VPWR sky130_fd_sc_hd__fill_2
XFILLER_0_58_115 VGND VGND VPWR VPWR sky130_fd_sc_hd__fill_1
XFILLER_0_13_55 VGND VGND VPWR VPWR sky130_fd_sc_hd__fill_1
XFILLER_0_27_513 VGND VGND VPWR VPWR sky130_fd_sc_hd__decap_3
XFILLER_0_89_15 VPWR VGND VPWR VGND sky130_ef_sc_hd__decap_12
XFILLER_0_42_527 VGND VGND VPWR VPWR sky130_fd_sc_hd__fill_1
XFILLER_0_112_404 VGND VGND VPWR VPWR sky130_fd_sc_hd__decap_8
XFILLER_0_81_184 VGND VGND VPWR VPWR sky130_fd_sc_hd__decap_4
XFILLER_0_2_613 VPWR VGND VPWR VGND sky130_ef_sc_hd__decap_12
X_5370_ _2250_ _2254_ _2261_ _2263_ _2260_ VGND VGND VPWR VPWR _2264_ sky130_fd_sc_hd__a32o_1
XFILLER_0_2_657 VPWR VGND VPWR VGND sky130_ef_sc_hd__decap_12
XFILLER_0_22_251 VGND VGND VPWR VPWR sky130_fd_sc_hd__fill_1
X_4321_ u_pe_array.g_pe_row\[3\].g_pe_col\[0\].u_pe.move_reg\[10\] net62 VGND VGND
+ VPWR VPWR _1461_ sky130_fd_sc_hd__or2_1
XFILLER_0_1_167 VGND VGND VPWR VPWR sky130_fd_sc_hd__fill_1
XFILLER_0_50_593 VGND VGND VPWR VPWR sky130_fd_sc_hd__fill_1
X_4252_ u_pe_array.g_pe_row\[3\].g_pe_col\[1\].u_pe.psum_out\[10\] _1106_ VGND VGND
+ VPWR VPWR _1407_ sky130_fd_sc_hd__nand2_1
XFILLER_0_10_446 VGND VGND VPWR VPWR sky130_fd_sc_hd__decap_8
X_7040_ _3515_ VGND VGND VPWR VPWR _0827_ sky130_fd_sc_hd__clkbuf_1
X_4183_ u_pe_array.g_pe_row\[3\].g_pe_col\[1\].u_pe.act_val\[3\] VGND VGND VPWR VPWR
+ _1344_ sky130_fd_sc_hd__inv_2
XFILLER_0_38_85 VGND VGND VPWR VPWR sky130_fd_sc_hd__decap_8
X_7942_ clknet_leaf_80_clk _0847_ VGND VGND VPWR VPWR u_pe_array.u_fifo1.buffer\[7\]\[2\]
+ sky130_fd_sc_hd__dfxtp_1
XFILLER_0_77_435 VPWR VGND VPWR VGND sky130_ef_sc_hd__decap_12
X_7873_ clknet_leaf_102_clk _0778_ VGND VGND VPWR VPWR u_pe_array.u_fifo2.buffer\[6\]\[1\]
+ sky130_fd_sc_hd__dfxtp_1
XFILLER_0_49_148 VGND VGND VPWR VPWR sky130_fd_sc_hd__decap_4
XFILLER_0_65_608 VGND VGND VPWR VPWR sky130_fd_sc_hd__fill_1
X_6824_ _3383_ _3386_ _3387_ _3379_ net829 VGND VGND VPWR VPWR _0739_ sky130_fd_sc_hd__a32o_1
X_6755_ u_pe_array.g_pe_row\[0\].g_pe_col\[0\].u_pe.psum_out\[10\] _3324_ _3330_ _3334_
+ VGND VGND VPWR VPWR _3337_ sky130_fd_sc_hd__a2bb2o_1
XFILLER_0_18_513 VGND VGND VPWR VPWR sky130_fd_sc_hd__fill_2
X_3967_ net87 u_fsm.psum_shift_en _1175_ u_pe_array.g_pe_row\[3\].g_pe_col\[2\].u_pe.move_reg\[10\]
+ VGND VGND VPWR VPWR _0094_ sky130_fd_sc_hd__a22o_1
X_5706_ u_pe_array.g_pe_row\[1\].g_pe_col\[1\].u_pe.act_val\[0\] _1728_ VGND VGND
+ VPWR VPWR _2516_ sky130_fd_sc_hd__nand2_1
XFILLER_0_73_652 VGND VGND VPWR VPWR sky130_fd_sc_hd__fill_2
Xclkbuf_leaf_30_clk clknet_3_3__leaf_clk VGND VGND VPWR VPWR clknet_leaf_30_clk sky130_fd_sc_hd__clkbuf_16
X_6686_ _3264_ _3263_ _3274_ _3269_ VGND VGND VPWR VPWR _3275_ sky130_fd_sc_hd__a31o_1
XFILLER_0_5_440 VGND VGND VPWR VPWR sky130_fd_sc_hd__fill_2
X_3898_ u_pe_array.g_pe_row\[3\].g_pe_col\[2\].u_pe.move_reg\[6\] _1118_ VGND VGND
+ VPWR VPWR _1137_ sky130_fd_sc_hd__or2_1
X_5637_ _1597_ u_pe_array.g_pe_row\[1\].g_pe_col\[2\].u_pe.psum_out\[11\] VGND VGND
+ VPWR VPWR _2478_ sky130_fd_sc_hd__and2b_1
X_5568_ _2413_ _2414_ VGND VGND VPWR VPWR _2416_ sky130_fd_sc_hd__nor2_1
Xhold141 _0305_ VGND VGND VPWR VPWR net215 sky130_fd_sc_hd__dlygate4sd3_1
Xhold152 u_pe_array.g_pe_row\[2\].g_pe_col\[1\].u_pe.move_reg\[6\] VGND VGND VPWR
+ VPWR net226 sky130_fd_sc_hd__dlygate4sd3_1
Xhold130 u_pe_array.g_pe_row\[3\].g_pe_col\[0\].u_pe.move_reg\[10\] VGND VGND VPWR
+ VPWR net204 sky130_fd_sc_hd__dlygate4sd3_1
X_4519_ u_pe_array.g_pe_row\[2\].g_pe_col\[3\].u_pe.psum_out\[7\] u_pe_array.g_pe_row\[2\].g_pe_col\[3\].u_pe.move_reg\[7\]
+ _1599_ VGND VGND VPWR VPWR _1608_ sky130_fd_sc_hd__mux2_1
X_7307_ clknet_leaf_5_clk net372 net945 VGND VGND VPWR VPWR u_pe_array.act_from_right\[10\]\[6\]
+ sky130_fd_sc_hd__dfrtp_1
Xhold163 _0665_ VGND VGND VPWR VPWR net237 sky130_fd_sc_hd__dlygate4sd3_1
Xhold174 u_pe_array.g_pe_row\[2\].g_pe_col\[0\].u_pe.move_reg\[11\] VGND VGND VPWR
+ VPWR net248 sky130_fd_sc_hd__dlygate4sd3_1
X_7238_ clknet_leaf_16_clk _0144_ net943 VGND VGND VPWR VPWR u_pe_array.g_pe_row\[3\].g_pe_col\[1\].u_pe.psum_out\[6\]
+ sky130_fd_sc_hd__dfrtp_1
Xhold185 u_pe_array.act_from_right\[2\]\[4\] VGND VGND VPWR VPWR net259 sky130_fd_sc_hd__dlygate4sd3_1
X_5499_ u_pe_array.u_fifo2.buffer\[3\]\[3\] _2331_ _2332_ u_pe_array.u_fifo2.buffer\[2\]\[3\]
+ _2360_ VGND VGND VPWR VPWR _2361_ sky130_fd_sc_hd__a221o_1
Xhold196 _0486_ VGND VGND VPWR VPWR net270 sky130_fd_sc_hd__dlygate4sd3_1
X_7169_ clknet_leaf_106_clk _0075_ net944 VGND VGND VPWR VPWR u_pe_array.act_from_left\[15\]\[4\]
+ sky130_fd_sc_hd__dfrtp_1
Xclkbuf_leaf_97_clk clknet_3_1__leaf_clk VGND VGND VPWR VPWR clknet_leaf_97_clk sky130_fd_sc_hd__clkbuf_16
XTAP_490 VGND VPWR sky130_fd_sc_hd__tapvpwrvgnd_1
XTAP_1623 VGND VPWR sky130_fd_sc_hd__tapvpwrvgnd_1
XTAP_1612 VGND VPWR sky130_fd_sc_hd__tapvpwrvgnd_1
XTAP_1601 VGND VPWR sky130_fd_sc_hd__tapvpwrvgnd_1
XTAP_1656 VGND VPWR sky130_fd_sc_hd__tapvpwrvgnd_1
XTAP_1667 VGND VPWR sky130_fd_sc_hd__tapvpwrvgnd_1
XTAP_1645 VGND VPWR sky130_fd_sc_hd__tapvpwrvgnd_1
XTAP_1634 VGND VPWR sky130_fd_sc_hd__tapvpwrvgnd_1
XFILLER_0_49_660 VPWR VGND VPWR VGND sky130_ef_sc_hd__decap_12
XTAP_1689 VGND VPWR sky130_fd_sc_hd__tapvpwrvgnd_1
XTAP_1678 VGND VPWR sky130_fd_sc_hd__tapvpwrvgnd_1
XFILLER_0_64_652 VPWR VGND VPWR VGND sky130_ef_sc_hd__decap_12
XFILLER_0_91_460 VGND VGND VPWR VPWR sky130_fd_sc_hd__decap_4
Xclkbuf_leaf_21_clk clknet_3_2__leaf_clk VGND VGND VPWR VPWR clknet_leaf_21_clk sky130_fd_sc_hd__clkbuf_16
XFILLER_0_63_173 VGND VGND VPWR VPWR sky130_fd_sc_hd__fill_1
XFILLER_0_24_505 VGND VGND VPWR VPWR sky130_fd_sc_hd__fill_1
XFILLER_0_36_365 VGND VGND VPWR VPWR sky130_fd_sc_hd__decap_8
XFILLER_0_106_253 VPWR VGND VPWR VGND sky130_ef_sc_hd__decap_12
XFILLER_0_106_297 VGND VGND VPWR VPWR sky130_fd_sc_hd__fill_1
Xclkbuf_leaf_88_clk clknet_3_4__leaf_clk VGND VGND VPWR VPWR clknet_leaf_88_clk sky130_fd_sc_hd__clkbuf_16
XFILLER_0_91_49 VGND VGND VPWR VPWR sky130_fd_sc_hd__decap_6
XFILLER_0_115_45 VGND VGND VPWR VPWR sky130_fd_sc_hd__decap_8
XFILLER_0_24_32 VGND VGND VPWR VPWR sky130_fd_sc_hd__decap_8
X_4870_ net465 _1749_ _1873_ _1876_ VGND VGND VPWR VPWR _0296_ sky130_fd_sc_hd__a22o_1
XFILLER_0_74_416 VGND VGND VPWR VPWR sky130_fd_sc_hd__fill_1
XFILLER_0_24_65 VGND VGND VPWR VPWR sky130_fd_sc_hd__decap_8
X_3821_ u_pe_array.g_pe_row\[3\].g_pe_col\[3\].u_pe.psum_out\[8\] _1059_ VGND VGND
+ VPWR VPWR _1073_ sky130_fd_sc_hd__nor2_1
XFILLER_0_46_118 VGND VGND VPWR VPWR sky130_fd_sc_hd__fill_2
XFILLER_0_117_518 VGND VGND VPWR VPWR sky130_fd_sc_hd__decap_4
X_6540_ u_pe_array.g_pe_row\[0\].g_pe_col\[1\].u_pe.act_val\[5\] VGND VGND VPWR VPWR
+ _3168_ sky130_fd_sc_hd__inv_2
XFILLER_0_55_641 VGND VGND VPWR VPWR sky130_fd_sc_hd__decap_4
XFILLER_0_39_181 VGND VGND VPWR VPWR sky130_fd_sc_hd__fill_1
Xclkbuf_leaf_12_clk clknet_3_3__leaf_clk VGND VGND VPWR VPWR clknet_leaf_12_clk sky130_fd_sc_hd__clkbuf_16
X_3752_ _0995_ _1001_ _1008_ VGND VGND VPWR VPWR _1009_ sky130_fd_sc_hd__a21o_1
XFILLER_0_15_505 VGND VGND VPWR VPWR sky130_fd_sc_hd__decap_8
XFILLER_0_42_302 VGND VGND VPWR VPWR sky130_fd_sc_hd__decap_6
X_6471_ net377 _3101_ _2987_ net496 VGND VGND VPWR VPWR _0658_ sky130_fd_sc_hd__a22o_1
X_3683_ u_pe_array.g_pe_row\[3\].g_pe_col\[3\].u_pe.psum_out\[10\] net411 _0947_ VGND
+ VGND VPWR VPWR _0959_ sky130_fd_sc_hd__mux2_1
XFILLER_0_71_7 VGND VGND VPWR VPWR sky130_fd_sc_hd__decap_4
X_5422_ net316 _2303_ _2273_ VGND VGND VPWR VPWR _2304_ sky130_fd_sc_hd__mux2_1
XFILLER_0_2_410 VGND VGND VPWR VPWR sky130_fd_sc_hd__decap_8
XFILLER_0_2_421 VPWR VGND VPWR VGND sky130_ef_sc_hd__decap_12
XFILLER_0_40_97 VGND VGND VPWR VPWR sky130_fd_sc_hd__fill_1
X_5353_ u_pe_array.g_pe_row\[1\].g_pe_col\[3\].u_pe.psum_out\[7\] u_pe_array.g_pe_row\[1\].g_pe_col\[3\].u_pe.psum_out\[8\]
+ _1426_ _2244_ _2245_ VGND VGND VPWR VPWR _2249_ sky130_fd_sc_hd__o2111a_1
XFILLER_0_70_699 VGND VGND VPWR VPWR sky130_fd_sc_hd__fill_1
X_4304_ _1448_ VGND VGND VPWR VPWR _0158_ sky130_fd_sc_hd__clkbuf_1
X_5284_ u_pe_array.g_pe_row\[1\].g_pe_col\[3\].u_pe.act_val\[2\] _2164_ _2184_ _2185_
+ VGND VGND VPWR VPWR _2187_ sky130_fd_sc_hd__o22ai_2
XFILLER_0_10_265 VGND VGND VPWR VPWR sky130_fd_sc_hd__fill_1
X_4235_ u_pe_array.g_pe_row\[3\].g_pe_col\[1\].u_pe.psum_out\[8\] _1106_ VGND VGND
+ VPWR VPWR _1392_ sky130_fd_sc_hd__nand2_1
Xclkbuf_leaf_79_clk clknet_3_5__leaf_clk VGND VGND VPWR VPWR clknet_leaf_79_clk sky130_fd_sc_hd__clkbuf_16
X_7023_ _3505_ VGND VGND VPWR VPWR _0820_ sky130_fd_sc_hd__clkbuf_1
X_4166_ u_pe_array.g_pe_row\[3\].g_pe_col\[1\].u_pe.act_val\[1\] u_pe_array.g_pe_row\[3\].g_pe_col\[1\].u_pe.psum_out\[2\]
+ _1106_ VGND VGND VPWR VPWR _1328_ sky130_fd_sc_hd__and3b_1
XFILLER_0_4_53 VPWR VGND VPWR VGND sky130_ef_sc_hd__decap_12
XFILLER_0_4_97 VPWR VGND VPWR VGND sky130_ef_sc_hd__decap_12
X_4097_ _1288_ VGND VGND VPWR VPWR _0111_ sky130_fd_sc_hd__clkbuf_1
X_7925_ clknet_leaf_76_clk _0830_ VGND VGND VPWR VPWR u_pe_array.u_fifo1.buffer\[4\]\[3\]
+ sky130_fd_sc_hd__dfxtp_1
XFILLER_0_77_243 VGND VGND VPWR VPWR sky130_fd_sc_hd__fill_1
X_7856_ clknet_leaf_86_clk _0761_ VGND VGND VPWR VPWR u_pe_array.u_fifo2.buffer\[3\]\[2\]
+ sky130_fd_sc_hd__dfxtp_1
XFILLER_0_92_213 VGND VGND VPWR VPWR sky130_fd_sc_hd__fill_1
XFILLER_0_81_93 VGND VGND VPWR VPWR sky130_fd_sc_hd__fill_2
XFILLER_0_65_449 VGND VGND VPWR VPWR sky130_fd_sc_hd__decap_4
X_6807_ _3374_ _3375_ VGND VGND VPWR VPWR _0734_ sky130_fd_sc_hd__nor2_1
X_4999_ _1968_ _1971_ _1976_ VGND VGND VPWR VPWR _1978_ sky130_fd_sc_hd__or3_1
X_7787_ clknet_leaf_63_clk _0693_ net74 VGND VGND VPWR VPWR u_pe_array.act_from_up\[4\]\[9\]
+ sky130_fd_sc_hd__dfrtp_1
XFILLER_0_46_641 VGND VGND VPWR VPWR sky130_fd_sc_hd__decap_3
XFILLER_0_116_540 VGND VGND VPWR VPWR sky130_fd_sc_hd__fill_2
X_6738_ _1092_ _3321_ _3322_ _1005_ net714 VGND VGND VPWR VPWR _0718_ sky130_fd_sc_hd__a32o_1
XFILLER_0_18_365 VGND VGND VPWR VPWR sky130_fd_sc_hd__fill_1
XFILLER_0_33_313 VGND VGND VPWR VPWR sky130_fd_sc_hd__decap_6
XFILLER_0_116_551 VGND VGND VPWR VPWR sky130_fd_sc_hd__decap_4
X_6669_ _3255_ _3249_ net65 _3259_ VGND VGND VPWR VPWR _3260_ sky130_fd_sc_hd__a211oi_2
XFILLER_0_61_633 VGND VGND VPWR VPWR sky130_fd_sc_hd__decap_4
XFILLER_0_60_110 VGND VGND VPWR VPWR sky130_fd_sc_hd__decap_6
XFILLER_0_18_398 VGND VGND VPWR VPWR sky130_fd_sc_hd__fill_2
XFILLER_0_33_335 VGND VGND VPWR VPWR sky130_fd_sc_hd__fill_1
XFILLER_0_33_346 VGND VGND VPWR VPWR sky130_fd_sc_hd__decap_6
XFILLER_0_103_212 VPWR VGND VPWR VGND sky130_ef_sc_hd__decap_12
XFILLER_0_103_201 VGND VGND VPWR VPWR sky130_fd_sc_hd__decap_3
XFILLER_0_61_666 VGND VGND VPWR VPWR sky130_fd_sc_hd__decap_6
XFILLER_0_5_281 VGND VGND VPWR VPWR sky130_fd_sc_hd__decap_3
XFILLER_0_60_176 VGND VGND VPWR VPWR sky130_fd_sc_hd__fill_1
XTAP_1442 VGND VPWR sky130_fd_sc_hd__tapvpwrvgnd_1
XTAP_1431 VGND VPWR sky130_fd_sc_hd__tapvpwrvgnd_1
XTAP_1420 VGND VPWR sky130_fd_sc_hd__tapvpwrvgnd_1
XTAP_1475 VGND VPWR sky130_fd_sc_hd__tapvpwrvgnd_1
XTAP_1464 VGND VPWR sky130_fd_sc_hd__tapvpwrvgnd_1
XTAP_1453 VGND VPWR sky130_fd_sc_hd__tapvpwrvgnd_1
XFILLER_0_68_298 VGND VGND VPWR VPWR sky130_fd_sc_hd__decap_3
XFILLER_0_68_276 VGND VGND VPWR VPWR sky130_fd_sc_hd__fill_2
XTAP_1497 VGND VPWR sky130_fd_sc_hd__tapvpwrvgnd_1
XTAP_1486 VGND VPWR sky130_fd_sc_hd__tapvpwrvgnd_1
XFILLER_0_83_268 VGND VGND VPWR VPWR sky130_fd_sc_hd__decap_4
XFILLER_0_24_335 VGND VGND VPWR VPWR sky130_fd_sc_hd__fill_1
XFILLER_0_36_184 VPWR VGND VPWR VGND sky130_ef_sc_hd__decap_12
XFILLER_0_12_519 VPWR VGND VPWR VGND sky130_ef_sc_hd__decap_12
XFILLER_0_101_69 VPWR VGND VPWR VGND sky130_ef_sc_hd__decap_12
XFILLER_0_86_27 VGND VGND VPWR VPWR sky130_fd_sc_hd__fill_1
XFILLER_0_20_530 VGND VGND VPWR VPWR sky130_fd_sc_hd__fill_2
X_4020_ u_pe_array.g_pe_row\[3\].g_pe_col\[2\].u_pe.psum_out\[5\] _1220_ VGND VGND
+ VPWR VPWR _1221_ sky130_fd_sc_hd__xnor2_1
Xclkbuf_leaf_1_clk clknet_3_0__leaf_clk VGND VGND VPWR VPWR clknet_leaf_1_clk sky130_fd_sc_hd__clkbuf_16
X_5971_ u_pe_array.act_from_up\[4\]\[10\] _2730_ _2511_ net224 VGND VGND VPWR VPWR
+ _0543_ sky130_fd_sc_hd__a22o_1
XFILLER_0_59_210 VPWR VGND VPWR VGND sky130_ef_sc_hd__decap_12
X_4922_ u_pe_array.g_pe_row\[2\].g_pe_col\[1\].u_pe.act_val\[2\] VGND VGND VPWR VPWR
+ _1907_ sky130_fd_sc_hd__inv_2
XFILLER_0_59_254 VGND VGND VPWR VPWR sky130_fd_sc_hd__decap_3
X_7710_ clknet_leaf_74_clk net327 net72 VGND VGND VPWR VPWR u_pe_array.g_pe_row\[0\].g_pe_col\[2\].u_pe.act_val\[1\]
+ sky130_fd_sc_hd__dfrtp_4
XFILLER_0_19_107 VGND VGND VPWR VPWR sky130_fd_sc_hd__decap_4
X_7641_ clknet_leaf_70_clk _0547_ net949 VGND VGND VPWR VPWR u_pe_array.g_pe_row\[1\].g_pe_col\[0\].u_pe.psum_out\[1\]
+ sky130_fd_sc_hd__dfrtp_1
X_4853_ _0946_ VGND VGND VPWR VPWR _1867_ sky130_fd_sc_hd__buf_12
X_7572_ clknet_leaf_42_clk _0478_ net946 VGND VGND VPWR VPWR u_pe_array.act_from_down\[1\]\[12\]
+ sky130_fd_sc_hd__dfrtp_1
X_3804_ _1046_ _1048_ VGND VGND VPWR VPWR _1057_ sky130_fd_sc_hd__nor2_1
XFILLER_0_7_557 VGND VGND VPWR VPWR sky130_fd_sc_hd__decap_3
X_4784_ _1805_ _1806_ VGND VGND VPWR VPWR _1807_ sky130_fd_sc_hd__or2_1
X_6523_ u_pe_array.g_pe_row\[0\].g_pe_col\[1\].u_pe.psum_out\[3\] _3138_ _3139_ VGND
+ VGND VPWR VPWR _3153_ sky130_fd_sc_hd__a21boi_1
X_3735_ _0978_ _0992_ _0993_ _0986_ net614 VGND VGND VPWR VPWR _0044_ sky130_fd_sc_hd__a32o_1
X_6454_ net246 _3101_ _2987_ _3108_ VGND VGND VPWR VPWR _0648_ sky130_fd_sc_hd__a22o_1
XFILLER_0_113_510 VGND VGND VPWR VPWR sky130_fd_sc_hd__decap_8
XFILLER_0_43_688 VGND VGND VPWR VPWR sky130_fd_sc_hd__fill_1
XFILLER_0_70_485 VGND VGND VPWR VPWR sky130_fd_sc_hd__fill_1
X_5405_ u_pe_array.g_pe_row\[1\].g_pe_col\[2\].u_pe.psum_out\[5\] _1108_ _1110_ _2290_
+ VGND VGND VPWR VPWR _2291_ sky130_fd_sc_hd__o211a_1
X_3666_ net125 _0949_ _0944_ _0950_ VGND VGND VPWR VPWR _0018_ sky130_fd_sc_hd__a22o_1
X_6385_ net769 _2586_ _3053_ _0978_ VGND VGND VPWR VPWR _0634_ sky130_fd_sc_hd__a22o_1
XFILLER_0_2_251 VGND VGND VPWR VPWR sky130_fd_sc_hd__fill_1
X_3597_ _0868_ _0895_ _0896_ VGND VGND VPWR VPWR _0897_ sky130_fd_sc_hd__or3b_1
X_5336_ _2220_ _2230_ VGND VGND VPWR VPWR _2234_ sky130_fd_sc_hd__or2b_1
X_5267_ u_pe_array.g_pe_row\[1\].g_pe_col\[3\].u_pe.act_val\[0\] _2164_ _2170_ _2171_
+ VGND VGND VPWR VPWR _2172_ sky130_fd_sc_hd__a2bb2o_1
XFILLER_0_76_93 VGND VGND VPWR VPWR sky130_fd_sc_hd__fill_2
X_4218_ _1374_ _1376_ VGND VGND VPWR VPWR _1377_ sky130_fd_sc_hd__xnor2_1
X_7006_ net743 _3360_ _3491_ VGND VGND VPWR VPWR _3496_ sky130_fd_sc_hd__mux2_1
X_5198_ _2130_ _1597_ _0931_ VGND VGND VPWR VPWR _2131_ sky130_fd_sc_hd__mux2_1
XFILLER_0_97_316 VGND VGND VPWR VPWR sky130_fd_sc_hd__fill_2
X_4149_ u_pe_array.g_pe_row\[3\].g_pe_col\[1\].u_pe.act_val\[0\] _1106_ u_pe_array.g_pe_row\[3\].g_pe_col\[1\].u_pe.psum_out\[1\]
+ VGND VGND VPWR VPWR _1313_ sky130_fd_sc_hd__a21oi_1
X_7908_ clknet_leaf_82_clk _0813_ VGND VGND VPWR VPWR u_pe_array.u_fifo1.buffer\[1\]\[4\]
+ sky130_fd_sc_hd__dfxtp_1
XFILLER_0_38_427 VGND VGND VPWR VPWR sky130_fd_sc_hd__fill_2
X_7839_ clknet_leaf_88_clk _0744_ VGND VGND VPWR VPWR u_pe_array.u_fifo2.buffer\[0\]\[3\]
+ sky130_fd_sc_hd__dfxtp_1
XFILLER_0_108_359 VGND VGND VPWR VPWR sky130_fd_sc_hd__decap_4
XFILLER_0_34_677 VPWR VGND VPWR VGND sky130_ef_sc_hd__decap_12
Xload_slew12 net71 VGND VGND VPWR VPWR net951 sky130_fd_sc_hd__buf_12
XFILLER_0_72_29 VGND VGND VPWR VPWR sky130_fd_sc_hd__decap_4
XTAP_1250 VGND VPWR sky130_fd_sc_hd__tapvpwrvgnd_1
XFILLER_0_84_533 VGND VGND VPWR VPWR sky130_fd_sc_hd__decap_4
XTAP_1283 VGND VPWR sky130_fd_sc_hd__tapvpwrvgnd_1
XTAP_1272 VGND VPWR sky130_fd_sc_hd__tapvpwrvgnd_1
XTAP_1261 VGND VPWR sky130_fd_sc_hd__tapvpwrvgnd_1
XTAP_1294 VGND VPWR sky130_fd_sc_hd__tapvpwrvgnd_1
XFILLER_0_71_205 VGND VGND VPWR VPWR sky130_fd_sc_hd__decap_4
XFILLER_0_21_11 VPWR VGND VPWR VGND sky130_ef_sc_hd__decap_12
XFILLER_0_24_121 VPWR VGND VPWR VGND sky130_ef_sc_hd__decap_12
XFILLER_0_114_329 VGND VGND VPWR VPWR sky130_fd_sc_hd__decap_8
Xhold707 net37 VGND VGND VPWR VPWR net781 sky130_fd_sc_hd__dlygate4sd3_1
Xhold718 net46 VGND VGND VPWR VPWR net792 sky130_fd_sc_hd__dlygate4sd3_1
XFILLER_0_21_99 VGND VGND VPWR VPWR sky130_fd_sc_hd__decap_6
XFILLER_0_52_474 VGND VGND VPWR VPWR sky130_fd_sc_hd__fill_2
Xhold729 u_pe_array.g_pe_row\[3\].g_pe_col\[0\].u_pe.act_val\[3\] VGND VGND VPWR VPWR
+ net803 sky130_fd_sc_hd__dlygate4sd3_1
X_6170_ _2881_ u_pe_array.g_pe_row\[0\].g_pe_col\[3\].u_pe.act_val\[3\] u_pe_array.g_pe_row\[0\].g_pe_col\[3\].u_pe.w_out\[0\]
+ _1999_ VGND VGND VPWR VPWR _2883_ sky130_fd_sc_hd__nand4_1
X_5121_ u_pe_array.g_pe_row\[2\].g_pe_col\[0\].u_pe.act_val\[5\] _1284_ VGND VGND
+ VPWR VPWR _2063_ sky130_fd_sc_hd__nand2_1
X_5052_ u_pe_array.g_pe_row\[2\].g_pe_col\[0\].u_pe.psum_out\[11\] u_pe_array.g_pe_row\[2\].g_pe_col\[0\].u_pe.move_reg\[11\]
+ _1867_ VGND VGND VPWR VPWR _2014_ sky130_fd_sc_hd__mux2_1
X_4003_ _1033_ _1204_ _1205_ _0986_ net585 VGND VGND VPWR VPWR _0100_ sky130_fd_sc_hd__a32o_1
X_5954_ u_pe_array.u_fifo1.buffer\[4\]\[4\] _2680_ _2717_ _2719_ VGND VGND VPWR VPWR
+ _2720_ sky130_fd_sc_hd__a211o_1
X_5885_ _2668_ VGND VGND VPWR VPWR _0519_ sky130_fd_sc_hd__clkbuf_1
X_4905_ u_pe_array.g_pe_row\[2\].g_pe_col\[1\].u_pe.psum_out\[1\] _1891_ VGND VGND
+ VPWR VPWR _1892_ sky130_fd_sc_hd__or2_1
XFILLER_0_118_657 VPWR VGND VPWR VGND sky130_ef_sc_hd__decap_12
X_7624_ clknet_leaf_39_clk _0530_ net947 VGND VGND VPWR VPWR u_pe_array.act_from_left\[5\]\[10\]
+ sky130_fd_sc_hd__dfrtp_1
X_4836_ u_pe_array.g_pe_row\[2\].g_pe_col\[2\].u_pe.psum_out\[11\] _0933_ VGND VGND
+ VPWR VPWR _1854_ sky130_fd_sc_hd__and2b_1
XFILLER_0_47_279 VGND VGND VPWR VPWR sky130_fd_sc_hd__fill_1
XFILLER_0_62_238 VPWR VGND VPWR VGND sky130_ef_sc_hd__decap_12
X_7555_ clknet_leaf_69_clk _0461_ net949 VGND VGND VPWR VPWR u_pe_array.g_pe_row\[1\].g_pe_col\[2\].u_pe.psum_out\[10\]
+ sky130_fd_sc_hd__dfrtp_2
XFILLER_0_117_189 VGND VGND VPWR VPWR sky130_fd_sc_hd__decap_8
X_6506_ u_pe_array.g_pe_row\[0\].g_pe_col\[1\].u_pe.act_val\[2\] VGND VGND VPWR VPWR
+ _3137_ sky130_fd_sc_hd__inv_2
X_4767_ _1783_ _1791_ VGND VGND VPWR VPWR _1792_ sky130_fd_sc_hd__nor2_1
X_3718_ _0977_ VGND VGND VPWR VPWR _0978_ sky130_fd_sc_hd__clkbuf_16
X_7486_ clknet_leaf_41_clk _0392_ net947 VGND VGND VPWR VPWR u_pe_array.g_pe_row\[1\].g_pe_col\[3\].u_pe.move_reg\[8\]
+ sky130_fd_sc_hd__dfrtp_1
X_4698_ net98 _1732_ _1735_ net413 VGND VGND VPWR VPWR _0256_ sky130_fd_sc_hd__a22o_1
X_6437_ net27 _2486_ _0930_ VGND VGND VPWR VPWR _3099_ sky130_fd_sc_hd__mux2_1
XFILLER_0_113_373 VGND VGND VPWR VPWR sky130_fd_sc_hd__fill_2
X_3649_ _0935_ VGND VGND VPWR VPWR _0016_ sky130_fd_sc_hd__clkbuf_1
X_6368_ _3023_ _3033_ _3037_ VGND VGND VPWR VPWR _3038_ sky130_fd_sc_hd__o21a_1
X_5319_ _2216_ _2217_ _2215_ _2206_ VGND VGND VPWR VPWR _2219_ sky130_fd_sc_hd__o211a_1
XFILLER_0_11_393 VGND VGND VPWR VPWR sky130_fd_sc_hd__fill_2
XFILLER_0_11_371 VGND VGND VPWR VPWR sky130_fd_sc_hd__decap_8
Xhold12 _0306_ VGND VGND VPWR VPWR net86 sky130_fd_sc_hd__dlygate4sd3_1
Xhold23 u_pe_array.act_from_right\[8\]\[0\] VGND VGND VPWR VPWR net97 sky130_fd_sc_hd__dlygate4sd3_1
X_6299_ u_pe_array.g_pe_row\[0\].g_pe_col\[2\].u_pe.act_val\[0\] _2853_ _2847_ net192
+ VGND VGND VPWR VPWR _0615_ sky130_fd_sc_hd__a22o_1
Xhold34 u_pe_array.act_from_up\[6\]\[11\] VGND VGND VPWR VPWR net108 sky130_fd_sc_hd__dlygate4sd3_1
Xhold45 u_pe_array.act_from_down\[11\]\[4\] VGND VGND VPWR VPWR net119 sky130_fd_sc_hd__buf_1
Xhold56 u_pe_array.act_from_left\[5\]\[11\] VGND VGND VPWR VPWR net130 sky130_fd_sc_hd__dlygate4sd3_1
Xhold78 _0582_ VGND VGND VPWR VPWR net152 sky130_fd_sc_hd__dlygate4sd3_1
Xhold67 u_pe_array.act_from_left\[5\]\[7\] VGND VGND VPWR VPWR net141 sky130_fd_sc_hd__dlygate4sd3_1
Xhold89 _0222_ VGND VGND VPWR VPWR net163 sky130_fd_sc_hd__dlygate4sd3_1
XFILLER_0_78_382 VPWR VGND VPWR VGND sky130_ef_sc_hd__decap_12
XFILLER_0_66_533 VGND VGND VPWR VPWR sky130_fd_sc_hd__decap_8
XFILLER_0_108_167 VGND VGND VPWR VPWR sky130_fd_sc_hd__fill_2
XFILLER_0_19_482 VGND VGND VPWR VPWR sky130_fd_sc_hd__fill_2
XFILLER_0_53_216 VGND VGND VPWR VPWR sky130_fd_sc_hd__decap_4
XFILLER_0_34_474 VGND VGND VPWR VPWR sky130_fd_sc_hd__fill_2
XANTENNA_9 net21 VGND VGND VPWR VPWR sky130_fd_sc_hd__diode_2
XFILLER_0_104_362 VGND VGND VPWR VPWR sky130_fd_sc_hd__fill_2
XFILLER_0_21_113 VPWR VGND VPWR VGND sky130_ef_sc_hd__decap_12
XTAP_319 VGND VPWR sky130_fd_sc_hd__tapvpwrvgnd_1
XTAP_308 VGND VPWR sky130_fd_sc_hd__tapvpwrvgnd_1
XFILLER_0_89_614 VGND VGND VPWR VPWR sky130_fd_sc_hd__fill_2
XFILLER_0_107_57 VPWR VGND VPWR VGND sky130_ef_sc_hd__decap_12
XFILLER_0_89_636 VPWR VGND VPWR VGND sky130_ef_sc_hd__decap_12
XFILLER_0_89_625 VGND VGND VPWR VPWR sky130_fd_sc_hd__decap_3
XFILLER_0_88_124 VGND VGND VPWR VPWR sky130_fd_sc_hd__decap_8
XFILLER_0_69_393 VGND VGND VPWR VPWR sky130_fd_sc_hd__fill_2
XFILLER_0_84_363 VGND VGND VPWR VPWR sky130_fd_sc_hd__fill_1
X_5670_ _0938_ VGND VGND VPWR VPWR _2499_ sky130_fd_sc_hd__clkbuf_8
XTAP_1080 VGND VPWR sky130_fd_sc_hd__tapvpwrvgnd_1
XTAP_1091 VGND VPWR sky130_fd_sc_hd__tapvpwrvgnd_1
XFILLER_0_29_257 VPWR VGND VPWR VGND sky130_ef_sc_hd__decap_12
X_4621_ u_pe_array.g_pe_row\[2\].g_pe_col\[3\].u_pe.psum_out\[7\] _1427_ VGND VGND
+ VPWR VPWR _1684_ sky130_fd_sc_hd__or2_1
XFILLER_0_96_9 VGND VGND VPWR VPWR sky130_fd_sc_hd__decap_3
X_7340_ clknet_leaf_26_clk _0246_ net943 VGND VGND VPWR VPWR u_pe_array.g_pe_row\[2\].g_pe_col\[1\].u_pe.w_out\[0\]
+ sky130_fd_sc_hd__dfrtp_4
XFILLER_0_4_335 VGND VGND VPWR VPWR sky130_fd_sc_hd__decap_4
X_4552_ u_pe_array.g_pe_row\[2\].g_pe_col\[3\].u_pe.act_val\[1\] _1424_ _1619_ _1620_
+ VGND VGND VPWR VPWR _1621_ sky130_fd_sc_hd__nand4_1
Xhold504 u_pe_array.act_from_up\[14\]\[4\] VGND VGND VPWR VPWR net578 sky130_fd_sc_hd__dlygate4sd3_1
Xhold526 u_pe_array.u_fifo1.buffer\[7\]\[4\] VGND VGND VPWR VPWR net600 sky130_fd_sc_hd__dlygate4sd3_1
Xhold515 u_pe_array.u_fifo1.buffer\[6\]\[0\] VGND VGND VPWR VPWR net589 sky130_fd_sc_hd__dlygate4sd3_1
X_7271_ clknet_leaf_98_clk _0177_ net951 VGND VGND VPWR VPWR u_pe_array.act_from_left\[13\]\[11\]
+ sky130_fd_sc_hd__dfrtp_1
X_4483_ _1577_ _1582_ _1092_ VGND VGND VPWR VPWR _1584_ sky130_fd_sc_hd__o21ai_1
X_6222_ _2930_ u_pe_array.g_pe_row\[0\].g_pe_col\[3\].u_pe.psum_out\[7\] _2913_ VGND
+ VGND VPWR VPWR _2931_ sky130_fd_sc_hd__mux2_1
Xhold537 u_pe_array.u_fifo2.buffer\[2\]\[3\] VGND VGND VPWR VPWR net611 sky130_fd_sc_hd__dlygate4sd3_1
Xhold548 u_pe_array.u_fifo1.wr_ptr\[2\] VGND VGND VPWR VPWR net622 sky130_fd_sc_hd__dlygate4sd3_1
XFILLER_0_40_477 VGND VGND VPWR VPWR sky130_fd_sc_hd__decap_4
Xhold559 u_pe_array.g_pe_row\[1\].g_pe_col\[0\].u_pe.act_val\[4\] VGND VGND VPWR VPWR
+ net633 sky130_fd_sc_hd__dlygate4sd3_1
XFILLER_0_110_365 VGND VGND VPWR VPWR sky130_fd_sc_hd__decap_8
XFILLER_0_110_343 VGND VGND VPWR VPWR sky130_fd_sc_hd__fill_1
X_6153_ u_pe_array.g_pe_row\[0\].g_pe_col\[3\].u_pe.psum_out\[1\] _2866_ VGND VGND
+ VPWR VPWR _2868_ sky130_fd_sc_hd__nand2_1
XFILLER_0_0_585 VGND VGND VPWR VPWR sky130_fd_sc_hd__decap_3
XTAP_820 VGND VPWR sky130_fd_sc_hd__tapvpwrvgnd_1
XTAP_842 VGND VPWR sky130_fd_sc_hd__tapvpwrvgnd_1
XTAP_831 VGND VPWR sky130_fd_sc_hd__tapvpwrvgnd_1
XTAP_853 VGND VPWR sky130_fd_sc_hd__tapvpwrvgnd_1
X_5104_ _2046_ _2042_ _2044_ VGND VGND VPWR VPWR _2048_ sky130_fd_sc_hd__or3_1
X_6084_ _2824_ _2829_ _1092_ VGND VGND VPWR VPWR _2831_ sky130_fd_sc_hd__o21ai_1
XTAP_864 VGND VPWR sky130_fd_sc_hd__tapvpwrvgnd_1
XTAP_875 VGND VPWR sky130_fd_sc_hd__tapvpwrvgnd_1
XTAP_886 VGND VPWR sky130_fd_sc_hd__tapvpwrvgnd_1
X_5035_ net848 _1732_ _1735_ _2004_ VGND VGND VPWR VPWR _0333_ sky130_fd_sc_hd__a22o_1
XTAP_897 VGND VPWR sky130_fd_sc_hd__tapvpwrvgnd_1
XFILLER_0_95_617 VGND VGND VPWR VPWR sky130_fd_sc_hd__decap_3
XFILLER_0_94_105 VGND VGND VPWR VPWR sky130_fd_sc_hd__fill_1
X_6986_ _3485_ VGND VGND VPWR VPWR _0803_ sky130_fd_sc_hd__clkbuf_1
XFILLER_0_94_138 VGND VGND VPWR VPWR sky130_fd_sc_hd__fill_2
X_5937_ u_pe_array.u_fifo1.buffer\[3\]\[2\] _2685_ _2686_ u_pe_array.u_fifo1.buffer\[2\]\[2\]
+ _2704_ VGND VGND VPWR VPWR _2705_ sky130_fd_sc_hd__a221o_1
XFILLER_0_48_555 VGND VGND VPWR VPWR sky130_fd_sc_hd__fill_1
XFILLER_0_118_421 VPWR VGND VPWR VGND sky130_ef_sc_hd__decap_12
XFILLER_0_118_443 VGND VGND VPWR VPWR sky130_fd_sc_hd__decap_4
X_5868_ net837 _2655_ _2273_ VGND VGND VPWR VPWR _2656_ sky130_fd_sc_hd__mux2_1
X_7607_ clknet_leaf_94_clk _0513_ net951 VGND VGND VPWR VPWR net45 sky130_fd_sc_hd__dfrtp_2
X_5799_ u_pe_array.g_pe_row\[1\].g_pe_col\[1\].u_pe.psum_out\[9\] _1728_ VGND VGND
+ VPWR VPWR _2601_ sky130_fd_sc_hd__or2_1
X_4819_ u_pe_array.g_pe_row\[2\].g_pe_col\[2\].u_pe.psum_out\[9\] _0933_ VGND VGND
+ VPWR VPWR _1839_ sky130_fd_sc_hd__nand2_1
XFILLER_0_105_137 VGND VGND VPWR VPWR sky130_fd_sc_hd__decap_8
X_7538_ clknet_leaf_68_clk net191 net72 VGND VGND VPWR VPWR u_pe_array.g_pe_row\[1\].g_pe_col\[2\].u_pe.move_reg\[6\]
+ sky130_fd_sc_hd__dfrtp_1
XFILLER_0_16_474 VGND VGND VPWR VPWR sky130_fd_sc_hd__fill_2
X_7469_ clknet_leaf_65_clk _0375_ net946 VGND VGND VPWR VPWR u_pe_array.act_from_down\[3\]\[4\]
+ sky130_fd_sc_hd__dfrtp_1
XFILLER_0_43_293 VGND VGND VPWR VPWR sky130_fd_sc_hd__decap_8
XFILLER_0_114_693 VGND VGND VPWR VPWR sky130_fd_sc_hd__decap_6
Xoutput46 net46 VGND VGND VPWR VPWR psum_out0[7] sky130_fd_sc_hd__clkbuf_4
Xoutput35 net35 VGND VGND VPWR VPWR done sky130_fd_sc_hd__buf_2
Xoutput57 net57 VGND VGND VPWR VPWR psum_out1[5] sky130_fd_sc_hd__buf_2
XFILLER_0_98_444 VGND VGND VPWR VPWR sky130_fd_sc_hd__decap_8
XFILLER_0_39_533 VPWR VGND VPWR VGND sky130_ef_sc_hd__decap_12
XPHY_152 VGND VGND VPWR VPWR sky130_fd_sc_hd__decap_3
XPHY_141 VGND VGND VPWR VPWR sky130_fd_sc_hd__decap_3
XFILLER_0_66_363 VGND VGND VPWR VPWR sky130_fd_sc_hd__fill_1
XPHY_130 VGND VGND VPWR VPWR sky130_fd_sc_hd__decap_3
XPHY_185 VGND VGND VPWR VPWR sky130_fd_sc_hd__decap_3
XPHY_174 VGND VGND VPWR VPWR sky130_fd_sc_hd__decap_3
XPHY_163 VGND VGND VPWR VPWR sky130_fd_sc_hd__decap_3
XFILLER_0_54_547 VGND VGND VPWR VPWR sky130_fd_sc_hd__fill_1
XFILLER_0_26_205 VGND VGND VPWR VPWR sky130_fd_sc_hd__decap_3
XPHY_196 VGND VGND VPWR VPWR sky130_fd_sc_hd__decap_3
XFILLER_0_81_344 VGND VGND VPWR VPWR sky130_fd_sc_hd__fill_1
Xclkbuf_3_1__f_clk clknet_0_clk VGND VGND VPWR VPWR clknet_3_1__leaf_clk sky130_fd_sc_hd__clkbuf_16
XFILLER_0_105_671 VGND VGND VPWR VPWR sky130_fd_sc_hd__fill_1
XFILLER_0_22_433 VGND VGND VPWR VPWR sky130_fd_sc_hd__fill_1
XFILLER_0_104_181 VGND VGND VPWR VPWR sky130_fd_sc_hd__fill_1
XFILLER_0_22_477 VGND VGND VPWR VPWR sky130_fd_sc_hd__decap_6
XFILLER_0_22_488 VGND VGND VPWR VPWR sky130_fd_sc_hd__fill_2
XFILLER_0_94_27 VGND VGND VPWR VPWR sky130_fd_sc_hd__fill_1
XFILLER_0_89_411 VGND VGND VPWR VPWR sky130_fd_sc_hd__decap_4
XFILLER_0_89_444 VGND VGND VPWR VPWR sky130_fd_sc_hd__decap_4
XFILLER_0_89_477 VGND VGND VPWR VPWR sky130_fd_sc_hd__decap_4
X_6840_ _3397_ VGND VGND VPWR VPWR _0745_ sky130_fd_sc_hd__clkbuf_1
XFILLER_0_9_405 VPWR VGND VPWR VGND sky130_ef_sc_hd__decap_12
X_6771_ u_pe_array.u_fifo1.wr_ptr\[2\] u_pe_array.u_fifo1.wr_ptr\[3\] _3349_ _3350_
+ VGND VGND VPWR VPWR _3351_ sky130_fd_sc_hd__nand4b_2
X_5722_ _2529_ _2530_ net603 _1006_ VGND VGND VPWR VPWR _0494_ sky130_fd_sc_hd__a2bb2o_1
XFILLER_0_85_650 VGND VGND VPWR VPWR sky130_fd_sc_hd__fill_1
X_3983_ _1184_ _1186_ VGND VGND VPWR VPWR _1187_ sky130_fd_sc_hd__xnor2_1
XFILLER_0_84_171 VGND VGND VPWR VPWR sky130_fd_sc_hd__fill_1
X_5653_ net516 u_pe_array.g_pe_row\[1\].g_pe_col\[1\].u_pe.act_val\[0\] _2133_ VGND
+ VGND VPWR VPWR _2490_ sky130_fd_sc_hd__mux2_1
XFILLER_0_4_121 VPWR VGND VPWR VGND sky130_ef_sc_hd__decap_12
X_4604_ _1667_ _1668_ VGND VGND VPWR VPWR _1669_ sky130_fd_sc_hd__xnor2_1
X_5584_ net887 _1904_ _2430_ _1726_ VGND VGND VPWR VPWR _0456_ sky130_fd_sc_hd__a22o_1
X_7323_ clknet_leaf_18_clk _0229_ net943 VGND VGND VPWR VPWR u_pe_array.g_pe_row\[2\].g_pe_col\[3\].u_pe.move_reg\[9\]
+ sky130_fd_sc_hd__dfrtp_1
XFILLER_0_4_165 VPWR VGND VPWR VGND sky130_ef_sc_hd__decap_12
Xhold301 u_pe_array.g_pe_row\[2\].g_pe_col\[2\].u_pe.move_reg\[7\] VGND VGND VPWR
+ VPWR net375 sky130_fd_sc_hd__dlygate4sd3_1
X_4535_ u_pe_array.g_pe_row\[2\].g_pe_col\[3\].u_pe.act_val\[3\] _1605_ _1611_ net321
+ VGND VGND VPWR VPWR _0223_ sky130_fd_sc_hd__a22o_1
Xhold312 _0312_ VGND VGND VPWR VPWR net386 sky130_fd_sc_hd__dlygate4sd3_1
Xhold334 _0625_ VGND VGND VPWR VPWR net408 sky130_fd_sc_hd__dlygate4sd3_1
Xhold323 u_pe_array.g_pe_row\[2\].g_pe_col\[3\].u_pe.move_reg\[12\] VGND VGND VPWR
+ VPWR net397 sky130_fd_sc_hd__dlygate4sd3_1
X_7254_ clknet_leaf_26_clk _0160_ net943 VGND VGND VPWR VPWR net59 sky130_fd_sc_hd__dfrtp_1
XFILLER_0_111_652 VPWR VGND VPWR VGND sky130_ef_sc_hd__decap_12
Xhold345 u_pe_array.act_from_down\[3\]\[2\] VGND VGND VPWR VPWR net419 sky130_fd_sc_hd__buf_1
Xhold378 u_pe_array.act_from_right\[2\]\[9\] VGND VGND VPWR VPWR net452 sky130_fd_sc_hd__dlygate4sd3_1
Xhold367 u_pe_array.act_from_down\[11\]\[7\] VGND VGND VPWR VPWR net441 sky130_fd_sc_hd__dlygate4sd3_1
Xhold356 _0257_ VGND VGND VPWR VPWR net430 sky130_fd_sc_hd__dlygate4sd3_1
X_4466_ _1003_ _1568_ VGND VGND VPWR VPWR _1569_ sky130_fd_sc_hd__nor2_1
XFILLER_0_111_685 VPWR VGND VPWR VGND sky130_ef_sc_hd__decap_12
XFILLER_0_110_162 VGND VGND VPWR VPWR sky130_fd_sc_hd__decap_8
Xhold389 u_pe_array.g_pe_row\[3\].g_pe_col\[1\].u_pe.psum_out\[0\] VGND VGND VPWR
+ VPWR net463 sky130_fd_sc_hd__dlygate4sd3_1
X_6205_ _2913_ _2914_ VGND VGND VPWR VPWR _2915_ sky130_fd_sc_hd__or2_1
X_4397_ _1495_ _1501_ _1504_ VGND VGND VPWR VPWR _1505_ sky130_fd_sc_hd__a21o_1
X_7185_ clknet_leaf_97_clk net101 net945 VGND VGND VPWR VPWR u_pe_array.g_pe_row\[3\].g_pe_col\[2\].u_pe.move_reg\[7\]
+ sky130_fd_sc_hd__dfrtp_1
XFILLER_0_110_195 VGND VGND VPWR VPWR sky130_fd_sc_hd__fill_1
X_6136_ u_pe_array.g_pe_row\[0\].g_pe_col\[3\].u_pe.act_val\[5\] _2853_ _2847_ net526
+ VGND VGND VPWR VPWR _0579_ sky130_fd_sc_hd__a22o_1
XFILLER_0_0_393 VPWR VGND VPWR VGND sky130_ef_sc_hd__decap_12
XTAP_650 VGND VPWR sky130_fd_sc_hd__tapvpwrvgnd_1
XTAP_661 VGND VPWR sky130_fd_sc_hd__tapvpwrvgnd_1
XTAP_683 VGND VPWR sky130_fd_sc_hd__tapvpwrvgnd_1
XTAP_672 VGND VPWR sky130_fd_sc_hd__tapvpwrvgnd_1
XTAP_694 VGND VPWR sky130_fd_sc_hd__tapvpwrvgnd_1
X_6067_ _1003_ _2815_ VGND VGND VPWR VPWR _2816_ sky130_fd_sc_hd__nor2_1
X_5018_ u_pe_array.g_pe_row\[2\].g_pe_col\[1\].u_pe.psum_out\[9\] u_pe_array.g_pe_row\[2\].g_pe_col\[1\].u_pe.psum_out\[10\]
+ _1105_ VGND VGND VPWR VPWR _1994_ sky130_fd_sc_hd__o21a_1
X_6969_ u_pe_array.u_fifo1.count\[2\] VGND VGND VPWR VPWR _3473_ sky130_fd_sc_hd__inv_2
XFILLER_0_48_363 VGND VGND VPWR VPWR sky130_fd_sc_hd__fill_1
XFILLER_0_75_160 VGND VGND VPWR VPWR sky130_fd_sc_hd__decap_3
XFILLER_0_36_514 VGND VGND VPWR VPWR sky130_fd_sc_hd__decap_4
XFILLER_0_118_251 VGND VGND VPWR VPWR sky130_fd_sc_hd__fill_1
XFILLER_0_91_642 VPWR VGND VPWR VGND sky130_ef_sc_hd__decap_12
XFILLER_0_90_141 VGND VGND VPWR VPWR sky130_fd_sc_hd__decap_3
XFILLER_0_91_697 VGND VGND VPWR VPWR sky130_fd_sc_hd__decap_4
XFILLER_0_98_230 VGND VGND VPWR VPWR sky130_fd_sc_hd__fill_2
XFILLER_0_59_617 VGND VGND VPWR VPWR sky130_fd_sc_hd__decap_8
XFILLER_0_98_285 VGND VGND VPWR VPWR sky130_fd_sc_hd__fill_1
XFILLER_0_80_29 VGND VGND VPWR VPWR sky130_fd_sc_hd__fill_1
XFILLER_0_80_18 VGND VGND VPWR VPWR sky130_fd_sc_hd__fill_1
XFILLER_0_39_363 VGND VGND VPWR VPWR sky130_fd_sc_hd__decap_8
XFILLER_0_89_27 VGND VGND VPWR VPWR sky130_fd_sc_hd__decap_3
XFILLER_0_81_163 VGND VGND VPWR VPWR sky130_fd_sc_hd__decap_4
XFILLER_0_1_113 VPWR VGND VPWR VGND sky130_ef_sc_hd__decap_12
XFILLER_0_2_625 VPWR VGND VPWR VGND sky130_ef_sc_hd__decap_12
X_4320_ _1460_ VGND VGND VPWR VPWR _0162_ sky130_fd_sc_hd__clkbuf_1
XFILLER_0_2_669 VPWR VGND VPWR VGND sky130_ef_sc_hd__decap_12
X_4251_ _1399_ _1400_ _1405_ _1402_ _1397_ VGND VGND VPWR VPWR _1406_ sky130_fd_sc_hd__a32o_1
X_4182_ u_pe_array.g_pe_row\[3\].g_pe_col\[1\].u_pe.act_val\[4\] u_pe_array.g_pe_row\[3\].g_pe_col\[1\].u_pe.w_out\[0\]
+ VGND VGND VPWR VPWR _1343_ sky130_fd_sc_hd__nand2_1
X_7941_ clknet_leaf_81_clk _0846_ VGND VGND VPWR VPWR u_pe_array.u_fifo1.buffer\[7\]\[1\]
+ sky130_fd_sc_hd__dfxtp_1
X_7872_ clknet_leaf_102_clk _0777_ VGND VGND VPWR VPWR u_pe_array.u_fifo2.buffer\[6\]\[0\]
+ sky130_fd_sc_hd__dfxtp_1
XFILLER_0_77_447 VGND VGND VPWR VPWR sky130_fd_sc_hd__fill_1
XFILLER_0_77_458 VGND VGND VPWR VPWR sky130_fd_sc_hd__fill_2
X_6823_ u_pe_array.u_fifo2.count\[0\] _3385_ u_pe_array.u_fifo2.count\[2\] VGND VGND
+ VPWR VPWR _3387_ sky130_fd_sc_hd__a21o_1
X_6754_ _1092_ _3335_ _3336_ _1005_ net904 VGND VGND VPWR VPWR _0720_ sky130_fd_sc_hd__a32o_1
XFILLER_0_58_672 VGND VGND VPWR VPWR sky130_fd_sc_hd__fill_1
XFILLER_0_9_257 VGND VGND VPWR VPWR sky130_fd_sc_hd__fill_1
X_3966_ u_pe_array.act_from_up\[14\]\[9\] u_fsm.psum_shift_en _1175_ net394 VGND VGND
+ VPWR VPWR _0093_ sky130_fd_sc_hd__a22o_1
X_5705_ u_pe_array.g_pe_row\[1\].g_pe_col\[1\].u_pe.act_val\[1\] u_pe_array.g_pe_row\[1\].g_pe_col\[1\].u_pe.w_out\[0\]
+ VGND VGND VPWR VPWR _2515_ sky130_fd_sc_hd__nand2_1
X_6685_ _3270_ VGND VGND VPWR VPWR _3274_ sky130_fd_sc_hd__inv_2
XFILLER_0_92_3 VPWR VGND VPWR VGND sky130_ef_sc_hd__decap_12
XFILLER_0_72_141 VGND VGND VPWR VPWR sky130_fd_sc_hd__decap_8
X_3897_ _1136_ VGND VGND VPWR VPWR _0063_ sky130_fd_sc_hd__clkbuf_1
X_5636_ u_pe_array.g_pe_row\[1\].g_pe_col\[2\].u_pe.psum_out\[11\] _1597_ VGND VGND
+ VPWR VPWR _2477_ sky130_fd_sc_hd__and2b_1
XFILLER_0_45_399 VPWR VGND VPWR VGND sky130_ef_sc_hd__decap_12
X_5567_ _2413_ _2414_ VGND VGND VPWR VPWR _2415_ sky130_fd_sc_hd__and2_1
Xhold153 _0308_ VGND VGND VPWR VPWR net227 sky130_fd_sc_hd__dlygate4sd3_1
Xhold120 _0583_ VGND VGND VPWR VPWR net194 sky130_fd_sc_hd__dlygate4sd3_1
Xhold142 u_pe_array.g_pe_row\[3\].g_pe_col\[0\].u_pe.move_reg\[9\] VGND VGND VPWR
+ VPWR net216 sky130_fd_sc_hd__dlygate4sd3_1
Xhold131 _0189_ VGND VGND VPWR VPWR net205 sky130_fd_sc_hd__dlygate4sd3_1
X_5498_ u_pe_array.u_fifo2.buffer\[5\]\[3\] _2333_ _2334_ u_pe_array.u_fifo2.buffer\[6\]\[3\]
+ _2335_ VGND VGND VPWR VPWR _2360_ sky130_fd_sc_hd__a221o_1
X_7306_ clknet_leaf_1_clk _0212_ net944 VGND VGND VPWR VPWR u_pe_array.act_from_right\[10\]\[5\]
+ sky130_fd_sc_hd__dfrtp_1
XFILLER_0_41_594 VPWR VGND VPWR VGND sky130_ef_sc_hd__decap_12
X_4518_ net371 _1605_ _1305_ _1607_ VGND VGND VPWR VPWR _0213_ sky130_fd_sc_hd__a22o_1
Xhold175 _0354_ VGND VGND VPWR VPWR net249 sky130_fd_sc_hd__dlygate4sd3_1
X_7237_ clknet_leaf_16_clk _0143_ net943 VGND VGND VPWR VPWR u_pe_array.g_pe_row\[3\].g_pe_col\[1\].u_pe.psum_out\[5\]
+ sky130_fd_sc_hd__dfrtp_1
Xhold186 _0619_ VGND VGND VPWR VPWR net260 sky130_fd_sc_hd__dlygate4sd3_1
Xhold164 u_pe_array.act_from_right\[2\]\[5\] VGND VGND VPWR VPWR net238 sky130_fd_sc_hd__dlygate4sd3_1
X_4449_ _1551_ _1552_ VGND VGND VPWR VPWR _1553_ sky130_fd_sc_hd__and2_1
XFILLER_0_111_493 VGND VGND VPWR VPWR sky130_fd_sc_hd__decap_4
Xhold197 u_pe_array.act_from_up\[6\]\[0\] VGND VGND VPWR VPWR net271 sky130_fd_sc_hd__dlygate4sd3_1
XFILLER_0_95_81 VPWR VGND VPWR VGND sky130_ef_sc_hd__decap_12
X_7168_ clknet_leaf_17_clk _0074_ net943 VGND VGND VPWR VPWR u_pe_array.act_from_left\[15\]\[3\]
+ sky130_fd_sc_hd__dfrtp_1
X_6119_ u_pe_array.g_pe_row\[0\].g_pe_col\[3\].u_pe.psum_out\[7\] u_pe_array.g_pe_row\[0\].g_pe_col\[3\].u_pe.move_reg\[7\]
+ _2844_ VGND VGND VPWR VPWR _2854_ sky130_fd_sc_hd__mux2_1
X_7099_ clknet_leaf_87_clk _0005_ net948 VGND VGND VPWR VPWR u_fsm.h_cnt\[1\] sky130_fd_sc_hd__dfrtp_1
XTAP_480 VGND VPWR sky130_fd_sc_hd__tapvpwrvgnd_1
XTAP_491 VGND VPWR sky130_fd_sc_hd__tapvpwrvgnd_1
XFILLER_0_96_701 VGND VGND VPWR VPWR sky130_fd_sc_hd__decap_4
XTAP_1624 VGND VPWR sky130_fd_sc_hd__tapvpwrvgnd_1
XTAP_1613 VGND VPWR sky130_fd_sc_hd__tapvpwrvgnd_1
XTAP_1602 VGND VPWR sky130_fd_sc_hd__tapvpwrvgnd_1
XFILLER_0_95_233 VGND VGND VPWR VPWR sky130_fd_sc_hd__decap_8
XTAP_1657 VGND VPWR sky130_fd_sc_hd__tapvpwrvgnd_1
XTAP_1646 VGND VPWR sky130_fd_sc_hd__tapvpwrvgnd_1
XTAP_1635 VGND VPWR sky130_fd_sc_hd__tapvpwrvgnd_1
XTAP_1679 VGND VPWR sky130_fd_sc_hd__tapvpwrvgnd_1
XTAP_1668 VGND VPWR sky130_fd_sc_hd__tapvpwrvgnd_1
XFILLER_0_64_631 VGND VGND VPWR VPWR sky130_fd_sc_hd__fill_1
XFILLER_0_48_193 VGND VGND VPWR VPWR sky130_fd_sc_hd__decap_3
XFILLER_0_64_697 VGND VGND VPWR VPWR sky130_fd_sc_hd__decap_3
XFILLER_0_8_290 VGND VGND VPWR VPWR sky130_fd_sc_hd__fill_2
XFILLER_0_106_265 VGND VGND VPWR VPWR sky130_fd_sc_hd__decap_8
XFILLER_0_51_325 VGND VGND VPWR VPWR sky130_fd_sc_hd__decap_8
XFILLER_0_20_701 VGND VGND VPWR VPWR sky130_fd_sc_hd__decap_4
XFILLER_0_32_594 VPWR VGND VPWR VGND sky130_ef_sc_hd__decap_12
XFILLER_0_115_57 VPWR VGND VPWR VGND sky130_ef_sc_hd__decap_12
XFILLER_0_47_609 VGND VGND VPWR VPWR sky130_fd_sc_hd__decap_6
X_3820_ _1070_ _1071_ VGND VGND VPWR VPWR _1072_ sky130_fd_sc_hd__nand2_1
X_3751_ _0996_ _1000_ VGND VGND VPWR VPWR _1008_ sky130_fd_sc_hd__nor2_1
XFILLER_0_82_461 VGND VGND VPWR VPWR sky130_fd_sc_hd__decap_6
XFILLER_0_40_32 VGND VGND VPWR VPWR sky130_fd_sc_hd__fill_1
XFILLER_0_40_43 VPWR VGND VPWR VGND sky130_ef_sc_hd__decap_12
X_6470_ u_pe_array.g_pe_row\[0\].g_pe_col\[1\].u_pe.act_val\[1\] _3101_ _2987_ net175
+ VGND VGND VPWR VPWR _0657_ sky130_fd_sc_hd__a22o_1
X_3682_ net467 _0949_ _0944_ _0958_ VGND VGND VPWR VPWR _0026_ sky130_fd_sc_hd__a22o_1
XFILLER_0_70_678 VGND VGND VPWR VPWR sky130_fd_sc_hd__fill_1
X_5421_ u_pe_array.g_pe_row\[1\].g_pe_col\[2\].u_pe.psum_out\[9\] _1108_ _1110_ _2302_
+ VGND VGND VPWR VPWR _2303_ sky130_fd_sc_hd__o211a_1
XFILLER_0_23_550 VGND VGND VPWR VPWR sky130_fd_sc_hd__decap_4
X_5352_ net933 _1904_ _2248_ _1726_ VGND VGND VPWR VPWR _0406_ sky130_fd_sc_hd__a22o_1
XFILLER_0_2_433 VPWR VGND VPWR VGND sky130_ef_sc_hd__decap_12
X_4303_ net57 _1447_ _1116_ VGND VGND VPWR VPWR _1448_ sky130_fd_sc_hd__mux2_1
XFILLER_0_2_477 VPWR VGND VPWR VGND sky130_ef_sc_hd__decap_12
X_5283_ u_pe_array.g_pe_row\[1\].g_pe_col\[3\].u_pe.act_val\[2\] _2164_ _2184_ _2185_
+ VGND VGND VPWR VPWR _2186_ sky130_fd_sc_hd__or4_1
X_7022_ net652 _3362_ _3499_ VGND VGND VPWR VPWR _3505_ sky130_fd_sc_hd__mux2_1
X_4234_ _1374_ _1384_ _1389_ _1390_ VGND VGND VPWR VPWR _1391_ sky130_fd_sc_hd__o31a_1
X_4165_ net473 _1273_ _1327_ _1021_ VGND VGND VPWR VPWR _0140_ sky130_fd_sc_hd__a22o_1
XFILLER_0_4_65 VPWR VGND VPWR VGND sky130_ef_sc_hd__decap_12
XFILLER_0_78_701 VGND VGND VPWR VPWR sky130_fd_sc_hd__decap_4
X_4096_ _1286_ _1287_ _0931_ VGND VGND VPWR VPWR _1288_ sky130_fd_sc_hd__mux2_1
X_7924_ clknet_leaf_81_clk _0829_ VGND VGND VPWR VPWR u_pe_array.u_fifo1.buffer\[4\]\[2\]
+ sky130_fd_sc_hd__dfxtp_1
X_7855_ clknet_leaf_86_clk _0760_ VGND VGND VPWR VPWR u_pe_array.u_fifo2.buffer\[3\]\[1\]
+ sky130_fd_sc_hd__dfxtp_1
X_6806_ u_pe_array.u_fifo2.rd_ptr\[0\] _3371_ net892 VGND VGND VPWR VPWR _3375_ sky130_fd_sc_hd__a21oi_1
X_4998_ _1968_ _1971_ _1976_ VGND VGND VPWR VPWR _1977_ sky130_fd_sc_hd__o21ai_1
X_7786_ clknet_leaf_62_clk _0692_ net74 VGND VGND VPWR VPWR u_pe_array.act_from_up\[4\]\[8\]
+ sky130_fd_sc_hd__dfrtp_1
X_6737_ _3316_ _3320_ VGND VGND VPWR VPWR _3322_ sky130_fd_sc_hd__nand2_1
XFILLER_0_61_612 VGND VGND VPWR VPWR sky130_fd_sc_hd__decap_4
X_3949_ net21 u_pe_array.act_from_up\[14\]\[0\] _0857_ VGND VGND VPWR VPWR _1168_
+ sky130_fd_sc_hd__mux2_1
X_6668_ u_pe_array.g_pe_row\[0\].g_pe_col\[0\].u_pe.act_val\[1\] _3246_ _3256_ _3257_
+ VGND VGND VPWR VPWR _3259_ sky130_fd_sc_hd__o22a_1
X_6599_ _3214_ _3216_ _3221_ VGND VGND VPWR VPWR _3222_ sky130_fd_sc_hd__o21ai_1
X_5619_ u_pe_array.g_pe_row\[1\].g_pe_col\[2\].u_pe.psum_out\[9\] _1597_ VGND VGND
+ VPWR VPWR _2462_ sky130_fd_sc_hd__nand2_1
XFILLER_0_60_166 VGND VGND VPWR VPWR sky130_fd_sc_hd__fill_1
XFILLER_0_41_391 VGND VGND VPWR VPWR sky130_fd_sc_hd__fill_1
XTAP_1432 VGND VPWR sky130_fd_sc_hd__tapvpwrvgnd_1
XTAP_1410 VGND VPWR sky130_fd_sc_hd__tapvpwrvgnd_1
XTAP_1421 VGND VPWR sky130_fd_sc_hd__tapvpwrvgnd_1
XTAP_1465 VGND VPWR sky130_fd_sc_hd__tapvpwrvgnd_1
XTAP_1454 VGND VPWR sky130_fd_sc_hd__tapvpwrvgnd_1
XTAP_1443 VGND VPWR sky130_fd_sc_hd__tapvpwrvgnd_1
XTAP_1498 VGND VPWR sky130_fd_sc_hd__tapvpwrvgnd_1
XTAP_1487 VGND VPWR sky130_fd_sc_hd__tapvpwrvgnd_1
XTAP_1476 VGND VPWR sky130_fd_sc_hd__tapvpwrvgnd_1
Xfanout70 net71 VGND VGND VPWR VPWR net70 sky130_fd_sc_hd__buf_6
XFILLER_0_52_601 VGND VGND VPWR VPWR sky130_fd_sc_hd__fill_2
XFILLER_0_101_15 VPWR VGND VPWR VGND sky130_ef_sc_hd__decap_12
XFILLER_0_52_645 VGND VGND VPWR VPWR sky130_fd_sc_hd__decap_8
XFILLER_0_51_166 VGND VGND VPWR VPWR sky130_fd_sc_hd__fill_2
XFILLER_0_20_586 VGND VGND VPWR VPWR sky130_fd_sc_hd__fill_2
XFILLER_0_19_55 VGND VGND VPWR VPWR sky130_fd_sc_hd__fill_1
XFILLER_0_19_99 VGND VGND VPWR VPWR sky130_fd_sc_hd__decap_4
XFILLER_0_99_391 VGND VGND VPWR VPWR sky130_fd_sc_hd__fill_1
X_5970_ u_pe_array.act_from_up\[4\]\[9\] _2730_ _2511_ net299 VGND VGND VPWR VPWR
+ _0542_ sky130_fd_sc_hd__a22o_1
XFILLER_0_59_222 VGND VGND VPWR VPWR sky130_fd_sc_hd__fill_2
XFILLER_0_35_54 VGND VGND VPWR VPWR sky130_fd_sc_hd__fill_2
X_4921_ _1895_ _1901_ _1905_ VGND VGND VPWR VPWR _1906_ sky130_fd_sc_hd__a21o_1
X_4852_ _1866_ VGND VGND VPWR VPWR _0288_ sky130_fd_sc_hd__clkbuf_1
XFILLER_0_59_266 VGND VGND VPWR VPWR sky130_fd_sc_hd__decap_4
X_7640_ clknet_leaf_90_clk net533 net949 VGND VGND VPWR VPWR u_pe_array.g_pe_row\[1\].g_pe_col\[0\].u_pe.psum_out\[0\]
+ sky130_fd_sc_hd__dfrtp_1
X_3803_ _1033_ _1055_ _1056_ _0986_ net558 VGND VGND VPWR VPWR _0049_ sky130_fd_sc_hd__a32o_1
XFILLER_0_51_53 VGND VGND VPWR VPWR sky130_fd_sc_hd__decap_3
X_7571_ clknet_leaf_43_clk _0477_ net946 VGND VGND VPWR VPWR u_pe_array.act_from_down\[1\]\[11\]
+ sky130_fd_sc_hd__dfrtp_1
XFILLER_0_7_525 VPWR VGND VPWR VGND sky130_ef_sc_hd__decap_12
X_4783_ _1804_ _0933_ u_pe_array.g_pe_row\[2\].g_pe_col\[2\].u_pe.psum_out\[6\] VGND
+ VGND VPWR VPWR _1806_ sky130_fd_sc_hd__a21oi_1
X_6522_ u_pe_array.g_pe_row\[0\].g_pe_col\[1\].u_pe.psum_out\[4\] _3151_ VGND VGND
+ VPWR VPWR _3152_ sky130_fd_sc_hd__xnor2_1
X_3734_ u_pe_array.g_pe_row\[3\].g_pe_col\[3\].u_pe.psum_out\[1\] _0991_ VGND VGND
+ VPWR VPWR _0993_ sky130_fd_sc_hd__nand2_1
X_6453_ u_pe_array.g_pe_row\[0\].g_pe_col\[1\].u_pe.psum_out\[5\] u_pe_array.g_pe_row\[0\].g_pe_col\[1\].u_pe.act_val\[5\]
+ _3102_ VGND VGND VPWR VPWR _3108_ sky130_fd_sc_hd__mux2_1
X_3665_ u_pe_array.g_pe_row\[3\].g_pe_col\[3\].u_pe.psum_out\[1\] u_pe_array.g_pe_row\[3\].g_pe_col\[3\].u_pe.act_val\[1\]
+ _0947_ VGND VGND VPWR VPWR _0950_ sky130_fd_sc_hd__mux2_1
X_5404_ _2289_ _1112_ VGND VGND VPWR VPWR _2290_ sky130_fd_sc_hd__nand2_1
XFILLER_0_100_205 VGND VGND VPWR VPWR sky130_fd_sc_hd__fill_1
X_6384_ _3050_ _3052_ VGND VGND VPWR VPWR _3053_ sky130_fd_sc_hd__xnor2_1
X_3596_ u_fsm.state\[0\] _0853_ _0852_ _0862_ _0874_ VGND VGND VPWR VPWR _0896_ sky130_fd_sc_hd__a311o_1
XFILLER_0_100_249 VGND VGND VPWR VPWR sky130_fd_sc_hd__decap_3
X_5335_ _0977_ VGND VGND VPWR VPWR _2233_ sky130_fd_sc_hd__buf_8
X_5266_ _2162_ _2168_ VGND VGND VPWR VPWR _2171_ sky130_fd_sc_hd__nand2_1
XFILLER_0_55_3 VPWR VGND VPWR VGND sky130_ef_sc_hd__decap_12
X_4217_ _1375_ _1365_ _1363_ VGND VGND VPWR VPWR _1376_ sky130_fd_sc_hd__a21oi_1
X_7005_ _3495_ VGND VGND VPWR VPWR _0812_ sky130_fd_sc_hd__clkbuf_1
X_5197_ u_pe_array.g_pe_row\[0\].g_pe_col\[2\].u_pe.w_out\[1\] VGND VGND VPWR VPWR
+ _2130_ sky130_fd_sc_hd__buf_8
X_4148_ _1033_ _1311_ _1312_ _0986_ net463 VGND VGND VPWR VPWR _0138_ sky130_fd_sc_hd__a32o_1
X_4079_ u_pe_array.g_pe_row\[3\].g_pe_col\[2\].u_pe.psum_out\[10\] _1259_ _1266_ _1270_
+ VGND VGND VPWR VPWR _1274_ sky130_fd_sc_hd__a2bb2o_1
XFILLER_0_92_93 VGND VGND VPWR VPWR sky130_fd_sc_hd__decap_3
X_7907_ clknet_leaf_82_clk _0812_ VGND VGND VPWR VPWR u_pe_array.u_fifo1.buffer\[1\]\[3\]
+ sky130_fd_sc_hd__dfxtp_1
XFILLER_0_93_501 VGND VGND VPWR VPWR sky130_fd_sc_hd__decap_3
XFILLER_0_78_586 VGND VGND VPWR VPWR sky130_fd_sc_hd__fill_2
XFILLER_0_65_225 VGND VGND VPWR VPWR sky130_fd_sc_hd__decap_4
X_7838_ clknet_leaf_86_clk _0743_ VGND VGND VPWR VPWR u_pe_array.u_fifo2.buffer\[0\]\[2\]
+ sky130_fd_sc_hd__dfxtp_1
X_7769_ clknet_leaf_48_clk _0675_ net947 VGND VGND VPWR VPWR u_pe_array.g_pe_row\[0\].g_pe_col\[1\].u_pe.psum_out\[6\]
+ sky130_fd_sc_hd__dfrtp_1
XFILLER_0_18_141 VGND VGND VPWR VPWR sky130_fd_sc_hd__fill_1
XFILLER_0_33_111 VGND VGND VPWR VPWR sky130_fd_sc_hd__fill_1
XFILLER_0_61_464 VGND VGND VPWR VPWR sky130_fd_sc_hd__decap_6
XFILLER_0_34_689 VGND VGND VPWR VPWR sky130_fd_sc_hd__decap_8
XTAP_1240 VGND VPWR sky130_fd_sc_hd__tapvpwrvgnd_1
XTAP_1284 VGND VPWR sky130_fd_sc_hd__tapvpwrvgnd_1
XTAP_1273 VGND VPWR sky130_fd_sc_hd__tapvpwrvgnd_1
XTAP_1262 VGND VPWR sky130_fd_sc_hd__tapvpwrvgnd_1
XTAP_1251 VGND VPWR sky130_fd_sc_hd__tapvpwrvgnd_1
XTAP_1295 VGND VPWR sky130_fd_sc_hd__tapvpwrvgnd_1
XFILLER_0_25_601 VGND VGND VPWR VPWR sky130_fd_sc_hd__decap_3
XFILLER_0_21_23 VPWR VGND VPWR VGND sky130_ef_sc_hd__decap_12
XFILLER_0_24_133 VGND VGND VPWR VPWR sky130_fd_sc_hd__decap_6
Xhold719 u_pe_array.g_pe_row\[0\].g_pe_col\[1\].u_pe.psum_out\[2\] VGND VGND VPWR
+ VPWR net793 sky130_fd_sc_hd__dlygate4sd3_1
Xhold708 u_pe_array.g_pe_row\[2\].g_pe_col\[3\].u_pe.psum_out\[9\] VGND VGND VPWR
+ VPWR net782 sky130_fd_sc_hd__dlygate4sd3_1
X_5120_ u_pe_array.g_pe_row\[2\].g_pe_col\[0\].u_pe.act_val\[4\] _1284_ _2053_ VGND
+ VGND VPWR VPWR _2062_ sky130_fd_sc_hd__and3_1
X_5051_ net478 _2006_ _2009_ _2013_ VGND VGND VPWR VPWR _0340_ sky130_fd_sc_hd__a22o_1
X_4002_ _1203_ _1199_ _1201_ VGND VGND VPWR VPWR _1205_ sky130_fd_sc_hd__or3_1
XFILLER_0_1_55 VGND VGND VPWR VPWR sky130_fd_sc_hd__fill_1
X_5953_ u_pe_array.u_fifo1.buffer\[3\]\[4\] _2685_ _2686_ u_pe_array.u_fifo1.buffer\[2\]\[4\]
+ _2718_ VGND VGND VPWR VPWR _2719_ sky130_fd_sc_hd__a221o_1
XFILLER_0_47_203 VGND VGND VPWR VPWR sky130_fd_sc_hd__fill_2
XFILLER_0_47_214 VGND VGND VPWR VPWR sky130_fd_sc_hd__fill_2
X_5884_ net800 _2667_ _2273_ VGND VGND VPWR VPWR _2668_ sky130_fd_sc_hd__mux2_1
X_4904_ _1887_ _1890_ VGND VGND VPWR VPWR _1891_ sky130_fd_sc_hd__xnor2_1
XFILLER_0_75_545 VGND VGND VPWR VPWR sky130_fd_sc_hd__decap_3
XFILLER_0_62_85 VPWR VGND VPWR VGND sky130_ef_sc_hd__decap_12
XFILLER_0_118_625 VGND VGND VPWR VPWR sky130_fd_sc_hd__fill_1
XFILLER_0_90_504 VGND VGND VPWR VPWR sky130_fd_sc_hd__decap_3
X_7623_ clknet_leaf_67_clk _0529_ net946 VGND VGND VPWR VPWR u_pe_array.act_from_left\[5\]\[9\]
+ sky130_fd_sc_hd__dfrtp_1
X_4835_ _1852_ _1853_ u_pe_array.g_pe_row\[2\].g_pe_col\[2\].u_pe.psum_out\[10\] _1006_
+ VGND VGND VPWR VPWR _0284_ sky130_fd_sc_hd__a2bb2o_1
XFILLER_0_35_409 VGND VGND VPWR VPWR sky130_fd_sc_hd__fill_1
XFILLER_0_118_669 VGND VGND VPWR VPWR sky130_fd_sc_hd__decap_3
X_4766_ _1789_ _1790_ VGND VGND VPWR VPWR _1791_ sky130_fd_sc_hd__or2_1
X_7554_ clknet_leaf_93_clk _0460_ net72 VGND VGND VPWR VPWR u_pe_array.g_pe_row\[1\].g_pe_col\[2\].u_pe.psum_out\[9\]
+ sky130_fd_sc_hd__dfrtp_2
X_6505_ _3126_ _3132_ _3135_ VGND VGND VPWR VPWR _3136_ sky130_fd_sc_hd__a21o_1
XFILLER_0_15_133 VGND VGND VPWR VPWR sky130_fd_sc_hd__fill_1
X_3717_ _0894_ VGND VGND VPWR VPWR _0977_ sky130_fd_sc_hd__buf_8
X_7485_ clknet_leaf_41_clk _0391_ net947 VGND VGND VPWR VPWR u_pe_array.g_pe_row\[1\].g_pe_col\[3\].u_pe.move_reg\[7\]
+ sky130_fd_sc_hd__dfrtp_1
X_4697_ u_pe_array.g_pe_row\[2\].g_pe_col\[2\].u_pe.psum_out\[8\] u_pe_array.g_pe_row\[2\].g_pe_col\[2\].u_pe.move_reg\[8\]
+ _1599_ VGND VGND VPWR VPWR _1744_ sky130_fd_sc_hd__mux2_1
X_6436_ net544 _2586_ _3098_ _0978_ VGND VGND VPWR VPWR _0640_ sky130_fd_sc_hd__a22o_1
X_3648_ _0933_ _0934_ _0931_ VGND VGND VPWR VPWR _0935_ sky130_fd_sc_hd__mux2_1
XFILLER_0_3_561 VPWR VGND VPWR VGND sky130_ef_sc_hd__decap_12
XFILLER_0_30_114 VGND VGND VPWR VPWR sky130_fd_sc_hd__decap_8
X_3579_ u_fsm.state\[0\] u_fsm.next_state\[0\] VGND VGND VPWR VPWR _0885_ sky130_fd_sc_hd__xnor2_1
X_6367_ _3034_ _3036_ VGND VGND VPWR VPWR _3037_ sky130_fd_sc_hd__xor2_1
XFILLER_0_87_82 VPWR VGND VPWR VGND sky130_ef_sc_hd__decap_12
X_5318_ _2215_ _2206_ _2216_ _2217_ VGND VGND VPWR VPWR _2218_ sky130_fd_sc_hd__a211oi_1
X_6298_ net206 _1731_ _2009_ _2986_ VGND VGND VPWR VPWR _0614_ sky130_fd_sc_hd__a22o_1
Xhold13 u_pe_array.act_from_up\[14\]\[10\] VGND VGND VPWR VPWR net87 sky130_fd_sc_hd__dlygate4sd3_1
X_5249_ net514 _0939_ VGND VGND VPWR VPWR _2158_ sky130_fd_sc_hd__and2_1
Xhold35 _0449_ VGND VGND VPWR VPWR net109 sky130_fd_sc_hd__dlygate4sd3_1
Xhold24 u_pe_array.act_from_up\[14\]\[8\] VGND VGND VPWR VPWR net98 sky130_fd_sc_hd__dlygate4sd3_1
Xhold46 _0224_ VGND VGND VPWR VPWR net120 sky130_fd_sc_hd__dlygate4sd3_1
Xhold79 u_pe_array.act_from_left\[13\]\[9\] VGND VGND VPWR VPWR net153 sky130_fd_sc_hd__dlygate4sd3_1
Xhold57 u_pe_array.act_from_left\[7\]\[11\] VGND VGND VPWR VPWR net131 sky130_fd_sc_hd__dlygate4sd3_1
Xhold68 u_pe_array.act_from_left\[13\]\[12\] VGND VGND VPWR VPWR net142 sky130_fd_sc_hd__dlygate4sd3_1
XFILLER_0_109_614 VGND VGND VPWR VPWR sky130_fd_sc_hd__fill_2
XFILLER_0_78_394 VGND VGND VPWR VPWR sky130_fd_sc_hd__decap_3
XFILLER_0_93_364 VGND VGND VPWR VPWR sky130_fd_sc_hd__fill_1
XFILLER_0_66_589 VGND VGND VPWR VPWR sky130_fd_sc_hd__decap_4
XFILLER_0_109_669 VGND VGND VPWR VPWR sky130_fd_sc_hd__decap_3
XFILLER_0_19_461 VGND VGND VPWR VPWR sky130_fd_sc_hd__fill_1
XFILLER_0_21_125 VGND VGND VPWR VPWR sky130_fd_sc_hd__decap_6
XFILLER_0_21_169 VPWR VGND VPWR VGND sky130_ef_sc_hd__decap_12
XTAP_309 VGND VPWR sky130_fd_sc_hd__tapvpwrvgnd_1
XFILLER_0_30_681 VPWR VGND VPWR VGND sky130_ef_sc_hd__decap_12
XFILLER_0_89_648 VPWR VGND VPWR VGND sky130_ef_sc_hd__decap_12
XFILLER_0_107_69 VPWR VGND VPWR VGND sky130_ef_sc_hd__decap_12
XFILLER_0_76_309 VGND VGND VPWR VPWR sky130_fd_sc_hd__decap_3
XFILLER_0_72_504 VGND VGND VPWR VPWR sky130_fd_sc_hd__fill_1
XTAP_1081 VGND VPWR sky130_fd_sc_hd__tapvpwrvgnd_1
XTAP_1092 VGND VPWR sky130_fd_sc_hd__tapvpwrvgnd_1
XTAP_1070 VGND VPWR sky130_fd_sc_hd__tapvpwrvgnd_1
XFILLER_0_29_269 VGND VGND VPWR VPWR sky130_fd_sc_hd__decap_6
X_4620_ u_pe_array.g_pe_row\[2\].g_pe_col\[3\].u_pe.psum_out\[7\] _1427_ VGND VGND
+ VPWR VPWR _1683_ sky130_fd_sc_hd__nand2_1
XFILLER_0_113_3 VPWR VGND VPWR VGND sky130_ef_sc_hd__decap_12
XFILLER_0_25_420 VPWR VGND VPWR VGND sky130_ef_sc_hd__decap_12
X_4551_ _1616_ _1617_ _1618_ VGND VGND VPWR VPWR _1620_ sky130_fd_sc_hd__or3_1
XFILLER_0_52_272 VPWR VGND VPWR VGND sky130_ef_sc_hd__decap_12
Xhold516 u_pe_array.g_pe_row\[0\].g_pe_col\[3\].u_pe.psum_out\[11\] VGND VGND VPWR
+ VPWR net590 sky130_fd_sc_hd__dlygate4sd3_1
XFILLER_0_80_592 VGND VGND VPWR VPWR sky130_fd_sc_hd__decap_6
XFILLER_0_12_114 VGND VGND VPWR VPWR sky130_fd_sc_hd__fill_1
Xhold505 u_pe_array.u_fifo1.buffer\[6\]\[1\] VGND VGND VPWR VPWR net579 sky130_fd_sc_hd__dlygate4sd3_1
X_7270_ clknet_leaf_88_clk _0176_ net948 VGND VGND VPWR VPWR u_pe_array.act_from_left\[13\]\[10\]
+ sky130_fd_sc_hd__dfrtp_1
Xhold527 u_pe_array.u_fifo1.buffer\[2\]\[1\] VGND VGND VPWR VPWR net601 sky130_fd_sc_hd__dlygate4sd3_1
X_4482_ _1577_ _1582_ VGND VGND VPWR VPWR _1583_ sky130_fd_sc_hd__and2_1
XFILLER_0_110_322 VGND VGND VPWR VPWR sky130_fd_sc_hd__fill_1
X_6221_ _2928_ _2929_ VGND VGND VPWR VPWR _2930_ sky130_fd_sc_hd__and2_1
Xhold549 u_pe_array.u_fifo2.buffer\[1\]\[0\] VGND VGND VPWR VPWR net623 sky130_fd_sc_hd__dlygate4sd3_1
Xhold538 u_pe_array.u_fifo2.buffer\[8\]\[0\] VGND VGND VPWR VPWR net612 sky130_fd_sc_hd__dlygate4sd3_1
X_6152_ u_pe_array.g_pe_row\[0\].g_pe_col\[3\].u_pe.psum_out\[1\] _2866_ VGND VGND
+ VPWR VPWR _2867_ sky130_fd_sc_hd__or2_1
XTAP_810 VGND VPWR sky130_fd_sc_hd__tapvpwrvgnd_1
X_5103_ _2042_ _2044_ _2046_ VGND VGND VPWR VPWR _2047_ sky130_fd_sc_hd__o21ai_1
XFILLER_0_0_597 VGND VGND VPWR VPWR sky130_fd_sc_hd__fill_1
XTAP_821 VGND VPWR sky130_fd_sc_hd__tapvpwrvgnd_1
XTAP_843 VGND VPWR sky130_fd_sc_hd__tapvpwrvgnd_1
XTAP_832 VGND VPWR sky130_fd_sc_hd__tapvpwrvgnd_1
X_6083_ _2824_ _2829_ VGND VGND VPWR VPWR _2830_ sky130_fd_sc_hd__and2_1
XFILLER_0_57_96 VGND VGND VPWR VPWR sky130_fd_sc_hd__decap_4
XTAP_854 VGND VPWR sky130_fd_sc_hd__tapvpwrvgnd_1
XTAP_865 VGND VPWR sky130_fd_sc_hd__tapvpwrvgnd_1
XTAP_876 VGND VPWR sky130_fd_sc_hd__tapvpwrvgnd_1
X_5034_ u_pe_array.g_pe_row\[2\].g_pe_col\[0\].u_pe.psum_out\[3\] u_pe_array.g_pe_row\[2\].g_pe_col\[0\].u_pe.act_val\[3\]
+ _1867_ VGND VGND VPWR VPWR _2004_ sky130_fd_sc_hd__mux2_1
XTAP_887 VGND VPWR sky130_fd_sc_hd__tapvpwrvgnd_1
XTAP_898 VGND VPWR sky130_fd_sc_hd__tapvpwrvgnd_1
XFILLER_0_18_3 VPWR VGND VPWR VGND sky130_ef_sc_hd__decap_12
XFILLER_0_88_681 VPWR VGND VPWR VGND sky130_ef_sc_hd__decap_12
XFILLER_0_67_309 VGND VGND VPWR VPWR sky130_fd_sc_hd__fill_2
X_6985_ net561 _3347_ _3484_ VGND VGND VPWR VPWR _3485_ sky130_fd_sc_hd__mux2_1
X_5936_ u_pe_array.u_fifo1.buffer\[5\]\[2\] _2687_ _2688_ u_pe_array.u_fifo1.buffer\[6\]\[2\]
+ _2689_ VGND VGND VPWR VPWR _2704_ sky130_fd_sc_hd__a221o_1
XFILLER_0_75_353 VPWR VGND VPWR VGND sky130_ef_sc_hd__decap_12
XFILLER_0_75_342 VGND VGND VPWR VPWR sky130_fd_sc_hd__fill_2
XFILLER_0_118_433 VGND VGND VPWR VPWR sky130_fd_sc_hd__decap_4
X_7606_ clknet_leaf_84_clk _0512_ net948 VGND VGND VPWR VPWR net44 sky130_fd_sc_hd__dfrtp_1
X_5867_ u_pe_array.g_pe_row\[1\].g_pe_col\[0\].u_pe.psum_out\[8\] _1112_ _1109_ _2654_
+ VGND VGND VPWR VPWR _2655_ sky130_fd_sc_hd__o211a_1
XFILLER_0_105_105 VGND VGND VPWR VPWR sky130_fd_sc_hd__decap_6
X_5798_ u_pe_array.g_pe_row\[1\].g_pe_col\[1\].u_pe.psum_out\[9\] _1728_ VGND VGND
+ VPWR VPWR _2600_ sky130_fd_sc_hd__nand2_1
X_4818_ net852 _1273_ _1836_ _1838_ VGND VGND VPWR VPWR _0282_ sky130_fd_sc_hd__a22o_1
X_4749_ _1773_ _1774_ VGND VGND VPWR VPWR _1775_ sky130_fd_sc_hd__nand2_1
X_7537_ clknet_leaf_92_clk _0443_ net949 VGND VGND VPWR VPWR u_pe_array.g_pe_row\[1\].g_pe_col\[2\].u_pe.act_val\[5\]
+ sky130_fd_sc_hd__dfrtp_1
X_7468_ clknet_leaf_40_clk _0374_ net946 VGND VGND VPWR VPWR u_pe_array.act_from_down\[3\]\[3\]
+ sky130_fd_sc_hd__dfrtp_1
X_6419_ u_pe_array.g_pe_row\[0\].g_pe_col\[2\].u_pe.psum_out\[10\] _2130_ VGND VGND
+ VPWR VPWR _3084_ sky130_fd_sc_hd__or2_1
Xoutput58 net58 VGND VGND VPWR VPWR psum_out1[6] sky130_fd_sc_hd__clkbuf_4
X_7399_ clknet_leaf_28_clk net215 net942 VGND VGND VPWR VPWR u_pe_array.g_pe_row\[2\].g_pe_col\[1\].u_pe.act_val\[3\]
+ sky130_fd_sc_hd__dfrtp_2
XFILLER_0_12_681 VPWR VGND VPWR VGND sky130_ef_sc_hd__decap_12
Xoutput36 net36 VGND VGND VPWR VPWR psum_out0[0] sky130_fd_sc_hd__clkbuf_4
Xoutput47 net47 VGND VGND VPWR VPWR psum_out0[8] sky130_fd_sc_hd__clkbuf_4
XFILLER_0_3_391 VGND VGND VPWR VPWR sky130_fd_sc_hd__fill_1
XFILLER_0_101_399 VGND VGND VPWR VPWR sky130_fd_sc_hd__fill_1
XFILLER_0_86_618 VPWR VGND VPWR VGND sky130_ef_sc_hd__decap_12
XFILLER_0_58_309 VGND VGND VPWR VPWR sky130_fd_sc_hd__fill_1
XFILLER_0_85_128 VGND VGND VPWR VPWR sky130_fd_sc_hd__decap_6
XFILLER_0_39_545 VPWR VGND VPWR VGND sky130_ef_sc_hd__decap_12
XFILLER_0_109_411 VGND VGND VPWR VPWR sky130_fd_sc_hd__fill_1
XFILLER_0_94_640 VGND VGND VPWR VPWR sky130_fd_sc_hd__fill_1
XPHY_142 VGND VGND VPWR VPWR sky130_fd_sc_hd__decap_3
XPHY_131 VGND VGND VPWR VPWR sky130_fd_sc_hd__decap_3
XPHY_120 VGND VGND VPWR VPWR sky130_fd_sc_hd__decap_3
XFILLER_0_54_504 VGND VGND VPWR VPWR sky130_fd_sc_hd__decap_4
XPHY_175 VGND VGND VPWR VPWR sky130_fd_sc_hd__decap_3
XPHY_164 VGND VGND VPWR VPWR sky130_fd_sc_hd__decap_3
XFILLER_0_81_312 VPWR VGND VPWR VGND sky130_ef_sc_hd__decap_12
XPHY_153 VGND VGND VPWR VPWR sky130_fd_sc_hd__decap_3
XPHY_197 VGND VGND VPWR VPWR sky130_fd_sc_hd__decap_3
XPHY_186 VGND VGND VPWR VPWR sky130_fd_sc_hd__decap_3
XFILLER_0_54_559 VGND VGND VPWR VPWR sky130_fd_sc_hd__fill_2
XFILLER_0_78_29 VGND VGND VPWR VPWR sky130_fd_sc_hd__decap_8
XFILLER_0_62_581 VGND VGND VPWR VPWR sky130_fd_sc_hd__decap_6
XFILLER_0_22_467 VGND VGND VPWR VPWR sky130_fd_sc_hd__fill_1
XFILLER_0_118_57 VGND VGND VPWR VPWR sky130_fd_sc_hd__decap_8
XFILLER_0_89_401 VGND VGND VPWR VPWR sky130_fd_sc_hd__fill_2
XFILLER_0_27_66 VGND VGND VPWR VPWR sky130_fd_sc_hd__decap_4
XFILLER_0_27_77 VPWR VGND VPWR VGND sky130_ef_sc_hd__decap_12
XFILLER_0_27_99 VPWR VGND VPWR VGND sky130_ef_sc_hd__decap_12
XFILLER_0_89_467 VGND VGND VPWR VPWR sky130_fd_sc_hd__decap_3
X_3982_ u_pe_array.g_pe_row\[3\].g_pe_col\[2\].u_pe.psum_out\[2\] _1185_ VGND VGND
+ VPWR VPWR _1186_ sky130_fd_sc_hd__xnor2_1
XFILLER_0_9_417 VGND VGND VPWR VPWR sky130_fd_sc_hd__decap_6
XPHY_0 VGND VGND VPWR VPWR sky130_fd_sc_hd__decap_3
X_6770_ u_pe_array.u_fifo1.wr_ptr\[0\] u_pe_array.u_fifo1.wr_ptr\[1\] VGND VGND VPWR
+ VPWR _3350_ sky130_fd_sc_hd__nor2_1
XFILLER_0_43_54 VGND VGND VPWR VPWR sky130_fd_sc_hd__fill_2
X_5721_ _2522_ _2528_ _1003_ VGND VGND VPWR VPWR _2530_ sky130_fd_sc_hd__a21o_1
XFILLER_0_85_662 VGND VGND VPWR VPWR sky130_fd_sc_hd__fill_1
X_5652_ _2489_ VGND VGND VPWR VPWR _0465_ sky130_fd_sc_hd__clkbuf_1
XFILLER_0_5_623 VGND VGND VPWR VPWR sky130_fd_sc_hd__fill_1
XFILLER_0_60_529 VGND VGND VPWR VPWR sky130_fd_sc_hd__decap_3
XFILLER_0_4_133 VGND VGND VPWR VPWR sky130_fd_sc_hd__decap_6
X_4603_ _1656_ _1657_ _1654_ VGND VGND VPWR VPWR _1668_ sky130_fd_sc_hd__o21ba_1
X_5583_ _2428_ _2429_ VGND VGND VPWR VPWR _2430_ sky130_fd_sc_hd__xnor2_1
X_7322_ clknet_leaf_4_clk _0228_ net945 VGND VGND VPWR VPWR u_pe_array.g_pe_row\[2\].g_pe_col\[3\].u_pe.move_reg\[8\]
+ sky130_fd_sc_hd__dfrtp_1
Xhold302 u_pe_array.g_pe_row\[2\].g_pe_col\[3\].u_pe.psum_out\[2\] VGND VGND VPWR
+ VPWR net376 sky130_fd_sc_hd__dlygate4sd3_1
X_4534_ u_pe_array.g_pe_row\[2\].g_pe_col\[3\].u_pe.act_val\[2\] _1605_ _1611_ net162
+ VGND VGND VPWR VPWR _0222_ sky130_fd_sc_hd__a22o_1
Xhold324 u_pe_array.act_from_right\[0\]\[12\] VGND VGND VPWR VPWR net398 sky130_fd_sc_hd__dlygate4sd3_1
Xhold313 u_pe_array.act_from_up\[4\]\[12\] VGND VGND VPWR VPWR net387 sky130_fd_sc_hd__dlygate4sd3_1
Xhold335 u_pe_array.act_from_up\[4\]\[6\] VGND VGND VPWR VPWR net409 sky130_fd_sc_hd__dlygate4sd3_1
XFILLER_0_4_177 VPWR VGND VPWR VGND sky130_ef_sc_hd__decap_12
XFILLER_0_13_478 VGND VGND VPWR VPWR sky130_fd_sc_hd__decap_4
XFILLER_0_40_242 VGND VGND VPWR VPWR sky130_fd_sc_hd__fill_1
XFILLER_0_40_253 VGND VGND VPWR VPWR sky130_fd_sc_hd__decap_4
X_7253_ clknet_leaf_53_clk _0159_ net73 VGND VGND VPWR VPWR net58 sky130_fd_sc_hd__dfrtp_1
XFILLER_0_111_664 VGND VGND VPWR VPWR sky130_fd_sc_hd__decap_8
Xhold346 _0576_ VGND VGND VPWR VPWR net420 sky130_fd_sc_hd__dlygate4sd3_1
Xhold357 u_pe_array.g_pe_row\[3\].g_pe_col\[3\].u_pe.psum_out\[3\] VGND VGND VPWR
+ VPWR net431 sky130_fd_sc_hd__dlygate4sd3_1
Xhold368 _0227_ VGND VGND VPWR VPWR net442 sky130_fd_sc_hd__dlygate4sd3_1
XFILLER_0_40_286 VGND VGND VPWR VPWR sky130_fd_sc_hd__fill_2
X_4465_ _1559_ _1561_ _1566_ VGND VGND VPWR VPWR _1568_ sky130_fd_sc_hd__o21a_1
XFILLER_0_111_697 VGND VGND VPWR VPWR sky130_fd_sc_hd__decap_8
Xhold379 u_pe_array.act_from_right\[8\]\[9\] VGND VGND VPWR VPWR net453 sky130_fd_sc_hd__dlygate4sd3_1
X_6204_ _2912_ _1999_ u_pe_array.g_pe_row\[0\].g_pe_col\[3\].u_pe.psum_out\[6\] VGND
+ VGND VPWR VPWR _2914_ sky130_fd_sc_hd__a21oi_1
X_4396_ _1496_ _1500_ VGND VGND VPWR VPWR _1504_ sky130_fd_sc_hd__nor2_1
X_7184_ clknet_leaf_97_clk net103 net944 VGND VGND VPWR VPWR u_pe_array.g_pe_row\[3\].g_pe_col\[2\].u_pe.move_reg\[6\]
+ sky130_fd_sc_hd__dfrtp_1
X_6135_ u_pe_array.g_pe_row\[0\].g_pe_col\[3\].u_pe.act_val\[4\] _2853_ _2847_ net474
+ VGND VGND VPWR VPWR _0578_ sky130_fd_sc_hd__a22o_1
XTAP_640 VGND VPWR sky130_fd_sc_hd__tapvpwrvgnd_1
XTAP_651 VGND VPWR sky130_fd_sc_hd__tapvpwrvgnd_1
XTAP_662 VGND VPWR sky130_fd_sc_hd__tapvpwrvgnd_1
XTAP_684 VGND VPWR sky130_fd_sc_hd__tapvpwrvgnd_1
XTAP_673 VGND VPWR sky130_fd_sc_hd__tapvpwrvgnd_1
XTAP_695 VGND VPWR sky130_fd_sc_hd__tapvpwrvgnd_1
X_6066_ _2806_ _2808_ _2813_ VGND VGND VPWR VPWR _2815_ sky130_fd_sc_hd__o21a_1
X_5017_ _1884_ _1992_ _1993_ _1803_ net638 VGND VGND VPWR VPWR _0326_ sky130_fd_sc_hd__a32o_1
XFILLER_0_95_415 VGND VGND VPWR VPWR sky130_fd_sc_hd__decap_4
XFILLER_0_76_662 VGND VGND VPWR VPWR sky130_fd_sc_hd__fill_2
X_6968_ _3471_ VGND VGND VPWR VPWR _3472_ sky130_fd_sc_hd__inv_2
X_6899_ _3430_ VGND VGND VPWR VPWR _3431_ sky130_fd_sc_hd__buf_2
X_5919_ _2676_ _2677_ VGND VGND VPWR VPWR _2689_ sky130_fd_sc_hd__nor2_2
XFILLER_0_91_654 VPWR VGND VPWR VGND sky130_ef_sc_hd__decap_12
XFILLER_0_90_164 VGND VGND VPWR VPWR sky130_fd_sc_hd__decap_4
XFILLER_0_51_529 VGND VGND VPWR VPWR sky130_fd_sc_hd__decap_8
XFILLER_0_90_197 VGND VGND VPWR VPWR sky130_fd_sc_hd__decap_3
XFILLER_0_44_570 VGND VGND VPWR VPWR sky130_fd_sc_hd__fill_2
XFILLER_0_7_3 VPWR VGND VPWR VGND sky130_ef_sc_hd__decap_12
XFILLER_0_98_253 VGND VGND VPWR VPWR sky130_fd_sc_hd__decap_8
XFILLER_0_104_15 VPWR VGND VPWR VGND sky130_ef_sc_hd__decap_12
XFILLER_0_67_673 VPWR VGND VPWR VGND sky130_ef_sc_hd__decap_12
XFILLER_0_13_57 VPWR VGND VPWR VGND sky130_ef_sc_hd__decap_12
XFILLER_0_81_175 VGND VGND VPWR VPWR sky130_fd_sc_hd__fill_1
XFILLER_0_105_480 VGND VGND VPWR VPWR sky130_fd_sc_hd__fill_2
XFILLER_0_1_125 VPWR VGND VPWR VGND sky130_ef_sc_hd__decap_12
XFILLER_0_2_637 VGND VGND VPWR VPWR sky130_fd_sc_hd__decap_6
XFILLER_0_22_253 VPWR VGND VPWR VGND sky130_ef_sc_hd__decap_12
X_4250_ u_pe_array.g_pe_row\[3\].g_pe_col\[1\].u_pe.psum_out\[7\] u_pe_array.g_pe_row\[3\].g_pe_col\[1\].u_pe.psum_out\[8\]
+ _1106_ VGND VGND VPWR VPWR _1405_ sky130_fd_sc_hd__o21a_1
XFILLER_0_1_169 VPWR VGND VPWR VGND sky130_ef_sc_hd__decap_12
X_4181_ _1033_ _1341_ _1342_ _0986_ net461 VGND VGND VPWR VPWR _0141_ sky130_fd_sc_hd__a32o_1
X_7940_ clknet_leaf_81_clk _0845_ VGND VGND VPWR VPWR u_pe_array.u_fifo1.buffer\[7\]\[0\]
+ sky130_fd_sc_hd__dfxtp_1
X_7871_ clknet_leaf_101_clk _0776_ VGND VGND VPWR VPWR u_pe_array.u_fifo2.buffer\[5\]\[5\]
+ sky130_fd_sc_hd__dfxtp_1
X_6822_ u_pe_array.u_fifo2.count\[2\] _3382_ _3385_ u_pe_array.u_fifo2.count\[0\]
+ VGND VGND VPWR VPWR _3386_ sky130_fd_sc_hd__o211ai_2
XFILLER_0_9_225 VGND VGND VPWR VPWR sky130_fd_sc_hd__decap_4
X_6753_ _3330_ _3334_ VGND VGND VPWR VPWR _3336_ sky130_fd_sc_hd__or2_1
X_3965_ net98 u_fsm.psum_shift_en _1175_ u_pe_array.g_pe_row\[3\].g_pe_col\[2\].u_pe.move_reg\[8\]
+ VGND VGND VPWR VPWR _0092_ sky130_fd_sc_hd__a22o_1
X_5704_ _2233_ _2512_ _2514_ _2173_ net516 VGND VGND VPWR VPWR _0492_ sky130_fd_sc_hd__a32o_1
X_6684_ _3272_ _3273_ net650 _1007_ VGND VGND VPWR VPWR _0713_ sky130_fd_sc_hd__a2bb2o_1
XFILLER_0_70_85 VGND VGND VPWR VPWR sky130_fd_sc_hd__fill_2
X_3896_ net766 _1135_ _1116_ VGND VGND VPWR VPWR _1136_ sky130_fd_sc_hd__mux2_1
XFILLER_0_72_164 VGND VGND VPWR VPWR sky130_fd_sc_hd__fill_1
X_5635_ u_pe_array.g_pe_row\[1\].g_pe_col\[2\].u_pe.psum_out\[10\] _2462_ _2469_ _2473_
+ VGND VGND VPWR VPWR _2476_ sky130_fd_sc_hd__a2bb2o_1
XFILLER_0_85_3 VPWR VGND VPWR VGND sky130_ef_sc_hd__decap_12
XFILLER_0_72_197 VGND VGND VPWR VPWR sky130_fd_sc_hd__decap_8
Xhold110 _0585_ VGND VGND VPWR VPWR net184 sky130_fd_sc_hd__dlygate4sd3_1
XFILLER_0_13_231 VGND VGND VPWR VPWR sky130_fd_sc_hd__decap_8
X_5566_ u_pe_array.g_pe_row\[1\].g_pe_col\[2\].u_pe.act_val\[3\] _1595_ _2400_ _2399_
+ VGND VGND VPWR VPWR _2414_ sky130_fd_sc_hd__a31o_1
Xhold121 u_pe_array.g_pe_row\[2\].g_pe_col\[0\].u_pe.move_reg\[10\] VGND VGND VPWR
+ VPWR net195 sky130_fd_sc_hd__dlygate4sd3_1
XFILLER_0_79_83 VGND VGND VPWR VPWR sky130_fd_sc_hd__decap_6
Xhold143 _0188_ VGND VGND VPWR VPWR net217 sky130_fd_sc_hd__dlygate4sd3_1
Xhold132 u_pe_array.act_from_up\[6\]\[12\] VGND VGND VPWR VPWR net206 sky130_fd_sc_hd__clkdlybuf4s25_1
X_5497_ u_pe_array.u_fifo2.buffer\[7\]\[3\] _2327_ _2329_ u_pe_array.u_fifo2.buffer\[1\]\[3\]
+ VGND VGND VPWR VPWR _2359_ sky130_fd_sc_hd__a22o_1
X_7305_ clknet_leaf_1_clk _0211_ net944 VGND VGND VPWR VPWR u_pe_array.act_from_right\[10\]\[4\]
+ sky130_fd_sc_hd__dfrtp_1
X_4517_ u_pe_array.g_pe_row\[2\].g_pe_col\[3\].u_pe.psum_out\[6\] u_pe_array.g_pe_row\[2\].g_pe_col\[3\].u_pe.move_reg\[6\]
+ _1599_ VGND VGND VPWR VPWR _1607_ sky130_fd_sc_hd__mux2_1
XFILLER_0_111_472 VPWR VGND VPWR VGND sky130_ef_sc_hd__decap_12
X_7236_ clknet_leaf_15_clk _0142_ net943 VGND VGND VPWR VPWR u_pe_array.g_pe_row\[3\].g_pe_col\[1\].u_pe.psum_out\[4\]
+ sky130_fd_sc_hd__dfrtp_1
Xhold154 u_pe_array.g_pe_row\[1\].g_pe_col\[0\].u_pe.move_reg\[8\] VGND VGND VPWR
+ VPWR net228 sky130_fd_sc_hd__dlygate4sd3_1
Xhold165 _0620_ VGND VGND VPWR VPWR net239 sky130_fd_sc_hd__dlygate4sd3_1
XFILLER_0_13_297 VGND VGND VPWR VPWR sky130_fd_sc_hd__decap_3
Xhold176 u_pe_array.act_from_right\[10\]\[4\] VGND VGND VPWR VPWR net250 sky130_fd_sc_hd__dlygate4sd3_1
X_4448_ u_pe_array.g_pe_row\[3\].g_pe_col\[0\].u_pe.psum_out\[7\] _1287_ VGND VGND
+ VPWR VPWR _1552_ sky130_fd_sc_hd__or2_1
Xhold187 u_pe_array.g_pe_row\[3\].g_pe_col\[2\].u_pe.move_reg\[12\] VGND VGND VPWR
+ VPWR net261 sky130_fd_sc_hd__dlygate4sd3_1
Xhold198 u_pe_array.act_from_up\[4\]\[0\] VGND VGND VPWR VPWR net272 sky130_fd_sc_hd__dlygate4sd3_1
XFILLER_0_95_93 VPWR VGND VPWR VGND sky130_ef_sc_hd__decap_12
X_4379_ u_pe_array.g_pe_row\[3\].g_pe_col\[0\].u_pe.act_val\[0\] _1287_ VGND VGND
+ VPWR VPWR _1489_ sky130_fd_sc_hd__nand2_1
X_7167_ clknet_leaf_7_clk _0073_ net945 VGND VGND VPWR VPWR u_pe_array.act_from_left\[15\]\[2\]
+ sky130_fd_sc_hd__dfrtp_1
X_6118_ _0938_ VGND VGND VPWR VPWR _2853_ sky130_fd_sc_hd__clkbuf_8
XTAP_470 VGND VPWR sky130_fd_sc_hd__tapvpwrvgnd_1
XTAP_481 VGND VPWR sky130_fd_sc_hd__tapvpwrvgnd_1
XTAP_492 VGND VPWR sky130_fd_sc_hd__tapvpwrvgnd_1
X_7098_ clknet_leaf_87_clk _0004_ net948 VGND VGND VPWR VPWR u_fsm.h_cnt\[0\] sky130_fd_sc_hd__dfrtp_1
X_6049_ u_pe_array.g_pe_row\[1\].g_pe_col\[0\].u_pe.psum_out\[7\] _1865_ VGND VGND
+ VPWR VPWR _2799_ sky130_fd_sc_hd__or2_1
XTAP_1614 VGND VPWR sky130_fd_sc_hd__tapvpwrvgnd_1
XTAP_1603 VGND VPWR sky130_fd_sc_hd__tapvpwrvgnd_1
XTAP_1658 VGND VPWR sky130_fd_sc_hd__tapvpwrvgnd_1
XTAP_1647 VGND VPWR sky130_fd_sc_hd__tapvpwrvgnd_1
XTAP_1636 VGND VPWR sky130_fd_sc_hd__tapvpwrvgnd_1
XTAP_1625 VGND VPWR sky130_fd_sc_hd__tapvpwrvgnd_1
XTAP_1669 VGND VPWR sky130_fd_sc_hd__tapvpwrvgnd_1
XFILLER_0_95_278 VGND VGND VPWR VPWR sky130_fd_sc_hd__fill_2
XFILLER_0_49_673 VGND VGND VPWR VPWR sky130_fd_sc_hd__fill_2
XFILLER_0_91_440 VGND VGND VPWR VPWR sky130_fd_sc_hd__decap_8
XFILLER_0_36_323 VGND VGND VPWR VPWR sky130_fd_sc_hd__fill_2
XFILLER_0_36_345 VGND VGND VPWR VPWR sky130_fd_sc_hd__fill_2
XFILLER_0_91_473 VGND VGND VPWR VPWR sky130_fd_sc_hd__decap_6
XFILLER_0_36_378 VPWR VGND VPWR VGND sky130_ef_sc_hd__decap_12
XFILLER_0_91_495 VGND VGND VPWR VPWR sky130_fd_sc_hd__decap_8
XFILLER_0_102_494 VGND VGND VPWR VPWR sky130_fd_sc_hd__decap_4
XFILLER_0_115_69 VPWR VGND VPWR VGND sky130_ef_sc_hd__decap_12
XFILLER_0_27_345 VGND VGND VPWR VPWR sky130_fd_sc_hd__decap_8
X_3750_ _0985_ VGND VGND VPWR VPWR _1007_ sky130_fd_sc_hd__clkbuf_16
XFILLER_0_54_131 VGND VGND VPWR VPWR sky130_fd_sc_hd__decap_8
X_3681_ u_pe_array.g_pe_row\[3\].g_pe_col\[3\].u_pe.psum_out\[9\] u_pe_array.g_pe_row\[3\].g_pe_col\[3\].u_pe.move_reg\[9\]
+ _0947_ VGND VGND VPWR VPWR _0958_ sky130_fd_sc_hd__mux2_1
XFILLER_0_40_55 VPWR VGND VPWR VGND sky130_ef_sc_hd__decap_12
X_5420_ u_pe_array.g_pe_row\[1\].g_pe_col\[2\].u_pe.move_reg\[9\] net62 VGND VGND
+ VPWR VPWR _2302_ sky130_fd_sc_hd__or2_1
X_5351_ _2243_ _2247_ VGND VGND VPWR VPWR _2248_ sky130_fd_sc_hd__xnor2_1
XFILLER_0_2_445 VPWR VGND VPWR VGND sky130_ef_sc_hd__decap_12
X_5282_ u_pe_array.g_pe_row\[1\].g_pe_col\[3\].u_pe.psum_out\[3\] u_pe_array.g_pe_row\[1\].g_pe_col\[3\].u_pe.act_val\[3\]
+ _1423_ VGND VGND VPWR VPWR _2185_ sky130_fd_sc_hd__and3_1
X_4302_ u_pe_array.g_pe_row\[3\].g_pe_col\[0\].u_pe.psum_out\[5\] _1108_ _1110_ _1446_
+ VGND VGND VPWR VPWR _1447_ sky130_fd_sc_hd__o211a_1
XFILLER_0_2_489 VPWR VGND VPWR VGND sky130_ef_sc_hd__decap_12
X_4233_ _1372_ _1382_ u_pe_array.g_pe_row\[3\].g_pe_col\[1\].u_pe.psum_out\[7\] _1368_
+ VGND VGND VPWR VPWR _1390_ sky130_fd_sc_hd__o2bb2a_1
X_7021_ _3504_ VGND VGND VPWR VPWR _0819_ sky130_fd_sc_hd__clkbuf_1
X_4164_ _1325_ _1326_ VGND VGND VPWR VPWR _1327_ sky130_fd_sc_hd__xor2_1
X_4095_ u_pe_array.g_pe_row\[3\].g_pe_col\[0\].u_pe.w_out\[1\] VGND VGND VPWR VPWR
+ _1287_ sky130_fd_sc_hd__clkbuf_8
XFILLER_0_4_77 VGND VGND VPWR VPWR sky130_fd_sc_hd__decap_6
X_7923_ clknet_leaf_76_clk _0828_ VGND VGND VPWR VPWR u_pe_array.u_fifo1.buffer\[4\]\[1\]
+ sky130_fd_sc_hd__dfxtp_1
XFILLER_0_77_223 VGND VGND VPWR VPWR sky130_fd_sc_hd__fill_1
X_7854_ clknet_leaf_86_clk _0759_ VGND VGND VPWR VPWR u_pe_array.u_fifo2.buffer\[3\]\[0\]
+ sky130_fd_sc_hd__dfxtp_1
X_7785_ clknet_leaf_63_clk _0691_ net74 VGND VGND VPWR VPWR u_pe_array.act_from_up\[4\]\[7\]
+ sky130_fd_sc_hd__dfrtp_1
XFILLER_0_58_470 VGND VGND VPWR VPWR sky130_fd_sc_hd__decap_6
X_6805_ u_pe_array.u_fifo2.rd_ptr\[1\] u_pe_array.u_fifo2.rd_ptr\[0\] _3371_ VGND
+ VGND VPWR VPWR _3374_ sky130_fd_sc_hd__and3_1
X_4997_ _1965_ _1973_ _1974_ _1975_ VGND VGND VPWR VPWR _1976_ sky130_fd_sc_hd__a31o_1
X_6736_ _3316_ _3320_ VGND VGND VPWR VPWR _3321_ sky130_fd_sc_hd__or2_1
XFILLER_0_18_334 VGND VGND VPWR VPWR sky130_fd_sc_hd__decap_3
XFILLER_0_46_621 VPWR VGND VPWR VGND sky130_ef_sc_hd__decap_12
X_3948_ _0939_ VGND VGND VPWR VPWR _1167_ sky130_fd_sc_hd__buf_6
XFILLER_0_61_602 VGND VGND VPWR VPWR sky130_fd_sc_hd__decap_3
X_6667_ u_pe_array.g_pe_row\[0\].g_pe_col\[0\].u_pe.act_val\[1\] _3246_ _3256_ _3257_
+ VGND VGND VPWR VPWR _3258_ sky130_fd_sc_hd__nor4_1
X_3879_ u_pe_array.g_pe_row\[3\].g_pe_col\[2\].u_pe.act_val\[2\] VGND VGND VPWR VPWR
+ _1122_ sky130_fd_sc_hd__inv_2
X_6598_ u_pe_array.g_pe_row\[0\].g_pe_col\[1\].u_pe.psum_out\[11\] _3220_ _3211_ VGND
+ VGND VPWR VPWR _3221_ sky130_fd_sc_hd__mux2_1
XFILLER_0_60_145 VGND VGND VPWR VPWR sky130_fd_sc_hd__fill_1
X_5618_ _2460_ _2461_ net860 _1006_ VGND VGND VPWR VPWR _0459_ sky130_fd_sc_hd__a2bb2o_1
XFILLER_0_103_225 VGND VGND VPWR VPWR sky130_fd_sc_hd__fill_2
XFILLER_0_14_584 VGND VGND VPWR VPWR sky130_fd_sc_hd__decap_4
X_5549_ _2278_ _1597_ u_pe_array.g_pe_row\[1\].g_pe_col\[2\].u_pe.psum_out\[3\] VGND
+ VGND VPWR VPWR _2398_ sky130_fd_sc_hd__a21oi_1
X_7219_ clknet_leaf_10_clk _0125_ net945 VGND VGND VPWR VPWR u_pe_array.g_pe_row\[3\].g_pe_col\[1\].u_pe.act_val\[0\]
+ sky130_fd_sc_hd__dfrtp_4
XTAP_1433 VGND VPWR sky130_fd_sc_hd__tapvpwrvgnd_1
XTAP_1411 VGND VPWR sky130_fd_sc_hd__tapvpwrvgnd_1
XTAP_1422 VGND VPWR sky130_fd_sc_hd__tapvpwrvgnd_1
XTAP_1400 VGND VPWR sky130_fd_sc_hd__tapvpwrvgnd_1
XFILLER_0_68_245 VGND VGND VPWR VPWR sky130_fd_sc_hd__decap_6
XTAP_1466 VGND VPWR sky130_fd_sc_hd__tapvpwrvgnd_1
XTAP_1455 VGND VPWR sky130_fd_sc_hd__tapvpwrvgnd_1
XTAP_1444 VGND VPWR sky130_fd_sc_hd__tapvpwrvgnd_1
XTAP_1499 VGND VPWR sky130_fd_sc_hd__tapvpwrvgnd_1
XTAP_1488 VGND VPWR sky130_fd_sc_hd__tapvpwrvgnd_1
XTAP_1477 VGND VPWR sky130_fd_sc_hd__tapvpwrvgnd_1
Xfanout71 net13 VGND VGND VPWR VPWR net71 sky130_fd_sc_hd__buf_12
XFILLER_0_101_27 VPWR VGND VPWR VGND sky130_ef_sc_hd__decap_12
XFILLER_0_52_679 VGND VGND VPWR VPWR sky130_fd_sc_hd__fill_1
XFILLER_0_86_29 VPWR VGND VPWR VGND sky130_ef_sc_hd__decap_12
X_4920_ _1896_ _1900_ VGND VGND VPWR VPWR _1905_ sky130_fd_sc_hd__nor2_1
XFILLER_0_35_88 VPWR VGND VPWR VGND sky130_ef_sc_hd__decap_12
X_4851_ _1865_ _1286_ _0931_ VGND VGND VPWR VPWR _1866_ sky130_fd_sc_hd__mux2_1
X_3802_ _1049_ _1054_ VGND VGND VPWR VPWR _1056_ sky130_fd_sc_hd__nand2_1
XFILLER_0_74_248 VGND VGND VPWR VPWR sky130_fd_sc_hd__decap_4
XFILLER_0_28_632 VGND VGND VPWR VPWR sky130_fd_sc_hd__decap_3
X_7570_ clknet_leaf_44_clk _0476_ net947 VGND VGND VPWR VPWR u_pe_array.act_from_down\[1\]\[10\]
+ sky130_fd_sc_hd__dfrtp_1
XFILLER_0_7_537 VPWR VGND VPWR VGND sky130_ef_sc_hd__decap_12
X_4782_ _1804_ u_pe_array.g_pe_row\[2\].g_pe_col\[2\].u_pe.psum_out\[6\] _0933_ VGND
+ VGND VPWR VPWR _1805_ sky130_fd_sc_hd__and3_1
XFILLER_0_51_65 VGND VGND VPWR VPWR sky130_fd_sc_hd__fill_1
X_6521_ _3149_ _3150_ VGND VGND VPWR VPWR _3151_ sky130_fd_sc_hd__xnor2_2
XFILLER_0_70_421 VGND VGND VPWR VPWR sky130_fd_sc_hd__decap_3
X_3733_ u_pe_array.g_pe_row\[3\].g_pe_col\[3\].u_pe.psum_out\[1\] _0991_ VGND VGND
+ VPWR VPWR _0992_ sky130_fd_sc_hd__or2_1
X_6452_ net276 _3101_ _2987_ _3107_ VGND VGND VPWR VPWR _0647_ sky130_fd_sc_hd__a22o_1
X_3664_ _0939_ VGND VGND VPWR VPWR _0949_ sky130_fd_sc_hd__clkbuf_8
XFILLER_0_43_657 VGND VGND VPWR VPWR sky130_fd_sc_hd__fill_1
X_5403_ u_pe_array.g_pe_row\[1\].g_pe_col\[2\].u_pe.act_val\[5\] VGND VGND VPWR VPWR
+ _2289_ sky130_fd_sc_hd__inv_2
X_3595_ _0871_ _0872_ _0894_ VGND VGND VPWR VPWR _0895_ sky130_fd_sc_hd__o21a_1
X_6383_ _3051_ _3041_ _3039_ VGND VGND VPWR VPWR _3052_ sky130_fd_sc_hd__a21oi_1
XFILLER_0_51_690 VGND VGND VPWR VPWR sky130_fd_sc_hd__fill_1
X_5334_ _1884_ _2231_ _2232_ _2173_ net696 VGND VGND VPWR VPWR _0404_ sky130_fd_sc_hd__a32o_1
XFILLER_0_11_565 VGND VGND VPWR VPWR sky130_fd_sc_hd__fill_1
XFILLER_0_11_554 VGND VGND VPWR VPWR sky130_fd_sc_hd__decap_6
X_5265_ _2162_ _2168_ VGND VGND VPWR VPWR _2170_ sky130_fd_sc_hd__or2_1
XFILLER_0_76_62 VGND VGND VPWR VPWR sky130_fd_sc_hd__decap_4
X_4216_ _1362_ VGND VGND VPWR VPWR _1375_ sky130_fd_sc_hd__inv_2
X_7004_ net729 _3358_ _3491_ VGND VGND VPWR VPWR _3495_ sky130_fd_sc_hd__mux2_1
X_5196_ _2129_ VGND VGND VPWR VPWR _0369_ sky130_fd_sc_hd__clkbuf_1
XFILLER_0_48_3 VPWR VGND VPWR VGND sky130_ef_sc_hd__decap_12
X_4147_ u_pe_array.g_pe_row\[3\].g_pe_col\[1\].u_pe.psum_out\[0\] u_pe_array.g_pe_row\[3\].g_pe_col\[1\].u_pe.act_val\[0\]
+ u_pe_array.g_pe_row\[3\].g_pe_col\[1\].u_pe.w_out\[0\] VGND VGND VPWR VPWR _1312_
+ sky130_fd_sc_hd__nand3_1
X_4078_ _0985_ VGND VGND VPWR VPWR _1273_ sky130_fd_sc_hd__buf_8
XFILLER_0_92_83 VGND VGND VPWR VPWR sky130_fd_sc_hd__fill_1
X_7906_ clknet_leaf_83_clk _0811_ VGND VGND VPWR VPWR u_pe_array.u_fifo1.buffer\[1\]\[2\]
+ sky130_fd_sc_hd__dfxtp_1
XFILLER_0_78_598 VGND VGND VPWR VPWR sky130_fd_sc_hd__decap_4
XFILLER_0_65_204 VGND VGND VPWR VPWR sky130_fd_sc_hd__fill_2
X_7837_ clknet_leaf_87_clk _0742_ VGND VGND VPWR VPWR u_pe_array.u_fifo2.buffer\[0\]\[1\]
+ sky130_fd_sc_hd__dfxtp_1
XFILLER_0_65_237 VGND VGND VPWR VPWR sky130_fd_sc_hd__decap_3
X_7768_ clknet_leaf_49_clk _0674_ net947 VGND VGND VPWR VPWR u_pe_array.g_pe_row\[0\].g_pe_col\[1\].u_pe.psum_out\[5\]
+ sky130_fd_sc_hd__dfrtp_2
X_6719_ _1092_ _3304_ _3305_ _1005_ net525 VGND VGND VPWR VPWR _0716_ sky130_fd_sc_hd__a32o_1
X_7699_ clknet_leaf_75_clk _0605_ net949 VGND VGND VPWR VPWR u_pe_array.act_from_up\[6\]\[3\]
+ sky130_fd_sc_hd__dfrtp_1
XFILLER_0_6_581 VGND VGND VPWR VPWR sky130_fd_sc_hd__decap_6
XFILLER_0_33_167 VGND VGND VPWR VPWR sky130_fd_sc_hd__fill_1
XFILLER_0_33_178 VGND VGND VPWR VPWR sky130_fd_sc_hd__decap_4
XFILLER_0_104_589 VGND VGND VPWR VPWR sky130_fd_sc_hd__decap_6
XFILLER_0_88_307 VGND VGND VPWR VPWR sky130_fd_sc_hd__fill_1
XFILLER_0_88_318 VPWR VGND VPWR VGND sky130_ef_sc_hd__decap_12
XFILLER_0_96_340 VGND VGND VPWR VPWR sky130_fd_sc_hd__fill_1
XFILLER_0_96_362 VGND VGND VPWR VPWR sky130_fd_sc_hd__fill_2
XTAP_1241 VGND VPWR sky130_fd_sc_hd__tapvpwrvgnd_1
XTAP_1230 VGND VPWR sky130_fd_sc_hd__tapvpwrvgnd_1
XFILLER_0_84_557 VGND VGND VPWR VPWR sky130_fd_sc_hd__decap_8
XTAP_1274 VGND VPWR sky130_fd_sc_hd__tapvpwrvgnd_1
XTAP_1263 VGND VPWR sky130_fd_sc_hd__tapvpwrvgnd_1
XTAP_1252 VGND VPWR sky130_fd_sc_hd__tapvpwrvgnd_1
XFILLER_0_112_26 VGND VGND VPWR VPWR sky130_fd_sc_hd__fill_2
XTAP_1296 VGND VPWR sky130_fd_sc_hd__tapvpwrvgnd_1
XTAP_1285 VGND VPWR sky130_fd_sc_hd__tapvpwrvgnd_1
XFILLER_0_21_35 VGND VGND VPWR VPWR sky130_fd_sc_hd__fill_1
XFILLER_0_25_613 VGND VGND VPWR VPWR sky130_fd_sc_hd__decap_3
XFILLER_0_52_421 VGND VGND VPWR VPWR sky130_fd_sc_hd__fill_1
XFILLER_0_21_57 VPWR VGND VPWR VGND sky130_ef_sc_hd__decap_12
Xhold709 u_pe_array.g_pe_row\[2\].g_pe_col\[3\].u_pe.psum_out\[7\] VGND VGND VPWR
+ VPWR net783 sky130_fd_sc_hd__dlygate4sd3_1
XFILLER_0_110_504 VPWR VGND VPWR VGND sky130_ef_sc_hd__decap_12
XFILLER_0_20_362 VGND VGND VPWR VPWR sky130_fd_sc_hd__fill_2
X_5050_ u_pe_array.g_pe_row\[2\].g_pe_col\[0\].u_pe.psum_out\[10\] u_pe_array.g_pe_row\[2\].g_pe_col\[0\].u_pe.move_reg\[10\]
+ _1867_ VGND VGND VPWR VPWR _2013_ sky130_fd_sc_hd__mux2_1
X_4001_ _1199_ _1201_ _1203_ VGND VGND VPWR VPWR _1204_ sky130_fd_sc_hd__o21ai_1
XFILLER_0_46_54 VGND VGND VPWR VPWR sky130_fd_sc_hd__decap_6
XFILLER_0_79_329 VGND VGND VPWR VPWR sky130_fd_sc_hd__decap_6
X_5952_ u_pe_array.u_fifo1.buffer\[5\]\[4\] _2687_ _2688_ u_pe_array.u_fifo1.buffer\[6\]\[4\]
+ _2689_ VGND VGND VPWR VPWR _2718_ sky130_fd_sc_hd__a221o_1
X_4903_ _1888_ _1889_ VGND VGND VPWR VPWR _1890_ sky130_fd_sc_hd__xor2_1
XFILLER_0_118_615 VGND VGND VPWR VPWR sky130_fd_sc_hd__fill_1
XFILLER_0_62_97 VGND VGND VPWR VPWR sky130_fd_sc_hd__fill_1
X_5883_ u_pe_array.g_pe_row\[1\].g_pe_col\[0\].u_pe.psum_out\[12\] _1112_ _1109_ _2666_
+ VGND VGND VPWR VPWR _2667_ sky130_fd_sc_hd__o211a_2
XFILLER_0_75_557 VGND VGND VPWR VPWR sky130_fd_sc_hd__decap_3
X_7622_ clknet_leaf_89_clk _0528_ net949 VGND VGND VPWR VPWR u_pe_array.act_from_left\[5\]\[8\]
+ sky130_fd_sc_hd__dfrtp_1
X_4834_ _1846_ _1851_ _1092_ VGND VGND VPWR VPWR _1853_ sky130_fd_sc_hd__o21ai_1
XFILLER_0_117_136 VPWR VGND VPWR VGND sky130_ef_sc_hd__decap_12
X_4765_ _1787_ _1788_ VGND VGND VPWR VPWR _1790_ sky130_fd_sc_hd__and2_1
X_7553_ clknet_leaf_92_clk _0459_ net949 VGND VGND VPWR VPWR u_pe_array.g_pe_row\[1\].g_pe_col\[2\].u_pe.psum_out\[8\]
+ sky130_fd_sc_hd__dfrtp_2
X_6504_ _3127_ _3131_ VGND VGND VPWR VPWR _3135_ sky130_fd_sc_hd__nor2_1
XFILLER_0_83_590 VGND VGND VPWR VPWR sky130_fd_sc_hd__decap_3
X_3716_ _0976_ VGND VGND VPWR VPWR _0042_ sky130_fd_sc_hd__clkbuf_1
XFILLER_0_55_281 VGND VGND VPWR VPWR sky130_fd_sc_hd__decap_3
XFILLER_0_113_331 VGND VGND VPWR VPWR sky130_fd_sc_hd__fill_1
X_7484_ clknet_leaf_42_clk _0390_ net946 VGND VGND VPWR VPWR u_pe_array.g_pe_row\[1\].g_pe_col\[3\].u_pe.move_reg\[6\]
+ sky130_fd_sc_hd__dfrtp_1
XFILLER_0_31_605 VGND VGND VPWR VPWR sky130_fd_sc_hd__decap_8
XFILLER_0_31_627 VGND VGND VPWR VPWR sky130_fd_sc_hd__decap_6
X_4696_ net100 _1732_ _1735_ _1743_ VGND VGND VPWR VPWR _0255_ sky130_fd_sc_hd__a22o_1
X_6435_ _3096_ _3097_ VGND VGND VPWR VPWR _3098_ sky130_fd_sc_hd__xnor2_1
X_3647_ u_pe_array.g_pe_row\[3\].g_pe_col\[2\].u_pe.w_out\[1\] VGND VGND VPWR VPWR
+ _0934_ sky130_fd_sc_hd__buf_6
XFILLER_0_3_573 VPWR VGND VPWR VGND sky130_ef_sc_hd__decap_12
XFILLER_0_15_189 VPWR VGND VPWR VGND sky130_ef_sc_hd__decap_12
XFILLER_0_113_386 VGND VGND VPWR VPWR sky130_fd_sc_hd__decap_6
X_3578_ _0860_ u_fsm.next_state\[2\] _0882_ _0879_ VGND VGND VPWR VPWR _0884_ sky130_fd_sc_hd__o211a_1
X_6366_ u_pe_array.g_pe_row\[0\].g_pe_col\[2\].u_pe.psum_out\[5\] _3035_ VGND VGND
+ VPWR VPWR _3036_ sky130_fd_sc_hd__xnor2_1
XFILLER_0_87_94 VPWR VGND VPWR VGND sky130_ef_sc_hd__decap_12
X_5317_ u_pe_array.g_pe_row\[1\].g_pe_col\[3\].u_pe.act_val\[5\] _2164_ u_pe_array.g_pe_row\[1\].g_pe_col\[3\].u_pe.psum_out\[6\]
+ VGND VGND VPWR VPWR _2217_ sky130_fd_sc_hd__o21ba_1
X_6297_ net544 u_pe_array.g_pe_row\[0\].g_pe_col\[2\].u_pe.move_reg\[12\] _2844_ VGND
+ VGND VPWR VPWR _2986_ sky130_fd_sc_hd__mux2_1
Xhold14 _0094_ VGND VGND VPWR VPWR net88 sky130_fd_sc_hd__dlygate4sd3_1
X_5248_ _2157_ VGND VGND VPWR VPWR _0393_ sky130_fd_sc_hd__clkbuf_1
Xhold36 u_pe_array.act_from_right\[13\]\[12\] VGND VGND VPWR VPWR net110 sky130_fd_sc_hd__dlygate4sd3_1
Xhold25 _0092_ VGND VGND VPWR VPWR net99 sky130_fd_sc_hd__dlygate4sd3_1
Xhold47 u_pe_array.act_from_right\[13\]\[7\] VGND VGND VPWR VPWR net121 sky130_fd_sc_hd__dlygate4sd3_1
X_5179_ _2111_ _2115_ VGND VGND VPWR VPWR _2116_ sky130_fd_sc_hd__nand2_1
Xhold58 u_pe_array.act_from_down\[3\]\[10\] VGND VGND VPWR VPWR net132 sky130_fd_sc_hd__dlygate4sd3_1
Xhold69 u_pe_array.act_from_left\[5\]\[10\] VGND VGND VPWR VPWR net143 sky130_fd_sc_hd__dlygate4sd3_1
XFILLER_0_78_362 VGND VGND VPWR VPWR sky130_fd_sc_hd__fill_2
XFILLER_0_38_204 VGND VGND VPWR VPWR sky130_fd_sc_hd__decap_6
XFILLER_0_109_637 VPWR VGND VPWR VGND sky130_ef_sc_hd__decap_12
XFILLER_0_66_579 VGND VGND VPWR VPWR sky130_fd_sc_hd__decap_8
XFILLER_0_66_557 VPWR VGND VPWR VGND sky130_ef_sc_hd__decap_12
XFILLER_0_108_158 VGND VGND VPWR VPWR sky130_fd_sc_hd__decap_4
XFILLER_0_34_421 VPWR VGND VPWR VGND sky130_ef_sc_hd__decap_12
XFILLER_0_34_443 VGND VGND VPWR VPWR sky130_fd_sc_hd__decap_8
XFILLER_0_30_693 VGND VGND VPWR VPWR sky130_fd_sc_hd__decap_6
XFILLER_0_100_581 VGND VGND VPWR VPWR sky130_fd_sc_hd__fill_1
XFILLER_0_107_15 VPWR VGND VPWR VGND sky130_ef_sc_hd__decap_12
XFILLER_0_89_605 VGND VGND VPWR VPWR sky130_fd_sc_hd__fill_1
XFILLER_0_69_340 VGND VGND VPWR VPWR sky130_fd_sc_hd__decap_8
XFILLER_0_8_109 VPWR VGND VPWR VGND sky130_ef_sc_hd__decap_12
XFILLER_0_29_215 VGND VGND VPWR VPWR sky130_fd_sc_hd__decap_4
XTAP_1082 VGND VPWR sky130_fd_sc_hd__tapvpwrvgnd_1
XTAP_1071 VGND VPWR sky130_fd_sc_hd__tapvpwrvgnd_1
XTAP_1060 VGND VPWR sky130_fd_sc_hd__tapvpwrvgnd_1
XTAP_1093 VGND VPWR sky130_fd_sc_hd__tapvpwrvgnd_1
XFILLER_0_25_432 VGND VGND VPWR VPWR sky130_fd_sc_hd__decap_3
XFILLER_0_37_281 VGND VGND VPWR VPWR sky130_fd_sc_hd__decap_4
XFILLER_0_114_139 VGND VGND VPWR VPWR sky130_fd_sc_hd__fill_1
XFILLER_0_108_681 VPWR VGND VPWR VGND sky130_ef_sc_hd__decap_12
XFILLER_0_106_3 VPWR VGND VPWR VGND sky130_ef_sc_hd__decap_12
XFILLER_0_4_348 VGND VGND VPWR VPWR sky130_fd_sc_hd__decap_6
X_4550_ _1617_ _1618_ _1616_ VGND VGND VPWR VPWR _1619_ sky130_fd_sc_hd__o21ai_1
XFILLER_0_107_191 VPWR VGND VPWR VGND sky130_ef_sc_hd__decap_12
XFILLER_0_80_582 VGND VGND VPWR VPWR sky130_fd_sc_hd__decap_6
Xhold506 u_pe_array.u_fifo2.buffer\[2\]\[4\] VGND VGND VPWR VPWR net580 sky130_fd_sc_hd__dlygate4sd3_1
XFILLER_0_13_627 VGND VGND VPWR VPWR sky130_fd_sc_hd__decap_3
Xhold517 u_pe_array.u_fifo1.buffer\[7\]\[3\] VGND VGND VPWR VPWR net591 sky130_fd_sc_hd__dlygate4sd3_1
X_4481_ _1570_ _1580_ _1581_ VGND VGND VPWR VPWR _1582_ sky130_fd_sc_hd__a21oi_1
XFILLER_0_52_284 VGND VGND VPWR VPWR sky130_fd_sc_hd__decap_3
X_6220_ u_pe_array.g_pe_row\[0\].g_pe_col\[3\].u_pe.psum_out\[7\] _1999_ VGND VGND
+ VPWR VPWR _2929_ sky130_fd_sc_hd__or2_1
Xhold528 u_pe_array.g_pe_row\[3\].g_pe_col\[0\].u_pe.act_val\[1\] VGND VGND VPWR VPWR
+ net602 sky130_fd_sc_hd__dlygate4sd3_1
Xhold539 u_pe_array.u_fifo1.buffer\[4\]\[0\] VGND VGND VPWR VPWR net613 sky130_fd_sc_hd__dlygate4sd3_1
X_6151_ _2862_ _2865_ VGND VGND VPWR VPWR _2866_ sky130_fd_sc_hd__xnor2_1
XTAP_800 VGND VPWR sky130_fd_sc_hd__tapvpwrvgnd_1
X_5102_ _2031_ _2032_ _2045_ VGND VGND VPWR VPWR _2046_ sky130_fd_sc_hd__o21a_1
XFILLER_0_57_53 VGND VGND VPWR VPWR sky130_fd_sc_hd__decap_3
XTAP_811 VGND VPWR sky130_fd_sc_hd__tapvpwrvgnd_1
XTAP_822 VGND VPWR sky130_fd_sc_hd__tapvpwrvgnd_1
XTAP_844 VGND VPWR sky130_fd_sc_hd__tapvpwrvgnd_1
XTAP_833 VGND VPWR sky130_fd_sc_hd__tapvpwrvgnd_1
X_6082_ _2817_ _2827_ _2828_ VGND VGND VPWR VPWR _2829_ sky130_fd_sc_hd__a21oi_1
XTAP_855 VGND VPWR sky130_fd_sc_hd__tapvpwrvgnd_1
XTAP_866 VGND VPWR sky130_fd_sc_hd__tapvpwrvgnd_1
XTAP_877 VGND VPWR sky130_fd_sc_hd__tapvpwrvgnd_1
X_5033_ net491 _1732_ _1735_ _2003_ VGND VGND VPWR VPWR _0332_ sky130_fd_sc_hd__a22o_1
XTAP_888 VGND VPWR sky130_fd_sc_hd__tapvpwrvgnd_1
XTAP_899 VGND VPWR sky130_fd_sc_hd__tapvpwrvgnd_1
XFILLER_0_79_126 VGND VGND VPWR VPWR sky130_fd_sc_hd__decap_3
X_6984_ _3350_ _3483_ VGND VGND VPWR VPWR _3484_ sky130_fd_sc_hd__and2_2
XFILLER_0_48_502 VGND VGND VPWR VPWR sky130_fd_sc_hd__fill_2
XFILLER_0_88_693 VGND VGND VPWR VPWR sky130_fd_sc_hd__decap_6
X_5935_ u_pe_array.u_fifo1.buffer\[7\]\[2\] _2681_ _2683_ u_pe_array.u_fifo1.buffer\[1\]\[2\]
+ VGND VGND VPWR VPWR _2703_ sky130_fd_sc_hd__a22o_1
XFILLER_0_75_365 VGND VGND VPWR VPWR sky130_fd_sc_hd__decap_4
X_5866_ u_pe_array.g_pe_row\[1\].g_pe_col\[0\].u_pe.move_reg\[8\] net62 VGND VGND
+ VPWR VPWR _2654_ sky130_fd_sc_hd__or2_1
Xclkbuf_leaf_60_clk clknet_3_7__leaf_clk VGND VGND VPWR VPWR clknet_leaf_60_clk sky130_fd_sc_hd__clkbuf_16
X_7605_ clknet_leaf_79_clk _0511_ net948 VGND VGND VPWR VPWR net43 sky130_fd_sc_hd__dfrtp_1
X_4817_ _1003_ _1837_ VGND VGND VPWR VPWR _1838_ sky130_fd_sc_hd__nor2_1
XFILLER_0_35_218 VGND VGND VPWR VPWR sky130_fd_sc_hd__decap_6
X_5797_ net370 _2586_ _2597_ _2599_ VGND VGND VPWR VPWR _0500_ sky130_fd_sc_hd__a22o_1
XFILLER_0_8_676 VPWR VGND VPWR VGND sky130_ef_sc_hd__decap_12
XFILLER_0_16_421 VPWR VGND VPWR VGND sky130_ef_sc_hd__decap_12
X_4748_ _1772_ u_pe_array.g_pe_row\[2\].g_pe_col\[2\].u_pe.act_val\[3\] u_pe_array.g_pe_row\[2\].g_pe_col\[2\].u_pe.w_out\[0\]
+ _0933_ VGND VGND VPWR VPWR _1774_ sky130_fd_sc_hd__nand4_1
X_7536_ clknet_leaf_88_clk _0442_ net948 VGND VGND VPWR VPWR u_pe_array.g_pe_row\[1\].g_pe_col\[2\].u_pe.act_val\[4\]
+ sky130_fd_sc_hd__dfrtp_2
XFILLER_0_43_262 VGND VGND VPWR VPWR sky130_fd_sc_hd__fill_1
X_7467_ clknet_leaf_65_clk _0373_ net946 VGND VGND VPWR VPWR u_pe_array.act_from_down\[3\]\[2\]
+ sky130_fd_sc_hd__dfrtp_1
XFILLER_0_71_593 VGND VGND VPWR VPWR sky130_fd_sc_hd__decap_3
X_4679_ _1733_ VGND VGND VPWR VPWR _1734_ sky130_fd_sc_hd__buf_4
XFILLER_0_113_161 VGND VGND VPWR VPWR sky130_fd_sc_hd__decap_6
X_6418_ u_pe_array.g_pe_row\[0\].g_pe_col\[2\].u_pe.psum_out\[10\] _2130_ VGND VGND
+ VPWR VPWR _3083_ sky130_fd_sc_hd__nand2_1
Xoutput48 net48 VGND VGND VPWR VPWR psum_out0[9] sky130_fd_sc_hd__clkbuf_4
Xoutput37 net37 VGND VGND VPWR VPWR psum_out0[10] sky130_fd_sc_hd__clkbuf_4
XFILLER_0_101_345 VGND VGND VPWR VPWR sky130_fd_sc_hd__fill_1
X_7398_ clknet_leaf_22_clk net379 net942 VGND VGND VPWR VPWR u_pe_array.g_pe_row\[2\].g_pe_col\[1\].u_pe.act_val\[2\]
+ sky130_fd_sc_hd__dfrtp_2
Xoutput59 net59 VGND VGND VPWR VPWR psum_out1[7] sky130_fd_sc_hd__clkbuf_4
XFILLER_0_12_693 VGND VGND VPWR VPWR sky130_fd_sc_hd__decap_6
X_6349_ u_pe_array.g_pe_row\[0\].g_pe_col\[2\].u_pe.act_val\[4\] _2128_ VGND VGND
+ VPWR VPWR _3020_ sky130_fd_sc_hd__nand2_1
XFILLER_0_98_402 VGND VGND VPWR VPWR sky130_fd_sc_hd__fill_2
XFILLER_0_79_671 VGND VGND VPWR VPWR sky130_fd_sc_hd__fill_1
XFILLER_0_39_502 VGND VGND VPWR VPWR sky130_fd_sc_hd__fill_2
XFILLER_0_39_513 VGND VGND VPWR VPWR sky130_fd_sc_hd__decap_4
XPHY_143 VGND VGND VPWR VPWR sky130_fd_sc_hd__decap_3
XPHY_132 VGND VGND VPWR VPWR sky130_fd_sc_hd__decap_3
XPHY_121 VGND VGND VPWR VPWR sky130_fd_sc_hd__decap_3
XPHY_110 VGND VGND VPWR VPWR sky130_fd_sc_hd__decap_3
XFILLER_0_39_557 VGND VGND VPWR VPWR sky130_fd_sc_hd__decap_3
Xclkbuf_leaf_51_clk clknet_3_7__leaf_clk VGND VGND VPWR VPWR clknet_leaf_51_clk sky130_fd_sc_hd__clkbuf_16
XPHY_176 VGND VGND VPWR VPWR sky130_fd_sc_hd__decap_3
XPHY_165 VGND VGND VPWR VPWR sky130_fd_sc_hd__decap_3
XPHY_154 VGND VGND VPWR VPWR sky130_fd_sc_hd__decap_3
XFILLER_0_66_365 VPWR VGND VPWR VGND sky130_ef_sc_hd__decap_12
XFILLER_0_54_516 VGND VGND VPWR VPWR sky130_fd_sc_hd__fill_1
XPHY_198 VGND VGND VPWR VPWR sky130_fd_sc_hd__decap_3
XPHY_187 VGND VGND VPWR VPWR sky130_fd_sc_hd__decap_3
XFILLER_0_81_324 VPWR VGND VPWR VGND sky130_ef_sc_hd__decap_12
XFILLER_0_34_240 VGND VGND VPWR VPWR sky130_fd_sc_hd__fill_1
XFILLER_0_105_673 VPWR VGND VPWR VGND sky130_ef_sc_hd__decap_12
XFILLER_0_104_172 VGND VGND VPWR VPWR sky130_fd_sc_hd__fill_2
XFILLER_0_94_29 VPWR VGND VPWR VGND sky130_ef_sc_hd__decap_12
XFILLER_0_27_89 VGND VGND VPWR VPWR sky130_fd_sc_hd__fill_2
XFILLER_0_43_11 VGND VGND VPWR VPWR sky130_fd_sc_hd__fill_2
X_3981_ u_pe_array.g_pe_row\[3\].g_pe_col\[2\].u_pe.act_val\[1\] _0934_ VGND VGND
+ VPWR VPWR _1185_ sky130_fd_sc_hd__or2b_1
XPHY_1 VGND VGND VPWR VPWR sky130_fd_sc_hd__decap_3
X_5720_ _2522_ _2528_ VGND VGND VPWR VPWR _2529_ sky130_fd_sc_hd__nor2_1
XFILLER_0_85_641 VGND VGND VPWR VPWR sky130_fd_sc_hd__fill_1
Xclkbuf_leaf_42_clk clknet_3_6__leaf_clk VGND VGND VPWR VPWR clknet_leaf_42_clk sky130_fd_sc_hd__clkbuf_16
X_5651_ _2488_ _1865_ _0931_ VGND VGND VPWR VPWR _2489_ sky130_fd_sc_hd__mux2_1
X_4602_ _1665_ _1666_ VGND VGND VPWR VPWR _1667_ sky130_fd_sc_hd__nor2_1
X_5582_ _2417_ _2418_ _2415_ VGND VGND VPWR VPWR _2429_ sky130_fd_sc_hd__o21ba_1
X_7321_ clknet_leaf_17_clk net442 net945 VGND VGND VPWR VPWR u_pe_array.g_pe_row\[2\].g_pe_col\[3\].u_pe.move_reg\[7\]
+ sky130_fd_sc_hd__dfrtp_1
XFILLER_0_13_424 VGND VGND VPWR VPWR sky130_fd_sc_hd__fill_1
XFILLER_0_25_273 VGND VGND VPWR VPWR sky130_fd_sc_hd__fill_1
X_4533_ u_pe_array.g_pe_row\[2\].g_pe_col\[3\].u_pe.act_val\[1\] _1605_ _1611_ net125
+ VGND VGND VPWR VPWR _0221_ sky130_fd_sc_hd__a22o_1
XFILLER_0_111_610 VGND VGND VPWR VPWR sky130_fd_sc_hd__decap_6
Xhold303 u_pe_array.g_pe_row\[0\].g_pe_col\[1\].u_pe.act_val\[2\] VGND VGND VPWR VPWR
+ net377 sky130_fd_sc_hd__dlygate4sd3_1
XFILLER_0_102_109 VPWR VGND VPWR VGND sky130_ef_sc_hd__decap_12
Xhold325 _0655_ VGND VGND VPWR VPWR net399 sky130_fd_sc_hd__dlygate4sd3_1
Xhold314 u_pe_array.g_pe_row\[3\].g_pe_col\[1\].u_pe.psum_out\[7\] VGND VGND VPWR
+ VPWR net388 sky130_fd_sc_hd__dlygate4sd3_1
X_7252_ clknet_leaf_102_clk _0158_ net950 VGND VGND VPWR VPWR net57 sky130_fd_sc_hd__dfrtp_1
XFILLER_0_4_189 VGND VGND VPWR VPWR sky130_fd_sc_hd__decap_6
Xhold347 u_pe_array.act_from_down\[1\]\[9\] VGND VGND VPWR VPWR net421 sky130_fd_sc_hd__dlygate4sd3_1
X_6203_ _2912_ u_pe_array.g_pe_row\[0\].g_pe_col\[3\].u_pe.psum_out\[6\] _1999_ VGND
+ VGND VPWR VPWR _2913_ sky130_fd_sc_hd__and3_1
Xhold336 u_pe_array.g_pe_row\[3\].g_pe_col\[3\].u_pe.move_reg\[12\] VGND VGND VPWR
+ VPWR net410 sky130_fd_sc_hd__dlygate4sd3_1
XFILLER_0_7_55 VGND VGND VPWR VPWR sky130_fd_sc_hd__fill_1
Xhold369 u_pe_array.g_pe_row\[2\].g_pe_col\[2\].u_pe.psum_out\[7\] VGND VGND VPWR
+ VPWR net443 sky130_fd_sc_hd__dlygate4sd3_1
Xhold358 u_pe_array.g_pe_row\[2\].g_pe_col\[2\].u_pe.move_reg\[9\] VGND VGND VPWR
+ VPWR net432 sky130_fd_sc_hd__dlygate4sd3_1
X_4464_ _1559_ _1561_ _1566_ VGND VGND VPWR VPWR _1567_ sky130_fd_sc_hd__or3_1
XFILLER_0_68_85 VGND VGND VPWR VPWR sky130_fd_sc_hd__decap_8
X_4395_ _1502_ _1503_ net838 _1006_ VGND VGND VPWR VPWR _0194_ sky130_fd_sc_hd__a2bb2o_1
X_7183_ clknet_leaf_102_clk _0089_ net944 VGND VGND VPWR VPWR u_pe_array.g_pe_row\[3\].g_pe_col\[2\].u_pe.act_val\[5\]
+ sky130_fd_sc_hd__dfrtp_1
XFILLER_0_110_197 VPWR VGND VPWR VGND sky130_ef_sc_hd__decap_12
X_6134_ u_pe_array.g_pe_row\[0\].g_pe_col\[3\].u_pe.act_val\[3\] _2853_ _2847_ net425
+ VGND VGND VPWR VPWR _0577_ sky130_fd_sc_hd__a22o_1
XTAP_630 VGND VPWR sky130_fd_sc_hd__tapvpwrvgnd_1
XTAP_641 VGND VPWR sky130_fd_sc_hd__tapvpwrvgnd_1
XTAP_652 VGND VPWR sky130_fd_sc_hd__tapvpwrvgnd_1
XTAP_663 VGND VPWR sky130_fd_sc_hd__tapvpwrvgnd_1
XTAP_685 VGND VPWR sky130_fd_sc_hd__tapvpwrvgnd_1
XTAP_674 VGND VPWR sky130_fd_sc_hd__tapvpwrvgnd_1
X_6065_ _2806_ _2808_ _2813_ VGND VGND VPWR VPWR _2814_ sky130_fd_sc_hd__or3_1
X_5016_ _1984_ _1986_ _1991_ VGND VGND VPWR VPWR _1993_ sky130_fd_sc_hd__or3_1
XFILLER_0_30_3 VPWR VGND VPWR VGND sky130_ef_sc_hd__decap_12
XTAP_696 VGND VPWR sky130_fd_sc_hd__tapvpwrvgnd_1
XFILLER_0_95_449 VGND VGND VPWR VPWR sky130_fd_sc_hd__decap_3
XFILLER_0_67_129 VGND VGND VPWR VPWR sky130_fd_sc_hd__decap_4
X_6967_ _3463_ _3349_ VGND VGND VPWR VPWR _3471_ sky130_fd_sc_hd__nand2b_2
X_5918_ u_pe_array.u_fifo1.rd_ptr\[0\] u_pe_array.u_fifo1.rd_ptr\[3\] u_pe_array.u_fifo1.rd_ptr\[2\]
+ u_pe_array.u_fifo1.rd_ptr\[1\] VGND VGND VPWR VPWR _2688_ sky130_fd_sc_hd__and4bb_2
Xclkbuf_leaf_33_clk clknet_3_3__leaf_clk VGND VGND VPWR VPWR clknet_leaf_33_clk sky130_fd_sc_hd__clkbuf_16
X_6898_ u_pe_array.u_fifo2.wr_ptr\[1\] _3422_ u_pe_array.u_fifo2.wr_ptr\[0\] VGND
+ VGND VPWR VPWR _3430_ sky130_fd_sc_hd__or3b_1
XFILLER_0_36_527 VGND VGND VPWR VPWR sky130_fd_sc_hd__decap_4
XFILLER_0_48_365 VGND VGND VPWR VPWR sky130_fd_sc_hd__decap_6
XFILLER_0_118_253 VPWR VGND VPWR VGND sky130_ef_sc_hd__decap_12
XFILLER_0_63_335 VGND VGND VPWR VPWR sky130_fd_sc_hd__fill_1
X_5849_ u_pe_array.g_pe_row\[1\].g_pe_col\[0\].u_pe.act_val\[4\] _1118_ VGND VGND
+ VPWR VPWR _2641_ sky130_fd_sc_hd__or2_1
XFILLER_0_91_666 VGND VGND VPWR VPWR sky130_fd_sc_hd__decap_6
X_7519_ clknet_leaf_39_clk _0425_ net947 VGND VGND VPWR VPWR u_pe_array.act_from_left\[7\]\[0\]
+ sky130_fd_sc_hd__dfrtp_1
XFILLER_0_31_265 VGND VGND VPWR VPWR sky130_fd_sc_hd__decap_4
XFILLER_0_101_153 VPWR VGND VPWR VGND sky130_ef_sc_hd__decap_12
XFILLER_0_101_175 VGND VGND VPWR VPWR sky130_fd_sc_hd__fill_1
XFILLER_0_86_405 VGND VGND VPWR VPWR sky130_fd_sc_hd__decap_3
XFILLER_0_104_27 VGND VGND VPWR VPWR sky130_fd_sc_hd__fill_1
XFILLER_0_67_641 VGND VGND VPWR VPWR sky130_fd_sc_hd__decap_8
XFILLER_0_109_231 VGND VGND VPWR VPWR sky130_fd_sc_hd__fill_1
Xclkbuf_leaf_24_clk clknet_3_2__leaf_clk VGND VGND VPWR VPWR clknet_leaf_24_clk sky130_fd_sc_hd__clkbuf_16
XFILLER_0_67_685 VPWR VGND VPWR VGND sky130_ef_sc_hd__decap_12
XFILLER_0_27_505 VGND VGND VPWR VPWR sky130_fd_sc_hd__decap_8
XFILLER_0_81_121 VGND VGND VPWR VPWR sky130_fd_sc_hd__decap_6
XFILLER_0_13_69 VGND VGND VPWR VPWR sky130_fd_sc_hd__decap_3
XFILLER_0_35_593 VGND VGND VPWR VPWR sky130_fd_sc_hd__fill_2
XFILLER_0_1_137 VPWR VGND VPWR VGND sky130_ef_sc_hd__decap_12
XFILLER_0_22_265 VPWR VGND VPWR VGND sky130_ef_sc_hd__decap_12
X_4180_ _1340_ _1336_ _1338_ VGND VGND VPWR VPWR _1342_ sky130_fd_sc_hd__or3_1
X_7870_ clknet_leaf_101_clk _0775_ VGND VGND VPWR VPWR u_pe_array.u_fifo2.buffer\[5\]\[4\]
+ sky130_fd_sc_hd__dfxtp_1
X_6821_ _3384_ _3385_ VGND VGND VPWR VPWR _0738_ sky130_fd_sc_hd__xnor2_1
X_6752_ _3330_ _3334_ VGND VGND VPWR VPWR _3335_ sky130_fd_sc_hd__nand2_1
XFILLER_0_92_419 VGND VGND VPWR VPWR sky130_fd_sc_hd__fill_1
XFILLER_0_85_471 VGND VGND VPWR VPWR sky130_fd_sc_hd__decap_6
Xclkbuf_leaf_15_clk clknet_3_2__leaf_clk VGND VGND VPWR VPWR clknet_leaf_15_clk sky130_fd_sc_hd__clkbuf_16
X_3964_ net100 u_fsm.psum_shift_en _1175_ u_pe_array.g_pe_row\[3\].g_pe_col\[2\].u_pe.move_reg\[7\]
+ VGND VGND VPWR VPWR _0091_ sky130_fd_sc_hd__a22o_1
X_5703_ _2513_ VGND VGND VPWR VPWR _2514_ sky130_fd_sc_hd__inv_2
X_6683_ _3264_ _3263_ _3271_ _0879_ VGND VGND VPWR VPWR _3273_ sky130_fd_sc_hd__a31o_1
X_3895_ u_pe_array.g_pe_row\[3\].g_pe_col\[2\].u_pe.psum_out\[5\] _1108_ _1110_ _1134_
+ VGND VGND VPWR VPWR _1135_ sky130_fd_sc_hd__o211a_2
XFILLER_0_45_335 VGND VGND VPWR VPWR sky130_fd_sc_hd__fill_1
XFILLER_0_115_223 VGND VGND VPWR VPWR sky130_fd_sc_hd__fill_1
XFILLER_0_60_305 VGND VGND VPWR VPWR sky130_fd_sc_hd__decap_3
XFILLER_0_45_357 VPWR VGND VPWR VGND sky130_ef_sc_hd__decap_12
X_5634_ _2233_ _2474_ _2475_ _2173_ net678 VGND VGND VPWR VPWR _0461_ sky130_fd_sc_hd__a32o_1
XFILLER_0_72_176 VGND VGND VPWR VPWR sky130_fd_sc_hd__fill_1
XFILLER_0_5_432 VGND VGND VPWR VPWR sky130_fd_sc_hd__decap_8
XFILLER_0_26_582 VGND VGND VPWR VPWR sky130_fd_sc_hd__decap_6
XFILLER_0_78_3 VGND VGND VPWR VPWR sky130_fd_sc_hd__decap_8
Xhold100 _0263_ VGND VGND VPWR VPWR net174 sky130_fd_sc_hd__dlygate4sd3_1
X_7304_ clknet_leaf_106_clk _0210_ net944 VGND VGND VPWR VPWR u_pe_array.act_from_right\[10\]\[3\]
+ sky130_fd_sc_hd__dfrtp_1
X_5565_ _2409_ _2412_ VGND VGND VPWR VPWR _2413_ sky130_fd_sc_hd__xnor2_1
XFILLER_0_53_390 VGND VGND VPWR VPWR sky130_fd_sc_hd__fill_2
Xhold122 _0353_ VGND VGND VPWR VPWR net196 sky130_fd_sc_hd__dlygate4sd3_1
Xhold144 u_pe_array.act_from_right\[2\]\[2\] VGND VGND VPWR VPWR net218 sky130_fd_sc_hd__dlygate4sd3_1
Xhold133 _0450_ VGND VGND VPWR VPWR net207 sky130_fd_sc_hd__dlygate4sd3_1
Xhold111 u_pe_array.act_from_up\[6\]\[7\] VGND VGND VPWR VPWR net185 sky130_fd_sc_hd__buf_1
X_5496_ u_pe_array.u_fifo2.buffer\[0\]\[3\] _2324_ VGND VGND VPWR VPWR _2358_ sky130_fd_sc_hd__or2_1
X_4516_ net123 _1605_ _1305_ _1606_ VGND VGND VPWR VPWR _0212_ sky130_fd_sc_hd__a22o_1
X_7235_ clknet_leaf_22_clk _0141_ net942 VGND VGND VPWR VPWR u_pe_array.g_pe_row\[3\].g_pe_col\[1\].u_pe.psum_out\[3\]
+ sky130_fd_sc_hd__dfrtp_1
Xhold166 u_pe_array.act_from_right\[5\]\[12\] VGND VGND VPWR VPWR net240 sky130_fd_sc_hd__dlygate4sd3_1
Xhold177 u_pe_array.g_pe_row\[3\].g_pe_col\[0\].u_pe.move_reg\[11\] VGND VGND VPWR
+ VPWR net251 sky130_fd_sc_hd__dlygate4sd3_1
Xhold155 _0541_ VGND VGND VPWR VPWR net229 sky130_fd_sc_hd__dlygate4sd3_1
XFILLER_0_1_671 VGND VGND VPWR VPWR sky130_fd_sc_hd__fill_1
X_4447_ u_pe_array.g_pe_row\[3\].g_pe_col\[0\].u_pe.psum_out\[7\] _1287_ VGND VGND
+ VPWR VPWR _1551_ sky130_fd_sc_hd__nand2_1
XFILLER_0_111_484 VGND VGND VPWR VPWR sky130_fd_sc_hd__decap_3
Xhold199 u_pe_array.g_pe_row\[2\].g_pe_col\[1\].u_pe.move_reg\[12\] VGND VGND VPWR
+ VPWR net273 sky130_fd_sc_hd__dlygate4sd3_1
X_7166_ clknet_leaf_106_clk _0072_ net69 VGND VGND VPWR VPWR u_pe_array.act_from_left\[15\]\[1\]
+ sky130_fd_sc_hd__dfrtp_1
Xhold188 _0096_ VGND VGND VPWR VPWR net262 sky130_fd_sc_hd__dlygate4sd3_1
X_6117_ net324 _2499_ _2847_ _2852_ VGND VGND VPWR VPWR _0567_ sky130_fd_sc_hd__a22o_1
X_4378_ u_pe_array.g_pe_row\[3\].g_pe_col\[0\].u_pe.act_val\[1\] u_pe_array.g_pe_row\[3\].g_pe_col\[0\].u_pe.w_out\[0\]
+ VGND VGND VPWR VPWR _1488_ sky130_fd_sc_hd__nand2_1
XTAP_460 VGND VPWR sky130_fd_sc_hd__tapvpwrvgnd_1
XTAP_471 VGND VPWR sky130_fd_sc_hd__tapvpwrvgnd_1
XTAP_482 VGND VPWR sky130_fd_sc_hd__tapvpwrvgnd_1
XTAP_493 VGND VPWR sky130_fd_sc_hd__tapvpwrvgnd_1
X_7097_ clknet_leaf_89_clk _0003_ net949 VGND VGND VPWR VPWR u_fsm.cnt\[3\] sky130_fd_sc_hd__dfrtp_1
X_6048_ u_pe_array.g_pe_row\[1\].g_pe_col\[0\].u_pe.psum_out\[7\] _1865_ VGND VGND
+ VPWR VPWR _2798_ sky130_fd_sc_hd__nand2_1
XTAP_1615 VGND VPWR sky130_fd_sc_hd__tapvpwrvgnd_1
XTAP_1604 VGND VPWR sky130_fd_sc_hd__tapvpwrvgnd_1
XTAP_1648 VGND VPWR sky130_fd_sc_hd__tapvpwrvgnd_1
XTAP_1637 VGND VPWR sky130_fd_sc_hd__tapvpwrvgnd_1
XTAP_1626 VGND VPWR sky130_fd_sc_hd__tapvpwrvgnd_1
XTAP_1659 VGND VPWR sky130_fd_sc_hd__tapvpwrvgnd_1
XFILLER_0_63_121 VGND VGND VPWR VPWR sky130_fd_sc_hd__decap_3
XFILLER_0_36_313 VGND VGND VPWR VPWR sky130_fd_sc_hd__fill_1
XFILLER_0_32_585 VGND VGND VPWR VPWR sky130_fd_sc_hd__decap_3
XFILLER_0_74_408 VGND VGND VPWR VPWR sky130_fd_sc_hd__decap_8
XFILLER_0_27_335 VGND VGND VPWR VPWR sky130_fd_sc_hd__fill_1
XFILLER_0_6_229 VGND VGND VPWR VPWR sky130_fd_sc_hd__decap_3
XFILLER_0_15_519 VGND VGND VPWR VPWR sky130_fd_sc_hd__decap_6
X_3680_ net360 _0949_ _0944_ _0957_ VGND VGND VPWR VPWR _0025_ sky130_fd_sc_hd__a22o_1
XFILLER_0_40_67 VGND VGND VPWR VPWR sky130_fd_sc_hd__fill_1
X_5350_ _2237_ _2244_ _2245_ _2246_ VGND VGND VPWR VPWR _2247_ sky130_fd_sc_hd__a31o_1
XFILLER_0_2_457 VPWR VGND VPWR VGND sky130_ef_sc_hd__decap_12
X_5281_ u_pe_array.g_pe_row\[1\].g_pe_col\[3\].u_pe.act_val\[3\] _1423_ u_pe_array.g_pe_row\[1\].g_pe_col\[3\].u_pe.psum_out\[3\]
+ VGND VGND VPWR VPWR _2184_ sky130_fd_sc_hd__a21oi_1
X_4301_ _1445_ _1112_ VGND VGND VPWR VPWR _1446_ sky130_fd_sc_hd__nand2_1
XFILLER_0_49_54 VGND VGND VPWR VPWR sky130_fd_sc_hd__fill_2
X_4232_ _1350_ _1362_ _1363_ VGND VGND VPWR VPWR _1389_ sky130_fd_sc_hd__o21bai_1
X_7020_ net682 _3360_ _3499_ VGND VGND VPWR VPWR _3504_ sky130_fd_sc_hd__mux2_1
XFILLER_0_49_65 VGND VGND VPWR VPWR sky130_fd_sc_hd__fill_2
XFILLER_0_49_98 VGND VGND VPWR VPWR sky130_fd_sc_hd__fill_2
Xclkbuf_leaf_4_clk clknet_3_0__leaf_clk VGND VGND VPWR VPWR clknet_leaf_4_clk sky130_fd_sc_hd__clkbuf_16
X_4163_ _1316_ _1317_ VGND VGND VPWR VPWR _1326_ sky130_fd_sc_hd__and2_1
X_4094_ u_pe_array.g_pe_row\[2\].g_pe_col\[0\].u_pe.w_out\[1\] VGND VGND VPWR VPWR
+ _1286_ sky130_fd_sc_hd__buf_6
X_7922_ clknet_leaf_76_clk _0827_ VGND VGND VPWR VPWR u_pe_array.u_fifo1.buffer\[4\]\[0\]
+ sky130_fd_sc_hd__dfxtp_1
XFILLER_0_81_41 VPWR VGND VPWR VGND sky130_ef_sc_hd__decap_12
X_7853_ clknet_leaf_101_clk _0758_ VGND VGND VPWR VPWR u_pe_array.u_fifo2.buffer\[2\]\[5\]
+ sky130_fd_sc_hd__dfxtp_1
X_4996_ u_pe_array.g_pe_row\[2\].g_pe_col\[1\].u_pe.psum_out\[8\] u_pe_array.g_pe_row\[2\].g_pe_col\[1\].u_pe.psum_out\[9\]
+ _1105_ VGND VGND VPWR VPWR _1975_ sky130_fd_sc_hd__and3_1
XFILLER_0_92_205 VGND VGND VPWR VPWR sky130_fd_sc_hd__fill_1
X_7784_ clknet_leaf_62_clk _0690_ net74 VGND VGND VPWR VPWR u_pe_array.act_from_up\[4\]\[6\]
+ sky130_fd_sc_hd__dfrtp_1
X_6804_ net753 _3371_ _3373_ VGND VGND VPWR VPWR _0733_ sky130_fd_sc_hd__a21oi_1
XFILLER_0_18_302 VGND VGND VPWR VPWR sky130_fd_sc_hd__decap_3
XFILLER_0_105_81 VPWR VGND VPWR VGND sky130_ef_sc_hd__decap_12
X_6735_ u_pe_array.g_pe_row\[0\].g_pe_col\[0\].u_pe.psum_out\[8\] _3319_ _3307_ VGND
+ VGND VPWR VPWR _3320_ sky130_fd_sc_hd__mux2_1
XFILLER_0_92_249 VGND VGND VPWR VPWR sky130_fd_sc_hd__decap_3
XFILLER_0_73_430 VGND VGND VPWR VPWR sky130_fd_sc_hd__decap_4
X_3947_ _0983_ _1156_ _1166_ net127 VGND VGND VPWR VPWR _0083_ sky130_fd_sc_hd__a22o_1
XFILLER_0_46_633 VGND VGND VPWR VPWR sky130_fd_sc_hd__decap_8
X_6666_ u_pe_array.g_pe_row\[0\].g_pe_col\[0\].u_pe.psum_out\[2\] u_pe_array.g_pe_row\[0\].g_pe_col\[0\].u_pe.act_val\[2\]
+ _2486_ VGND VGND VPWR VPWR _3257_ sky130_fd_sc_hd__and3_1
X_3878_ _1121_ VGND VGND VPWR VPWR _0059_ sky130_fd_sc_hd__clkbuf_1
XFILLER_0_45_187 VGND VGND VPWR VPWR sky130_fd_sc_hd__fill_2
X_6597_ _3218_ _3219_ VGND VGND VPWR VPWR _3220_ sky130_fd_sc_hd__or2_1
XFILLER_0_5_262 VGND VGND VPWR VPWR sky130_fd_sc_hd__decap_3
X_5617_ _2451_ _2454_ _2459_ _0879_ VGND VGND VPWR VPWR _2461_ sky130_fd_sc_hd__a31o_1
XFILLER_0_103_237 VGND VGND VPWR VPWR sky130_fd_sc_hd__fill_2
X_5548_ u_pe_array.g_pe_row\[1\].g_pe_col\[2\].u_pe.act_val\[3\] _1595_ VGND VGND
+ VPWR VPWR _2397_ sky130_fd_sc_hd__nand2_1
XFILLER_0_14_596 VPWR VGND VPWR VGND sky130_ef_sc_hd__decap_12
XFILLER_0_41_393 VGND VGND VPWR VPWR sky130_fd_sc_hd__decap_8
X_7218_ clknet_leaf_13_clk _0124_ net942 VGND VGND VPWR VPWR u_pe_array.act_from_down\[9\]\[12\]
+ sky130_fd_sc_hd__dfrtp_1
X_5479_ _2320_ _2339_ _2342_ _2343_ net717 VGND VGND VPWR VPWR _0438_ sky130_fd_sc_hd__a32o_1
X_7149_ clknet_leaf_21_clk _0055_ net943 VGND VGND VPWR VPWR u_pe_array.g_pe_row\[3\].g_pe_col\[3\].u_pe.psum_out\[12\]
+ sky130_fd_sc_hd__dfrtp_1
XTAP_290 VGND VPWR sky130_fd_sc_hd__tapvpwrvgnd_1
XFILLER_0_96_533 VGND VGND VPWR VPWR sky130_fd_sc_hd__decap_6
XTAP_1412 VGND VPWR sky130_fd_sc_hd__tapvpwrvgnd_1
XTAP_1423 VGND VPWR sky130_fd_sc_hd__tapvpwrvgnd_1
XTAP_1401 VGND VPWR sky130_fd_sc_hd__tapvpwrvgnd_1
XTAP_1456 VGND VPWR sky130_fd_sc_hd__tapvpwrvgnd_1
XTAP_1445 VGND VPWR sky130_fd_sc_hd__tapvpwrvgnd_1
XTAP_1434 VGND VPWR sky130_fd_sc_hd__tapvpwrvgnd_1
XFILLER_0_56_419 VGND VGND VPWR VPWR sky130_fd_sc_hd__fill_1
XTAP_1489 VGND VPWR sky130_fd_sc_hd__tapvpwrvgnd_1
XTAP_1478 VGND VPWR sky130_fd_sc_hd__tapvpwrvgnd_1
XTAP_1467 VGND VPWR sky130_fd_sc_hd__tapvpwrvgnd_1
XFILLER_0_83_238 VGND VGND VPWR VPWR sky130_fd_sc_hd__fill_1
XFILLER_0_37_611 VGND VGND VPWR VPWR sky130_fd_sc_hd__decap_4
Xfanout72 net13 VGND VGND VPWR VPWR net72 sky130_fd_sc_hd__buf_12
XFILLER_0_37_655 VPWR VGND VPWR VGND sky130_ef_sc_hd__decap_12
XFILLER_0_37_688 VPWR VGND VPWR VGND sky130_ef_sc_hd__decap_12
XFILLER_0_101_39 VPWR VGND VPWR VGND sky130_ef_sc_hd__decap_12
XFILLER_0_10_15 VPWR VGND VPWR VGND sky130_ef_sc_hd__decap_12
XFILLER_0_51_124 VPWR VGND VPWR VGND sky130_ef_sc_hd__decap_12
XFILLER_0_60_691 VGND VGND VPWR VPWR sky130_fd_sc_hd__decap_8
XFILLER_0_20_533 VGND VGND VPWR VPWR sky130_fd_sc_hd__decap_6
XFILLER_0_32_382 VGND VGND VPWR VPWR sky130_fd_sc_hd__fill_1
XFILLER_0_87_522 VGND VGND VPWR VPWR sky130_fd_sc_hd__decap_8
Xclkbuf_3_7__f_clk clknet_0_clk VGND VGND VPWR VPWR clknet_3_7__leaf_clk sky130_fd_sc_hd__clkbuf_16
XFILLER_0_59_246 VGND VGND VPWR VPWR sky130_fd_sc_hd__decap_8
X_4850_ u_pe_array.g_pe_row\[1\].g_pe_col\[0\].u_pe.w_out\[1\] VGND VGND VPWR VPWR
+ _1865_ sky130_fd_sc_hd__buf_6
X_3801_ _1049_ _1054_ VGND VGND VPWR VPWR _1055_ sky130_fd_sc_hd__or2_1
XFILLER_0_74_227 VGND VGND VPWR VPWR sky130_fd_sc_hd__fill_1
X_6520_ u_pe_array.g_pe_row\[0\].g_pe_col\[1\].u_pe.act_val\[4\] u_pe_array.g_pe_row\[0\].g_pe_col\[1\].u_pe.w_out\[0\]
+ VGND VGND VPWR VPWR _3150_ sky130_fd_sc_hd__nand2_1
XFILLER_0_7_549 VGND VGND VPWR VPWR sky130_fd_sc_hd__decap_8
X_4781_ u_pe_array.g_pe_row\[2\].g_pe_col\[2\].u_pe.act_val\[5\] VGND VGND VPWR VPWR
+ _1804_ sky130_fd_sc_hd__inv_2
X_3732_ _0981_ _0990_ VGND VGND VPWR VPWR _0991_ sky130_fd_sc_hd__xnor2_1
XFILLER_0_15_316 VGND VGND VPWR VPWR sky130_fd_sc_hd__decap_3
XFILLER_0_27_154 VPWR VGND VPWR VGND sky130_ef_sc_hd__decap_12
XFILLER_0_43_625 VGND VGND VPWR VPWR sky130_fd_sc_hd__decap_3
X_6451_ u_pe_array.g_pe_row\[0\].g_pe_col\[1\].u_pe.psum_out\[4\] u_pe_array.g_pe_row\[0\].g_pe_col\[1\].u_pe.act_val\[4\]
+ _3102_ VGND VGND VPWR VPWR _3107_ sky130_fd_sc_hd__mux2_1
XFILLER_0_113_502 VGND VGND VPWR VPWR sky130_fd_sc_hd__fill_2
X_3663_ net189 _0940_ _0944_ _0948_ VGND VGND VPWR VPWR _0017_ sky130_fd_sc_hd__a22o_1
XFILLER_0_113_557 VGND VGND VPWR VPWR sky130_fd_sc_hd__decap_3
XFILLER_0_2_221 VPWR VGND VPWR VGND sky130_ef_sc_hd__decap_12
X_5402_ _2288_ VGND VGND VPWR VPWR _0416_ sky130_fd_sc_hd__clkbuf_1
X_6382_ _3038_ VGND VGND VPWR VPWR _3051_ sky130_fd_sc_hd__inv_2
X_5333_ _2225_ _2230_ VGND VGND VPWR VPWR _2232_ sky130_fd_sc_hd__nand2_1
XFILLER_0_11_522 VGND VGND VPWR VPWR sky130_fd_sc_hd__decap_4
X_3594_ _0893_ VGND VGND VPWR VPWR _0894_ sky130_fd_sc_hd__buf_2
XFILLER_0_2_298 VGND VGND VPWR VPWR sky130_fd_sc_hd__fill_1
XFILLER_0_76_41 VGND VGND VPWR VPWR sky130_fd_sc_hd__fill_1
X_5264_ u_pe_array.g_pe_row\[1\].g_pe_col\[3\].u_pe.act_val\[0\] _2164_ _2168_ VGND
+ VGND VPWR VPWR _2169_ sky130_fd_sc_hd__or3b_1
X_4215_ _1372_ _1373_ VGND VGND VPWR VPWR _1374_ sky130_fd_sc_hd__or2b_1
X_7003_ _3494_ VGND VGND VPWR VPWR _0811_ sky130_fd_sc_hd__clkbuf_1
X_5195_ _2128_ _1595_ _0931_ VGND VGND VPWR VPWR _2129_ sky130_fd_sc_hd__mux2_1
X_4146_ u_pe_array.g_pe_row\[3\].g_pe_col\[1\].u_pe.act_val\[0\] u_pe_array.g_pe_row\[3\].g_pe_col\[1\].u_pe.w_out\[0\]
+ u_pe_array.g_pe_row\[3\].g_pe_col\[1\].u_pe.psum_out\[0\] VGND VGND VPWR VPWR _1311_
+ sky130_fd_sc_hd__a21o_1
XFILLER_0_97_308 VGND VGND VPWR VPWR sky130_fd_sc_hd__decap_8
X_4077_ _1033_ _1271_ _1272_ _0986_ net804 VGND VGND VPWR VPWR _0107_ sky130_fd_sc_hd__a32o_1
XFILLER_0_78_533 VGND VGND VPWR VPWR sky130_fd_sc_hd__fill_1
X_7905_ clknet_leaf_82_clk _0810_ VGND VGND VPWR VPWR u_pe_array.u_fifo1.buffer\[1\]\[1\]
+ sky130_fd_sc_hd__dfxtp_1
X_7836_ clknet_leaf_87_clk _0741_ VGND VGND VPWR VPWR u_pe_array.u_fifo2.buffer\[0\]\[0\]
+ sky130_fd_sc_hd__dfxtp_1
XFILLER_0_38_419 VGND VGND VPWR VPWR sky130_fd_sc_hd__fill_1
XFILLER_0_108_307 VGND VGND VPWR VPWR sky130_fd_sc_hd__fill_1
X_7767_ clknet_leaf_49_clk _0673_ net73 VGND VGND VPWR VPWR u_pe_array.g_pe_row\[0\].g_pe_col\[1\].u_pe.psum_out\[4\]
+ sky130_fd_sc_hd__dfrtp_1
X_4979_ _1884_ _1958_ _1959_ _1803_ net936 VGND VGND VPWR VPWR _0322_ sky130_fd_sc_hd__a32o_1
XFILLER_0_93_558 VGND VGND VPWR VPWR sky130_fd_sc_hd__fill_2
X_6718_ _3301_ _3303_ VGND VGND VPWR VPWR _3305_ sky130_fd_sc_hd__nand2_1
X_7698_ clknet_leaf_75_clk _0604_ net949 VGND VGND VPWR VPWR u_pe_array.act_from_up\[6\]\[2\]
+ sky130_fd_sc_hd__dfrtp_1
X_6649_ u_pe_array.act_from_right\[0\]\[12\] _0866_ _0940_ net222 VGND VGND VPWR VPWR
+ _0709_ sky130_fd_sc_hd__a22o_1
XFILLER_0_33_113 VPWR VGND VPWR VGND sky130_ef_sc_hd__decap_12
XFILLER_0_21_319 VPWR VGND VPWR VGND sky130_ef_sc_hd__decap_12
XFILLER_0_104_557 VGND VGND VPWR VPWR sky130_fd_sc_hd__decap_8
XTAP_1231 VGND VPWR sky130_fd_sc_hd__tapvpwrvgnd_1
XTAP_1220 VGND VPWR sky130_fd_sc_hd__tapvpwrvgnd_1
XTAP_1275 VGND VPWR sky130_fd_sc_hd__tapvpwrvgnd_1
XTAP_1264 VGND VPWR sky130_fd_sc_hd__tapvpwrvgnd_1
XTAP_1242 VGND VPWR sky130_fd_sc_hd__tapvpwrvgnd_1
XTAP_1253 VGND VPWR sky130_fd_sc_hd__tapvpwrvgnd_1
XTAP_1297 VGND VPWR sky130_fd_sc_hd__tapvpwrvgnd_1
XTAP_1286 VGND VPWR sky130_fd_sc_hd__tapvpwrvgnd_1
XFILLER_0_25_625 VGND VGND VPWR VPWR sky130_fd_sc_hd__fill_1
XFILLER_0_21_69 VGND VGND VPWR VPWR sky130_fd_sc_hd__decap_3
XFILLER_0_24_168 VGND VGND VPWR VPWR sky130_fd_sc_hd__decap_3
XFILLER_0_24_179 VGND VGND VPWR VPWR sky130_fd_sc_hd__fill_2
XFILLER_0_40_606 VGND VGND VPWR VPWR sky130_fd_sc_hd__fill_2
XFILLER_0_52_466 VGND VGND VPWR VPWR sky130_fd_sc_hd__decap_8
XFILLER_0_52_477 VGND VGND VPWR VPWR sky130_fd_sc_hd__fill_1
XFILLER_0_110_516 VGND VGND VPWR VPWR sky130_fd_sc_hd__decap_8
X_4000_ _1189_ _1190_ _1202_ VGND VGND VPWR VPWR _1203_ sky130_fd_sc_hd__o21a_1
XFILLER_0_46_33 VGND VGND VPWR VPWR sky130_fd_sc_hd__fill_1
XFILLER_0_27_9 VGND VGND VPWR VPWR sky130_fd_sc_hd__fill_1
X_5951_ u_pe_array.u_fifo1.buffer\[7\]\[4\] _2681_ _2683_ u_pe_array.u_fifo1.buffer\[1\]\[4\]
+ VGND VGND VPWR VPWR _2717_ sky130_fd_sc_hd__a22o_1
X_4902_ u_pe_array.g_pe_row\[2\].g_pe_col\[1\].u_pe.act_val\[0\] _1105_ VGND VGND
+ VPWR VPWR _1889_ sky130_fd_sc_hd__nand2_1
XFILLER_0_75_503 VGND VGND VPWR VPWR sky130_fd_sc_hd__fill_1
XFILLER_0_1_57 VPWR VGND VPWR VGND sky130_ef_sc_hd__decap_12
XFILLER_0_118_605 VGND VGND VPWR VPWR sky130_fd_sc_hd__fill_1
X_5882_ u_pe_array.g_pe_row\[1\].g_pe_col\[0\].u_pe.move_reg\[12\] net62 VGND VGND
+ VPWR VPWR _2666_ sky130_fd_sc_hd__or2_1
X_7621_ clknet_leaf_66_clk _0527_ net946 VGND VGND VPWR VPWR u_pe_array.act_from_left\[5\]\[7\]
+ sky130_fd_sc_hd__dfrtp_1
X_4833_ _1846_ _1851_ VGND VGND VPWR VPWR _1852_ sky130_fd_sc_hd__and2_1
XFILLER_0_83_580 VGND VGND VPWR VPWR sky130_fd_sc_hd__fill_2
XFILLER_0_7_357 VGND VGND VPWR VPWR sky130_fd_sc_hd__fill_1
X_4764_ _1787_ _1788_ VGND VGND VPWR VPWR _1789_ sky130_fd_sc_hd__nor2_1
XFILLER_0_28_474 VGND VGND VPWR VPWR sky130_fd_sc_hd__fill_2
X_7552_ clknet_leaf_93_clk _0458_ net949 VGND VGND VPWR VPWR u_pe_array.g_pe_row\[1\].g_pe_col\[2\].u_pe.psum_out\[7\]
+ sky130_fd_sc_hd__dfrtp_4
X_6503_ _3133_ _3134_ net793 _1007_ VGND VGND VPWR VPWR _0671_ sky130_fd_sc_hd__a2bb2o_1
X_7483_ clknet_leaf_38_clk _0389_ net951 VGND VGND VPWR VPWR u_pe_array.g_pe_row\[1\].g_pe_col\[3\].u_pe.act_val\[5\]
+ sky130_fd_sc_hd__dfrtp_1
X_3715_ net410 _0939_ VGND VGND VPWR VPWR _0976_ sky130_fd_sc_hd__and2_1
XFILLER_0_43_422 VGND VGND VPWR VPWR sky130_fd_sc_hd__fill_2
XFILLER_0_43_444 VGND VGND VPWR VPWR sky130_fd_sc_hd__fill_1
X_6434_ u_pe_array.g_pe_row\[0\].g_pe_col\[2\].u_pe.psum_out\[12\] _3090_ VGND VGND
+ VPWR VPWR _3097_ sky130_fd_sc_hd__xnor2_1
XFILLER_0_15_146 VGND VGND VPWR VPWR sky130_fd_sc_hd__fill_1
XFILLER_0_31_617 VGND VGND VPWR VPWR sky130_fd_sc_hd__decap_6
X_4695_ u_pe_array.g_pe_row\[2\].g_pe_col\[2\].u_pe.psum_out\[7\] net375 _1599_ VGND
+ VGND VPWR VPWR _1743_ sky130_fd_sc_hd__mux2_1
XFILLER_0_113_343 VPWR VGND VPWR VGND sky130_ef_sc_hd__decap_12
XFILLER_0_3_541 VPWR VGND VPWR VGND sky130_ef_sc_hd__decap_12
X_3646_ u_pe_array.g_pe_row\[2\].g_pe_col\[2\].u_pe.w_out\[1\] VGND VGND VPWR VPWR
+ _0933_ sky130_fd_sc_hd__buf_6
XFILLER_0_60_3 VGND VGND VPWR VPWR sky130_fd_sc_hd__fill_1
XFILLER_0_3_585 VPWR VGND VPWR VGND sky130_ef_sc_hd__decap_12
X_3577_ _0883_ VGND VGND VPWR VPWR u_fsm.next_state\[2\] sky130_fd_sc_hd__clkbuf_1
XFILLER_0_30_138 VGND VGND VPWR VPWR sky130_fd_sc_hd__fill_2
X_6365_ u_pe_array.g_pe_row\[0\].g_pe_col\[2\].u_pe.act_val\[4\] _2130_ VGND VGND
+ VPWR VPWR _3035_ sky130_fd_sc_hd__and2b_1
XFILLER_0_87_73 VGND VGND VPWR VPWR sky130_fd_sc_hd__fill_1
X_5316_ u_pe_array.g_pe_row\[1\].g_pe_col\[3\].u_pe.act_val\[5\] u_pe_array.g_pe_row\[1\].g_pe_col\[3\].u_pe.psum_out\[6\]
+ _1426_ VGND VGND VPWR VPWR _2216_ sky130_fd_sc_hd__and3b_1
X_6296_ net108 _1731_ _2009_ _2985_ VGND VGND VPWR VPWR _0613_ sky130_fd_sc_hd__a22o_1
X_5247_ net539 _0939_ VGND VGND VPWR VPWR _2157_ sky130_fd_sc_hd__and2_1
Xhold37 _0137_ VGND VGND VPWR VPWR net111 sky130_fd_sc_hd__dlygate4sd3_1
Xhold26 u_pe_array.act_from_up\[14\]\[7\] VGND VGND VPWR VPWR net100 sky130_fd_sc_hd__dlygate4sd3_1
Xhold15 u_pe_array.act_from_up\[14\]\[11\] VGND VGND VPWR VPWR net89 sky130_fd_sc_hd__dlygate4sd3_1
X_5178_ u_pe_array.g_pe_row\[2\].g_pe_col\[0\].u_pe.psum_out\[10\] _2114_ _2104_ VGND
+ VGND VPWR VPWR _2115_ sky130_fd_sc_hd__mux2_1
Xhold59 _0584_ VGND VGND VPWR VPWR net133 sky130_fd_sc_hd__dlygate4sd3_1
Xhold48 _0132_ VGND VGND VPWR VPWR net122 sky130_fd_sc_hd__dlygate4sd3_1
X_4129_ _0943_ VGND VGND VPWR VPWR _1305_ sky130_fd_sc_hd__buf_6
XFILLER_0_66_569 VGND VGND VPWR VPWR sky130_fd_sc_hd__fill_2
X_7819_ clknet_leaf_82_clk _0724_ VGND VGND VPWR VPWR u_pe_array.u_fifo1.buffer\[8\]\[1\]
+ sky130_fd_sc_hd__dfxtp_1
XFILLER_0_109_649 VPWR VGND VPWR VGND sky130_ef_sc_hd__decap_12
XFILLER_0_34_433 VGND VGND VPWR VPWR sky130_fd_sc_hd__fill_2
XFILLER_0_22_617 VGND VGND VPWR VPWR sky130_fd_sc_hd__decap_4
XFILLER_0_34_477 VGND VGND VPWR VPWR sky130_fd_sc_hd__fill_1
XFILLER_0_104_354 VGND VGND VPWR VPWR sky130_fd_sc_hd__decap_8
XFILLER_0_61_274 VGND VGND VPWR VPWR sky130_fd_sc_hd__decap_6
XFILLER_0_21_105 VGND VGND VPWR VPWR sky130_fd_sc_hd__fill_1
XFILLER_0_104_365 VPWR VGND VPWR VGND sky130_ef_sc_hd__decap_12
XFILLER_0_107_27 VPWR VGND VPWR VGND sky130_ef_sc_hd__decap_12
XFILLER_0_89_617 VGND VGND VPWR VPWR sky130_fd_sc_hd__fill_2
XFILLER_0_97_661 VGND VGND VPWR VPWR sky130_fd_sc_hd__decap_8
XTAP_1083 VGND VPWR sky130_fd_sc_hd__tapvpwrvgnd_1
XTAP_1072 VGND VPWR sky130_fd_sc_hd__tapvpwrvgnd_1
XTAP_1061 VGND VPWR sky130_fd_sc_hd__tapvpwrvgnd_1
XTAP_1050 VGND VPWR sky130_fd_sc_hd__tapvpwrvgnd_1
XTAP_1094 VGND VPWR sky130_fd_sc_hd__tapvpwrvgnd_1
XFILLER_0_108_693 VGND VGND VPWR VPWR sky130_fd_sc_hd__decap_6
XFILLER_0_80_561 VGND VGND VPWR VPWR sky130_fd_sc_hd__fill_1
Xhold507 u_pe_array.g_pe_row\[1\].g_pe_col\[3\].u_pe.psum_out\[3\] VGND VGND VPWR
+ VPWR net581 sky130_fd_sc_hd__dlygate4sd3_1
Xhold518 u_pe_array.u_fifo1.buffer\[4\]\[2\] VGND VGND VPWR VPWR net592 sky130_fd_sc_hd__dlygate4sd3_1
X_4480_ u_pe_array.g_pe_row\[3\].g_pe_col\[0\].u_pe.psum_out\[10\] _1570_ VGND VGND
+ VPWR VPWR _1581_ sky130_fd_sc_hd__nor2_1
Xhold529 u_pe_array.g_pe_row\[1\].g_pe_col\[1\].u_pe.psum_out\[2\] VGND VGND VPWR
+ VPWR net603 sky130_fd_sc_hd__dlygate4sd3_1
X_6150_ _2863_ _2864_ VGND VGND VPWR VPWR _2865_ sky130_fd_sc_hd__xor2_1
XFILLER_0_0_533 VPWR VGND VPWR VGND sky130_ef_sc_hd__decap_12
XFILLER_0_0_555 VGND VGND VPWR VPWR sky130_fd_sc_hd__decap_4
XTAP_801 VGND VPWR sky130_fd_sc_hd__tapvpwrvgnd_1
X_5101_ _2028_ _2030_ VGND VGND VPWR VPWR _2045_ sky130_fd_sc_hd__nand2_1
XTAP_812 VGND VPWR sky130_fd_sc_hd__tapvpwrvgnd_1
XTAP_823 VGND VPWR sky130_fd_sc_hd__tapvpwrvgnd_1
XTAP_834 VGND VPWR sky130_fd_sc_hd__tapvpwrvgnd_1
X_6081_ u_pe_array.g_pe_row\[1\].g_pe_col\[0\].u_pe.psum_out\[10\] _2817_ VGND VGND
+ VPWR VPWR _2828_ sky130_fd_sc_hd__nor2_1
XTAP_845 VGND VPWR sky130_fd_sc_hd__tapvpwrvgnd_1
XTAP_856 VGND VPWR sky130_fd_sc_hd__tapvpwrvgnd_1
XTAP_867 VGND VPWR sky130_fd_sc_hd__tapvpwrvgnd_1
X_5032_ u_pe_array.g_pe_row\[2\].g_pe_col\[0\].u_pe.psum_out\[2\] u_pe_array.g_pe_row\[2\].g_pe_col\[0\].u_pe.act_val\[2\]
+ _1867_ VGND VGND VPWR VPWR _2003_ sky130_fd_sc_hd__mux2_2
XTAP_878 VGND VPWR sky130_fd_sc_hd__tapvpwrvgnd_1
XTAP_889 VGND VPWR sky130_fd_sc_hd__tapvpwrvgnd_1
XFILLER_0_73_42 VGND VGND VPWR VPWR sky130_fd_sc_hd__decap_3
XFILLER_0_73_75 VGND VGND VPWR VPWR sky130_fd_sc_hd__decap_6
X_6983_ u_pe_array.u_fifo1.wr_ptr\[2\] u_pe_array.u_fifo1.wr_ptr\[3\] net948 _3349_
+ VGND VGND VPWR VPWR _3483_ sky130_fd_sc_hd__and4bb_1
X_5934_ u_pe_array.u_fifo1.buffer\[0\]\[2\] _2678_ VGND VGND VPWR VPWR _2702_ sky130_fd_sc_hd__or2_1
X_5865_ _2653_ VGND VGND VPWR VPWR _0514_ sky130_fd_sc_hd__clkbuf_1
X_7604_ clknet_leaf_37_clk _0510_ net951 VGND VGND VPWR VPWR net42 sky130_fd_sc_hd__dfrtp_2
X_4816_ _1828_ _1830_ _1835_ VGND VGND VPWR VPWR _1837_ sky130_fd_sc_hd__o21a_1
XFILLER_0_113_81 VPWR VGND VPWR VGND sky130_ef_sc_hd__decap_12
X_5796_ _1003_ _2598_ VGND VGND VPWR VPWR _2599_ sky130_fd_sc_hd__nor2_1
XFILLER_0_63_539 VGND VGND VPWR VPWR sky130_fd_sc_hd__fill_2
XFILLER_0_8_688 VPWR VGND VPWR VGND sky130_ef_sc_hd__decap_12
XFILLER_0_16_433 VPWR VGND VPWR VGND sky130_ef_sc_hd__decap_12
XFILLER_0_71_561 VGND VGND VPWR VPWR sky130_fd_sc_hd__decap_4
X_4747_ u_pe_array.g_pe_row\[2\].g_pe_col\[2\].u_pe.act_val\[3\] u_pe_array.g_pe_row\[2\].g_pe_col\[2\].u_pe.w_out\[0\]
+ _0933_ _1772_ VGND VGND VPWR VPWR _1773_ sky130_fd_sc_hd__a22o_1
X_7535_ clknet_leaf_91_clk _0441_ net948 VGND VGND VPWR VPWR u_pe_array.g_pe_row\[1\].g_pe_col\[2\].u_pe.act_val\[3\]
+ sky130_fd_sc_hd__dfrtp_1
XFILLER_0_43_241 VGND VGND VPWR VPWR sky130_fd_sc_hd__fill_1
XFILLER_0_114_641 VGND VGND VPWR VPWR sky130_fd_sc_hd__decap_3
X_7466_ clknet_leaf_65_clk _0372_ net946 VGND VGND VPWR VPWR u_pe_array.act_from_down\[3\]\[1\]
+ sky130_fd_sc_hd__dfrtp_1
X_4678_ _0857_ _0936_ _1109_ VGND VGND VPWR VPWR _1733_ sky130_fd_sc_hd__and3_1
XFILLER_0_98_83 VGND VGND VPWR VPWR sky130_fd_sc_hd__fill_1
X_7397_ clknet_leaf_22_clk net356 net943 VGND VGND VPWR VPWR u_pe_array.g_pe_row\[2\].g_pe_col\[1\].u_pe.act_val\[1\]
+ sky130_fd_sc_hd__dfrtp_1
X_3629_ _0921_ VGND VGND VPWR VPWR _0010_ sky130_fd_sc_hd__clkbuf_1
XFILLER_0_31_447 VGND VGND VPWR VPWR sky130_fd_sc_hd__fill_1
X_6417_ _3075_ _3076_ _3081_ _3078_ _3073_ VGND VGND VPWR VPWR _3082_ sky130_fd_sc_hd__a32o_1
XFILLER_0_101_335 VGND VGND VPWR VPWR sky130_fd_sc_hd__fill_1
Xoutput49 net49 VGND VGND VPWR VPWR psum_out1[0] sky130_fd_sc_hd__clkbuf_4
Xoutput38 net38 VGND VGND VPWR VPWR psum_out0[11] sky130_fd_sc_hd__buf_2
XFILLER_0_3_393 VPWR VGND VPWR VGND sky130_ef_sc_hd__decap_12
X_6348_ _2795_ _3018_ _3019_ _2621_ net546 VGND VGND VPWR VPWR _0631_ sky130_fd_sc_hd__a32o_1
X_6279_ u_pe_array.g_pe_row\[0\].g_pe_col\[2\].u_pe.psum_out\[3\] u_pe_array.g_pe_row\[0\].g_pe_col\[2\].u_pe.act_val\[3\]
+ _2844_ VGND VGND VPWR VPWR _2977_ sky130_fd_sc_hd__mux2_1
XFILLER_0_98_414 VGND VGND VPWR VPWR sky130_fd_sc_hd__decap_6
XPHY_100 VGND VGND VPWR VPWR sky130_fd_sc_hd__decap_3
XPHY_133 VGND VGND VPWR VPWR sky130_fd_sc_hd__decap_3
XPHY_122 VGND VGND VPWR VPWR sky130_fd_sc_hd__decap_3
XPHY_111 VGND VGND VPWR VPWR sky130_fd_sc_hd__decap_3
XFILLER_0_109_435 VPWR VGND VPWR VGND sky130_ef_sc_hd__decap_12
XPHY_166 VGND VGND VPWR VPWR sky130_fd_sc_hd__decap_3
XPHY_155 VGND VGND VPWR VPWR sky130_fd_sc_hd__decap_3
XPHY_144 VGND VGND VPWR VPWR sky130_fd_sc_hd__decap_3
XFILLER_0_54_528 VGND VGND VPWR VPWR sky130_fd_sc_hd__decap_4
XPHY_199 VGND VGND VPWR VPWR sky130_fd_sc_hd__decap_3
XPHY_188 VGND VGND VPWR VPWR sky130_fd_sc_hd__decap_3
XPHY_177 VGND VGND VPWR VPWR sky130_fd_sc_hd__decap_3
XFILLER_0_54_539 VGND VGND VPWR VPWR sky130_fd_sc_hd__decap_8
XFILLER_0_50_701 VGND VGND VPWR VPWR sky130_fd_sc_hd__decap_4
XFILLER_0_105_641 VPWR VGND VPWR VGND sky130_ef_sc_hd__decap_12
XFILLER_0_105_685 VPWR VGND VPWR VGND sky130_ef_sc_hd__decap_12
XFILLER_0_69_160 VGND VGND VPWR VPWR sky130_fd_sc_hd__decap_8
X_3980_ u_pe_array.g_pe_row\[3\].g_pe_col\[2\].u_pe.act_val\[2\] u_pe_array.g_pe_row\[3\].g_pe_col\[2\].u_pe.w_out\[0\]
+ VGND VGND VPWR VPWR _1184_ sky130_fd_sc_hd__nand2_1
XPHY_2 VGND VGND VPWR VPWR sky130_fd_sc_hd__decap_3
XFILLER_0_43_45 VGND VGND VPWR VPWR sky130_fd_sc_hd__fill_1
XFILLER_0_57_333 VGND VGND VPWR VPWR sky130_fd_sc_hd__decap_3
XFILLER_0_43_78 VPWR VGND VPWR VGND sky130_ef_sc_hd__decap_12
X_5650_ u_pe_array.g_pe_row\[0\].g_pe_col\[0\].u_pe.w_out\[1\] VGND VGND VPWR VPWR
+ _2488_ sky130_fd_sc_hd__clkbuf_8
Xclkbuf_0_clk clk VGND VGND VPWR VPWR clknet_0_clk sky130_fd_sc_hd__clkbuf_16
XFILLER_0_72_325 VGND VGND VPWR VPWR sky130_fd_sc_hd__decap_3
XFILLER_0_5_603 VPWR VGND VPWR VGND sky130_ef_sc_hd__decap_12
X_4601_ _1650_ _1660_ _1664_ VGND VGND VPWR VPWR _1666_ sky130_fd_sc_hd__nor3_1
X_5581_ _2426_ _2427_ VGND VGND VPWR VPWR _2428_ sky130_fd_sc_hd__nor2_1
X_7320_ clknet_leaf_4_clk net286 net945 VGND VGND VPWR VPWR u_pe_array.g_pe_row\[2\].g_pe_col\[3\].u_pe.move_reg\[6\]
+ sky130_fd_sc_hd__dfrtp_1
X_4532_ u_pe_array.g_pe_row\[2\].g_pe_col\[3\].u_pe.act_val\[0\] _1605_ _1611_ net189
+ VGND VGND VPWR VPWR _0220_ sky130_fd_sc_hd__a22o_1
X_7251_ clknet_3_2__leaf_clk _0157_ net70 VGND VGND VPWR VPWR net56 sky130_fd_sc_hd__dfrtp_1
Xhold326 u_pe_array.act_from_down\[1\]\[10\] VGND VGND VPWR VPWR net400 sky130_fd_sc_hd__dlygate4sd3_1
Xhold304 u_pe_array.act_from_down\[9\]\[2\] VGND VGND VPWR VPWR net378 sky130_fd_sc_hd__dlygate4sd3_1
Xhold315 u_pe_array.g_pe_row\[3\].g_pe_col\[3\].u_pe.act_val\[1\] VGND VGND VPWR VPWR
+ net389 sky130_fd_sc_hd__dlygate4sd3_1
X_4463_ _1551_ _1564_ _1565_ VGND VGND VPWR VPWR _1566_ sky130_fd_sc_hd__a21oi_1
X_6202_ u_pe_array.g_pe_row\[0\].g_pe_col\[3\].u_pe.act_val\[5\] VGND VGND VPWR VPWR
+ _2912_ sky130_fd_sc_hd__inv_2
Xhold337 u_pe_array.g_pe_row\[3\].g_pe_col\[3\].u_pe.move_reg\[10\] VGND VGND VPWR
+ VPWR net411 sky130_fd_sc_hd__dlygate4sd3_1
Xhold348 u_fsm.ch_cnt\[1\] VGND VGND VPWR VPWR net422 sky130_fd_sc_hd__dlygate4sd3_1
Xhold359 _0270_ VGND VGND VPWR VPWR net433 sky130_fd_sc_hd__dlygate4sd3_1
X_4394_ _1495_ _1501_ _1003_ VGND VGND VPWR VPWR _1503_ sky130_fd_sc_hd__a21o_1
X_7182_ clknet_leaf_102_clk _0088_ net944 VGND VGND VPWR VPWR u_pe_array.g_pe_row\[3\].g_pe_col\[2\].u_pe.act_val\[4\]
+ sky130_fd_sc_hd__dfrtp_2
XFILLER_0_0_363 VGND VGND VPWR VPWR sky130_fd_sc_hd__fill_1
XFILLER_0_110_187 VGND VGND VPWR VPWR sky130_fd_sc_hd__decap_8
X_6133_ u_pe_array.g_pe_row\[0\].g_pe_col\[3\].u_pe.act_val\[2\] _2853_ _2847_ net419
+ VGND VGND VPWR VPWR _0576_ sky130_fd_sc_hd__a22o_1
XTAP_620 VGND VPWR sky130_fd_sc_hd__tapvpwrvgnd_1
XTAP_631 VGND VPWR sky130_fd_sc_hd__tapvpwrvgnd_1
XTAP_642 VGND VPWR sky130_fd_sc_hd__tapvpwrvgnd_1
XFILLER_0_84_41 VGND VGND VPWR VPWR sky130_fd_sc_hd__decap_6
XTAP_653 VGND VPWR sky130_fd_sc_hd__tapvpwrvgnd_1
XTAP_675 VGND VPWR sky130_fd_sc_hd__tapvpwrvgnd_1
XTAP_664 VGND VPWR sky130_fd_sc_hd__tapvpwrvgnd_1
XTAP_686 VGND VPWR sky130_fd_sc_hd__tapvpwrvgnd_1
X_6064_ _2798_ _2811_ _2812_ VGND VGND VPWR VPWR _2813_ sky130_fd_sc_hd__a21oi_1
X_5015_ _1984_ _1986_ _1991_ VGND VGND VPWR VPWR _1992_ sky130_fd_sc_hd__o21ai_1
XFILLER_0_84_63 VGND VGND VPWR VPWR sky130_fd_sc_hd__fill_1
XTAP_697 VGND VPWR sky130_fd_sc_hd__tapvpwrvgnd_1
XFILLER_0_84_85 VGND VGND VPWR VPWR sky130_fd_sc_hd__decap_3
XFILLER_0_23_3 VGND VGND VPWR VPWR sky130_fd_sc_hd__decap_3
XFILLER_0_17_90 VPWR VGND VPWR VGND sky130_ef_sc_hd__decap_12
X_6966_ net736 _3468_ _3470_ VGND VGND VPWR VPWR _0798_ sky130_fd_sc_hd__a21oi_1
XFILLER_0_76_642 VGND VGND VPWR VPWR sky130_fd_sc_hd__fill_2
X_5917_ u_pe_array.u_fifo1.rd_ptr\[1\] u_pe_array.u_fifo1.rd_ptr\[3\] u_pe_array.u_fifo1.rd_ptr\[2\]
+ u_pe_array.u_fifo1.rd_ptr\[0\] VGND VGND VPWR VPWR _2687_ sky130_fd_sc_hd__and4bb_2
XFILLER_0_118_221 VGND VGND VPWR VPWR sky130_fd_sc_hd__decap_3
X_6897_ _3429_ VGND VGND VPWR VPWR _0770_ sky130_fd_sc_hd__clkbuf_1
XFILLER_0_118_265 VPWR VGND VPWR VGND sky130_ef_sc_hd__decap_12
X_5848_ _2640_ VGND VGND VPWR VPWR _0510_ sky130_fd_sc_hd__clkbuf_1
XFILLER_0_75_196 VPWR VGND VPWR VGND sky130_ef_sc_hd__decap_12
XFILLER_0_63_325 VGND VGND VPWR VPWR sky130_fd_sc_hd__fill_2
X_5779_ _2582_ u_pe_array.g_pe_row\[1\].g_pe_col\[1\].u_pe.psum_out\[7\] _2565_ VGND
+ VGND VPWR VPWR _2583_ sky130_fd_sc_hd__mux2_1
XFILLER_0_32_701 VGND VGND VPWR VPWR sky130_fd_sc_hd__decap_4
XFILLER_0_44_550 VPWR VGND VPWR VGND sky130_ef_sc_hd__decap_12
X_7518_ clknet_leaf_67_clk _0424_ net946 VGND VGND VPWR VPWR u_pe_array.act_from_right\[5\]\[12\]
+ sky130_fd_sc_hd__dfrtp_1
XFILLER_0_16_263 VGND VGND VPWR VPWR sky130_fd_sc_hd__decap_8
XFILLER_0_71_391 VGND VGND VPWR VPWR sky130_fd_sc_hd__fill_1
XFILLER_0_114_493 VGND VGND VPWR VPWR sky130_fd_sc_hd__fill_1
XFILLER_0_101_121 VGND VGND VPWR VPWR sky130_fd_sc_hd__decap_8
X_7449_ clknet_leaf_36_clk net264 net951 VGND VGND VPWR VPWR u_pe_array.g_pe_row\[2\].g_pe_col\[0\].u_pe.move_reg\[12\]
+ sky130_fd_sc_hd__dfrtp_1
XFILLER_0_31_277 VGND VGND VPWR VPWR sky130_fd_sc_hd__decap_3
XFILLER_0_101_165 VGND VGND VPWR VPWR sky130_fd_sc_hd__decap_3
Xhold860 u_pe_array.g_pe_row\[3\].g_pe_col\[0\].u_pe.act_val\[0\] VGND VGND VPWR VPWR
+ net934 sky130_fd_sc_hd__dlygate4sd3_1
XFILLER_0_102_699 VGND VGND VPWR VPWR sky130_fd_sc_hd__fill_1
XFILLER_0_13_15 VPWR VGND VPWR VGND sky130_ef_sc_hd__decap_12
XFILLER_0_66_141 VGND VGND VPWR VPWR sky130_fd_sc_hd__decap_6
XFILLER_0_109_243 VGND VGND VPWR VPWR sky130_fd_sc_hd__decap_3
XFILLER_0_67_697 VGND VGND VPWR VPWR sky130_fd_sc_hd__decap_8
XFILLER_0_81_155 VGND VGND VPWR VPWR sky130_fd_sc_hd__decap_4
XFILLER_0_81_144 VGND VGND VPWR VPWR sky130_fd_sc_hd__decap_8
XFILLER_0_81_133 VGND VGND VPWR VPWR sky130_fd_sc_hd__decap_8
XFILLER_0_81_188 VGND VGND VPWR VPWR sky130_fd_sc_hd__fill_1
XFILLER_0_35_561 VGND VGND VPWR VPWR sky130_fd_sc_hd__decap_6
XFILLER_0_112_419 VGND VGND VPWR VPWR sky130_fd_sc_hd__fill_1
XFILLER_0_62_380 VGND VGND VPWR VPWR sky130_fd_sc_hd__fill_1
XFILLER_0_1_105 VGND VGND VPWR VPWR sky130_fd_sc_hd__decap_6
XFILLER_0_22_233 VGND VGND VPWR VPWR sky130_fd_sc_hd__fill_1
XFILLER_0_50_531 VGND VGND VPWR VPWR sky130_fd_sc_hd__fill_1
XFILLER_0_50_542 VGND VGND VPWR VPWR sky130_fd_sc_hd__fill_1
XFILLER_0_1_149 VPWR VGND VPWR VGND sky130_ef_sc_hd__decap_12
XFILLER_0_22_277 VGND VGND VPWR VPWR sky130_fd_sc_hd__decap_8
XFILLER_0_10_439 VGND VGND VPWR VPWR sky130_fd_sc_hd__fill_2
XFILLER_0_22_288 VGND VGND VPWR VPWR sky130_fd_sc_hd__decap_4
XFILLER_0_38_78 VGND VGND VPWR VPWR sky130_fd_sc_hd__decap_6
X_6820_ _3381_ u_pe_array.u_fifo2.count\[0\] u_pe_array.u_fifo2.count\[3\] _2341_
+ u_pe_array.u_fifo2.count\[1\] VGND VGND VPWR VPWR _3385_ sky130_fd_sc_hd__a41o_1
X_6751_ u_pe_array.g_pe_row\[0\].g_pe_col\[0\].u_pe.psum_out\[10\] _3333_ _3324_ VGND
+ VGND VPWR VPWR _3334_ sky130_fd_sc_hd__mux2_1
XFILLER_0_70_32 VGND VGND VPWR VPWR sky130_fd_sc_hd__fill_1
XFILLER_0_9_249 VGND VGND VPWR VPWR sky130_fd_sc_hd__decap_8
X_3963_ net102 u_fsm.psum_shift_en _1175_ u_pe_array.g_pe_row\[3\].g_pe_col\[2\].u_pe.move_reg\[6\]
+ VGND VGND VPWR VPWR _0090_ sky130_fd_sc_hd__a22o_1
X_5702_ u_pe_array.g_pe_row\[1\].g_pe_col\[1\].u_pe.psum_out\[0\] u_pe_array.g_pe_row\[1\].g_pe_col\[1\].u_pe.act_val\[0\]
+ u_pe_array.g_pe_row\[1\].g_pe_col\[1\].u_pe.w_out\[0\] VGND VGND VPWR VPWR _2513_
+ sky130_fd_sc_hd__and3_1
X_6682_ _3264_ _3263_ _3271_ VGND VGND VPWR VPWR _3272_ sky130_fd_sc_hd__a21oi_1
XFILLER_0_58_697 VGND VGND VPWR VPWR sky130_fd_sc_hd__decap_3
X_3894_ _1133_ _1112_ VGND VGND VPWR VPWR _1134_ sky130_fd_sc_hd__nand2_1
XFILLER_0_45_369 VGND VGND VPWR VPWR sky130_fd_sc_hd__decap_3
X_5633_ _2469_ _2473_ VGND VGND VPWR VPWR _2475_ sky130_fd_sc_hd__or2_1
XFILLER_0_72_188 VGND VGND VPWR VPWR sky130_fd_sc_hd__decap_8
XFILLER_0_14_701 VGND VGND VPWR VPWR sky130_fd_sc_hd__decap_4
X_5564_ _2410_ _2411_ VGND VGND VPWR VPWR _2412_ sky130_fd_sc_hd__nor2_1
XFILLER_0_115_279 VGND VGND VPWR VPWR sky130_fd_sc_hd__fill_1
Xhold101 u_pe_array.act_from_down\[1\]\[1\] VGND VGND VPWR VPWR net175 sky130_fd_sc_hd__buf_1
XFILLER_0_79_52 VGND VGND VPWR VPWR sky130_fd_sc_hd__fill_1
X_7303_ clknet_leaf_107_clk _0209_ net944 VGND VGND VPWR VPWR u_pe_array.act_from_right\[10\]\[2\]
+ sky130_fd_sc_hd__dfrtp_1
X_4515_ u_pe_array.g_pe_row\[2\].g_pe_col\[3\].u_pe.psum_out\[5\] u_pe_array.g_pe_row\[2\].g_pe_col\[3\].u_pe.act_val\[5\]
+ _1599_ VGND VGND VPWR VPWR _1606_ sky130_fd_sc_hd__mux2_1
Xhold134 u_pe_array.g_pe_row\[1\].g_pe_col\[0\].u_pe.move_reg\[11\] VGND VGND VPWR
+ VPWR net208 sky130_fd_sc_hd__dlygate4sd3_1
Xhold112 _0445_ VGND VGND VPWR VPWR net186 sky130_fd_sc_hd__dlygate4sd3_1
Xhold123 u_fsm.v_cnt\[2\] VGND VGND VPWR VPWR net197 sky130_fd_sc_hd__dlygate4sd3_1
X_5495_ _2320_ _2356_ _2357_ _2343_ net647 VGND VGND VPWR VPWR _0440_ sky130_fd_sc_hd__a32o_1
Xhold156 u_pe_array.g_pe_row\[0\].g_pe_col\[0\].u_pe.move_reg\[11\] VGND VGND VPWR
+ VPWR net230 sky130_fd_sc_hd__dlygate4sd3_1
X_7234_ clknet_leaf_21_clk _0140_ net943 VGND VGND VPWR VPWR u_pe_array.g_pe_row\[3\].g_pe_col\[1\].u_pe.psum_out\[2\]
+ sky130_fd_sc_hd__dfrtp_1
Xhold167 _0491_ VGND VGND VPWR VPWR net241 sky130_fd_sc_hd__dlygate4sd3_1
Xhold145 _0617_ VGND VGND VPWR VPWR net219 sky130_fd_sc_hd__dlygate4sd3_1
X_4446_ _1541_ _1546_ _1549_ VGND VGND VPWR VPWR _1550_ sky130_fd_sc_hd__o21bai_1
Xhold189 u_pe_array.g_pe_row\[2\].g_pe_col\[0\].u_pe.move_reg\[12\] VGND VGND VPWR
+ VPWR net263 sky130_fd_sc_hd__dlygate4sd3_1
Xhold178 _0190_ VGND VGND VPWR VPWR net252 sky130_fd_sc_hd__dlygate4sd3_1
X_7165_ clknet_leaf_107_clk _0071_ net944 VGND VGND VPWR VPWR u_pe_array.act_from_left\[15\]\[0\]
+ sky130_fd_sc_hd__dfrtp_1
X_4377_ _0977_ VGND VGND VPWR VPWR _1487_ sky130_fd_sc_hd__buf_8
X_6116_ u_pe_array.g_pe_row\[0\].g_pe_col\[3\].u_pe.psum_out\[6\] u_pe_array.g_pe_row\[0\].g_pe_col\[3\].u_pe.move_reg\[6\]
+ _2844_ VGND VGND VPWR VPWR _2852_ sky130_fd_sc_hd__mux2_1
XTAP_450 VGND VPWR sky130_fd_sc_hd__tapvpwrvgnd_1
XTAP_461 VGND VPWR sky130_fd_sc_hd__tapvpwrvgnd_1
XTAP_472 VGND VPWR sky130_fd_sc_hd__tapvpwrvgnd_1
XTAP_483 VGND VPWR sky130_fd_sc_hd__tapvpwrvgnd_1
XTAP_494 VGND VPWR sky130_fd_sc_hd__tapvpwrvgnd_1
X_7096_ clknet_leaf_82_clk _0002_ net949 VGND VGND VPWR VPWR u_fsm.cnt\[2\] sky130_fd_sc_hd__dfrtp_1
X_6047_ _2787_ _2792_ _2796_ VGND VGND VPWR VPWR _2797_ sky130_fd_sc_hd__o21bai_1
XTAP_1605 VGND VPWR sky130_fd_sc_hd__tapvpwrvgnd_1
XTAP_1649 VGND VPWR sky130_fd_sc_hd__tapvpwrvgnd_1
XTAP_1638 VGND VPWR sky130_fd_sc_hd__tapvpwrvgnd_1
XTAP_1627 VGND VPWR sky130_fd_sc_hd__tapvpwrvgnd_1
XTAP_1616 VGND VPWR sky130_fd_sc_hd__tapvpwrvgnd_1
XFILLER_0_83_409 VGND VGND VPWR VPWR sky130_fd_sc_hd__decap_6
X_6949_ _3458_ _3456_ _3459_ VGND VGND VPWR VPWR _0792_ sky130_fd_sc_hd__a21oi_1
XFILLER_0_48_130 VGND VGND VPWR VPWR sky130_fd_sc_hd__decap_3
XFILLER_0_48_141 VGND VGND VPWR VPWR sky130_fd_sc_hd__decap_6
XFILLER_0_91_431 VGND VGND VPWR VPWR sky130_fd_sc_hd__fill_1
XFILLER_0_76_472 VGND VGND VPWR VPWR sky130_fd_sc_hd__decap_4
XFILLER_0_91_464 VGND VGND VPWR VPWR sky130_fd_sc_hd__fill_1
XFILLER_0_64_689 VGND VGND VPWR VPWR sky130_fd_sc_hd__decap_8
XFILLER_0_32_531 VGND VGND VPWR VPWR sky130_fd_sc_hd__fill_1
XFILLER_0_44_391 VGND VGND VPWR VPWR sky130_fd_sc_hd__fill_1
Xhold690 u_pe_array.g_pe_row\[3\].g_pe_col\[0\].u_pe.psum_out\[11\] VGND VGND VPWR
+ VPWR net764 sky130_fd_sc_hd__dlygate4sd3_1
XFILLER_0_67_494 VGND VGND VPWR VPWR sky130_fd_sc_hd__decap_3
XFILLER_0_70_637 VGND VGND VPWR VPWR sky130_fd_sc_hd__decap_6
XFILLER_0_112_249 VGND VGND VPWR VPWR sky130_fd_sc_hd__decap_3
X_5280_ _2179_ VGND VGND VPWR VPWR _2183_ sky130_fd_sc_hd__inv_2
X_4300_ u_pe_array.g_pe_row\[3\].g_pe_col\[0\].u_pe.act_val\[5\] VGND VGND VPWR VPWR
+ _1445_ sky130_fd_sc_hd__inv_2
XFILLER_0_2_469 VGND VGND VPWR VPWR sky130_fd_sc_hd__decap_6
X_4231_ _1352_ _1353_ _1387_ VGND VGND VPWR VPWR _1388_ sky130_fd_sc_hd__or3_1
XFILLER_0_57_9 VGND VGND VPWR VPWR sky130_fd_sc_hd__fill_2
XFILLER_0_10_247 VGND VGND VPWR VPWR sky130_fd_sc_hd__decap_4
X_4162_ _1322_ _1324_ VGND VGND VPWR VPWR _1325_ sky130_fd_sc_hd__xnor2_1
X_4093_ _1285_ VGND VGND VPWR VPWR _0110_ sky130_fd_sc_hd__clkbuf_1
XFILLER_0_65_65 VGND VGND VPWR VPWR sky130_fd_sc_hd__fill_2
X_7921_ clknet_leaf_77_clk _0826_ VGND VGND VPWR VPWR u_pe_array.u_fifo1.buffer\[3\]\[5\]
+ sky130_fd_sc_hd__dfxtp_1
XFILLER_0_77_225 VPWR VGND VPWR VGND sky130_ef_sc_hd__decap_12
X_7852_ clknet_leaf_101_clk _0757_ VGND VGND VPWR VPWR u_pe_array.u_fifo2.buffer\[2\]\[4\]
+ sky130_fd_sc_hd__dfxtp_1
X_4995_ u_pe_array.g_pe_row\[2\].g_pe_col\[1\].u_pe.psum_out\[9\] _1105_ VGND VGND
+ VPWR VPWR _1974_ sky130_fd_sc_hd__or2_1
X_6803_ u_pe_array.u_fifo2.rd_ptr\[0\] _3371_ _3372_ VGND VGND VPWR VPWR _3373_ sky130_fd_sc_hd__o21ai_1
X_7783_ clknet_leaf_73_clk _0689_ net13 VGND VGND VPWR VPWR u_pe_array.act_from_up\[4\]\[5\]
+ sky130_fd_sc_hd__dfrtp_1
XFILLER_0_105_93 VPWR VGND VPWR VGND sky130_ef_sc_hd__decap_12
X_6734_ _3317_ _3318_ VGND VGND VPWR VPWR _3319_ sky130_fd_sc_hd__and2_1
XFILLER_0_92_239 VGND VGND VPWR VPWR sky130_fd_sc_hd__fill_2
XFILLER_0_45_100 VGND VGND VPWR VPWR sky130_fd_sc_hd__fill_2
XFILLER_0_45_111 VGND VGND VPWR VPWR sky130_fd_sc_hd__fill_1
X_3946_ _0983_ _1153_ _1166_ net134 VGND VGND VPWR VPWR _0082_ sky130_fd_sc_hd__a22o_1
XFILLER_0_116_500 VGND VGND VPWR VPWR sky130_fd_sc_hd__decap_3
XFILLER_0_45_122 VGND VGND VPWR VPWR sky130_fd_sc_hd__decap_4
XFILLER_0_46_645 VGND VGND VPWR VPWR sky130_fd_sc_hd__fill_2
XFILLER_0_46_656 VGND VGND VPWR VPWR sky130_fd_sc_hd__decap_6
X_6665_ u_pe_array.g_pe_row\[0\].g_pe_col\[0\].u_pe.act_val\[2\] _2486_ u_pe_array.g_pe_row\[0\].g_pe_col\[0\].u_pe.psum_out\[2\]
+ VGND VGND VPWR VPWR _3256_ sky130_fd_sc_hd__a21oi_1
XFILLER_0_90_3 VPWR VGND VPWR VGND sky130_ef_sc_hd__decap_12
XFILLER_0_61_637 VGND VGND VPWR VPWR sky130_fd_sc_hd__fill_1
X_3877_ u_pe_array.act_from_right\[13\]\[1\] _1120_ _1116_ VGND VGND VPWR VPWR _1121_
+ sky130_fd_sc_hd__mux2_1
X_6596_ _2268_ u_pe_array.g_pe_row\[0\].g_pe_col\[1\].u_pe.psum_out\[11\] VGND VGND
+ VPWR VPWR _3219_ sky130_fd_sc_hd__and2b_1
X_5616_ _2451_ _2454_ _2459_ VGND VGND VPWR VPWR _2460_ sky130_fd_sc_hd__a21oi_1
X_5547_ u_pe_array.g_pe_row\[1\].g_pe_col\[2\].u_pe.act_val\[2\] _1595_ _2389_ VGND
+ VGND VPWR VPWR _2396_ sky130_fd_sc_hd__and3_1
X_5478_ _0938_ VGND VGND VPWR VPWR _2343_ sky130_fd_sc_hd__buf_8
X_7217_ clknet_leaf_14_clk _0123_ net942 VGND VGND VPWR VPWR u_pe_array.act_from_down\[9\]\[11\]
+ sky130_fd_sc_hd__dfrtp_1
X_4429_ _1522_ _1525_ _1533_ VGND VGND VPWR VPWR _1535_ sky130_fd_sc_hd__o21ai_1
XFILLER_0_111_293 VGND VGND VPWR VPWR sky130_fd_sc_hd__decap_6
X_7148_ clknet_leaf_23_clk _0054_ net943 VGND VGND VPWR VPWR u_pe_array.g_pe_row\[3\].g_pe_col\[3\].u_pe.psum_out\[11\]
+ sky130_fd_sc_hd__dfrtp_1
XTAP_280 VGND VPWR sky130_fd_sc_hd__tapvpwrvgnd_1
XTAP_291 VGND VPWR sky130_fd_sc_hd__tapvpwrvgnd_1
X_7079_ net571 _3347_ _3536_ VGND VGND VPWR VPWR _3537_ sky130_fd_sc_hd__mux2_1
XTAP_1424 VGND VPWR sky130_fd_sc_hd__tapvpwrvgnd_1
XTAP_1402 VGND VPWR sky130_fd_sc_hd__tapvpwrvgnd_1
XTAP_1413 VGND VPWR sky130_fd_sc_hd__tapvpwrvgnd_1
XFILLER_0_96_589 VPWR VGND VPWR VGND sky130_ef_sc_hd__decap_12
XTAP_1457 VGND VPWR sky130_fd_sc_hd__tapvpwrvgnd_1
XTAP_1446 VGND VPWR sky130_fd_sc_hd__tapvpwrvgnd_1
XTAP_1435 VGND VPWR sky130_fd_sc_hd__tapvpwrvgnd_1
XTAP_1479 VGND VPWR sky130_fd_sc_hd__tapvpwrvgnd_1
XTAP_1468 VGND VPWR sky130_fd_sc_hd__tapvpwrvgnd_1
XFILLER_0_49_483 VGND VGND VPWR VPWR sky130_fd_sc_hd__fill_1
Xfanout73 net13 VGND VGND VPWR VPWR net73 sky130_fd_sc_hd__clkbuf_8
XFILLER_0_37_645 VGND VGND VPWR VPWR sky130_fd_sc_hd__fill_1
XFILLER_0_37_667 VGND VGND VPWR VPWR sky130_fd_sc_hd__decap_4
XFILLER_0_52_615 VGND VGND VPWR VPWR sky130_fd_sc_hd__decap_6
XFILLER_0_64_497 VGND VGND VPWR VPWR sky130_fd_sc_hd__fill_2
XFILLER_0_10_27 VGND VGND VPWR VPWR sky130_fd_sc_hd__fill_1
XFILLER_0_51_136 VGND VGND VPWR VPWR sky130_fd_sc_hd__decap_3
XFILLER_0_51_169 VGND VGND VPWR VPWR sky130_fd_sc_hd__decap_4
XFILLER_0_35_57 VGND VGND VPWR VPWR sky130_fd_sc_hd__decap_3
XFILLER_0_59_225 VGND VGND VPWR VPWR sky130_fd_sc_hd__decap_6
XFILLER_0_47_409 VGND VGND VPWR VPWR sky130_fd_sc_hd__fill_1
X_3800_ _1050_ _1051_ _1053_ VGND VGND VPWR VPWR _1054_ sky130_fd_sc_hd__a21oi_1
XFILLER_0_74_217 VGND VGND VPWR VPWR sky130_fd_sc_hd__fill_1
X_4780_ _1487_ _1801_ _1802_ _1803_ net568 VGND VGND VPWR VPWR _0279_ sky130_fd_sc_hd__a32o_1
XFILLER_0_27_111 VGND VGND VPWR VPWR sky130_fd_sc_hd__fill_1
X_3731_ _0987_ _0989_ VGND VGND VPWR VPWR _0990_ sky130_fd_sc_hd__xor2_1
XFILLER_0_27_144 VGND VGND VPWR VPWR sky130_fd_sc_hd__fill_2
XFILLER_0_28_645 VGND VGND VPWR VPWR sky130_fd_sc_hd__decap_4
XFILLER_0_55_486 VGND VGND VPWR VPWR sky130_fd_sc_hd__decap_8
XFILLER_0_27_166 VGND VGND VPWR VPWR sky130_fd_sc_hd__fill_2
X_6450_ net319 _3101_ _2987_ _3106_ VGND VGND VPWR VPWR _0646_ sky130_fd_sc_hd__a22o_1
X_3662_ u_pe_array.g_pe_row\[3\].g_pe_col\[3\].u_pe.psum_out\[0\] u_pe_array.g_pe_row\[3\].g_pe_col\[3\].u_pe.act_val\[0\]
+ _0947_ VGND VGND VPWR VPWR _0948_ sky130_fd_sc_hd__mux2_1
XFILLER_0_15_328 VGND VGND VPWR VPWR sky130_fd_sc_hd__decap_8
X_6381_ _3048_ _3049_ VGND VGND VPWR VPWR _3050_ sky130_fd_sc_hd__or2b_1
X_3593_ _0853_ _0874_ VGND VGND VPWR VPWR _0893_ sky130_fd_sc_hd__and2_1
XFILLER_0_30_309 VGND VGND VPWR VPWR sky130_fd_sc_hd__decap_3
X_5401_ net876 _2287_ _2273_ VGND VGND VPWR VPWR _2288_ sky130_fd_sc_hd__mux2_1
X_5332_ _2225_ _2230_ VGND VGND VPWR VPWR _2231_ sky130_fd_sc_hd__or2_1
XFILLER_0_2_233 VPWR VGND VPWR VGND sky130_ef_sc_hd__decap_12
X_5263_ _2166_ _2167_ VGND VGND VPWR VPWR _2168_ sky130_fd_sc_hd__and2_1
X_4214_ _1368_ _1369_ _1371_ VGND VGND VPWR VPWR _1373_ sky130_fd_sc_hd__a21o_1
X_5194_ u_pe_array.g_pe_row\[0\].g_pe_col\[2\].u_pe.w_out\[0\] VGND VGND VPWR VPWR
+ _2128_ sky130_fd_sc_hd__buf_4
X_7002_ net663 _3356_ _3491_ VGND VGND VPWR VPWR _3494_ sky130_fd_sc_hd__mux2_1
X_4145_ net110 _1310_ _1175_ u_pe_array.g_pe_row\[3\].g_pe_col\[1\].u_pe.move_reg\[12\]
+ VGND VGND VPWR VPWR _0137_ sky130_fd_sc_hd__a22o_1
XFILLER_0_92_41 VPWR VGND VPWR VGND sky130_ef_sc_hd__decap_12
X_4076_ _1266_ _1270_ VGND VGND VPWR VPWR _1272_ sky130_fd_sc_hd__or2_1
XFILLER_0_92_85 VGND VGND VPWR VPWR sky130_fd_sc_hd__decap_8
X_7904_ clknet_leaf_82_clk _0809_ VGND VGND VPWR VPWR u_pe_array.u_fifo1.buffer\[1\]\[0\]
+ sky130_fd_sc_hd__dfxtp_1
X_7835_ clknet_leaf_85_clk _0740_ net948 VGND VGND VPWR VPWR u_pe_array.u_fifo2.count\[3\]
+ sky130_fd_sc_hd__dfrtp_2
X_4978_ _1953_ _1957_ VGND VGND VPWR VPWR _1959_ sky130_fd_sc_hd__nand2_1
X_7766_ clknet_leaf_52_clk _0672_ net74 VGND VGND VPWR VPWR u_pe_array.g_pe_row\[0\].g_pe_col\[1\].u_pe.psum_out\[3\]
+ sky130_fd_sc_hd__dfrtp_1
X_6717_ _3301_ _3303_ VGND VGND VPWR VPWR _3304_ sky130_fd_sc_hd__or2_1
XFILLER_0_61_401 VGND VGND VPWR VPWR sky130_fd_sc_hd__fill_2
X_3929_ _1160_ VGND VGND VPWR VPWR _0071_ sky130_fd_sc_hd__clkbuf_1
X_7697_ clknet_leaf_75_clk _0603_ net949 VGND VGND VPWR VPWR u_pe_array.act_from_up\[6\]\[1\]
+ sky130_fd_sc_hd__dfrtp_1
X_6648_ u_pe_array.act_from_right\[0\]\[11\] _0866_ _0940_ net230 VGND VGND VPWR VPWR
+ _0708_ sky130_fd_sc_hd__a22o_1
XFILLER_0_6_550 VPWR VGND VPWR VGND sky130_ef_sc_hd__decap_12
XFILLER_0_33_125 VGND VGND VPWR VPWR sky130_fd_sc_hd__decap_3
XFILLER_0_33_169 VGND VGND VPWR VPWR sky130_fd_sc_hd__fill_2
X_6579_ u_pe_array.g_pe_row\[0\].g_pe_col\[1\].u_pe.psum_out\[9\] _2268_ VGND VGND
+ VPWR VPWR _3204_ sky130_fd_sc_hd__or2_1
XFILLER_0_14_361 VGND VGND VPWR VPWR sky130_fd_sc_hd__decap_3
XFILLER_0_69_512 VGND VGND VPWR VPWR sky130_fd_sc_hd__fill_2
XTAP_1232 VGND VPWR sky130_fd_sc_hd__tapvpwrvgnd_1
XTAP_1221 VGND VPWR sky130_fd_sc_hd__tapvpwrvgnd_1
XTAP_1210 VGND VPWR sky130_fd_sc_hd__tapvpwrvgnd_1
XTAP_1265 VGND VPWR sky130_fd_sc_hd__tapvpwrvgnd_1
XTAP_1243 VGND VPWR sky130_fd_sc_hd__tapvpwrvgnd_1
XTAP_1254 VGND VPWR sky130_fd_sc_hd__tapvpwrvgnd_1
XFILLER_0_56_217 VPWR VGND VPWR VGND sky130_ef_sc_hd__decap_12
XTAP_1298 VGND VPWR sky130_fd_sc_hd__tapvpwrvgnd_1
XTAP_1287 VGND VPWR sky130_fd_sc_hd__tapvpwrvgnd_1
XTAP_1276 VGND VPWR sky130_fd_sc_hd__tapvpwrvgnd_1
XFILLER_0_37_464 VGND VGND VPWR VPWR sky130_fd_sc_hd__decap_3
XFILLER_0_37_486 VPWR VGND VPWR VGND sky130_ef_sc_hd__decap_12
XFILLER_0_115_9 VPWR VGND VPWR VGND sky130_ef_sc_hd__decap_12
XFILLER_0_52_434 VPWR VGND VPWR VGND sky130_ef_sc_hd__decap_12
XFILLER_0_24_147 VGND VGND VPWR VPWR sky130_fd_sc_hd__fill_1
XFILLER_0_32_191 VGND VGND VPWR VPWR sky130_fd_sc_hd__decap_4
XFILLER_0_103_591 VGND VGND VPWR VPWR sky130_fd_sc_hd__fill_2
XFILLER_0_46_23 VGND VGND VPWR VPWR sky130_fd_sc_hd__decap_4
X_5950_ u_pe_array.u_fifo1.buffer\[0\]\[4\] _2678_ VGND VGND VPWR VPWR _2716_ sky130_fd_sc_hd__or2_1
X_4901_ u_pe_array.g_pe_row\[2\].g_pe_col\[1\].u_pe.act_val\[1\] u_pe_array.g_pe_row\[2\].g_pe_col\[1\].u_pe.w_out\[0\]
+ VGND VGND VPWR VPWR _1888_ sky130_fd_sc_hd__nand2_1
XFILLER_0_62_33 VPWR VGND VPWR VGND sky130_ef_sc_hd__decap_12
XFILLER_0_1_69 VPWR VGND VPWR VGND sky130_ef_sc_hd__decap_12
X_5881_ _2665_ VGND VGND VPWR VPWR _0518_ sky130_fd_sc_hd__clkbuf_1
XFILLER_0_47_228 VGND VGND VPWR VPWR sky130_fd_sc_hd__decap_8
X_7620_ clknet_leaf_69_clk _0526_ net72 VGND VGND VPWR VPWR u_pe_array.act_from_left\[5\]\[6\]
+ sky130_fd_sc_hd__dfrtp_1
XFILLER_0_118_617 VGND VGND VPWR VPWR sky130_fd_sc_hd__decap_8
XFILLER_0_117_105 VGND VGND VPWR VPWR sky130_fd_sc_hd__decap_4
X_4832_ _1839_ _1849_ _1850_ VGND VGND VPWR VPWR _1851_ sky130_fd_sc_hd__a21oi_1
XFILLER_0_83_570 VGND VGND VPWR VPWR sky130_fd_sc_hd__fill_2
XFILLER_0_55_261 VPWR VGND VPWR VGND sky130_ef_sc_hd__decap_12
X_4763_ u_pe_array.g_pe_row\[2\].g_pe_col\[2\].u_pe.psum_out\[3\] _1773_ _1774_ VGND
+ VGND VPWR VPWR _1788_ sky130_fd_sc_hd__a21boi_1
XFILLER_0_28_464 VGND VGND VPWR VPWR sky130_fd_sc_hd__fill_2
X_7551_ clknet_leaf_94_clk _0457_ net949 VGND VGND VPWR VPWR u_pe_array.g_pe_row\[1\].g_pe_col\[2\].u_pe.psum_out\[6\]
+ sky130_fd_sc_hd__dfrtp_1
X_6502_ _3126_ _3132_ _1003_ VGND VGND VPWR VPWR _3134_ sky130_fd_sc_hd__a21o_1
X_3714_ _0975_ VGND VGND VPWR VPWR _0041_ sky130_fd_sc_hd__clkbuf_1
X_7482_ clknet_leaf_38_clk _0388_ net951 VGND VGND VPWR VPWR u_pe_array.g_pe_row\[1\].g_pe_col\[3\].u_pe.act_val\[4\]
+ sky130_fd_sc_hd__dfrtp_2
XFILLER_0_15_125 VGND VGND VPWR VPWR sky130_fd_sc_hd__fill_1
X_4694_ net102 _1732_ _1735_ _1742_ VGND VGND VPWR VPWR _0254_ sky130_fd_sc_hd__a22o_1
XFILLER_0_70_231 VGND VGND VPWR VPWR sky130_fd_sc_hd__fill_2
XFILLER_0_15_158 VGND VGND VPWR VPWR sky130_fd_sc_hd__decap_3
X_6433_ _3082_ _3086_ _3093_ _3095_ _3092_ VGND VGND VPWR VPWR _3096_ sky130_fd_sc_hd__a32o_1
XFILLER_0_113_355 VGND VGND VPWR VPWR sky130_fd_sc_hd__decap_4
XFILLER_0_102_83 VGND VGND VPWR VPWR sky130_fd_sc_hd__fill_1
X_3645_ _0932_ VGND VGND VPWR VPWR _0015_ sky130_fd_sc_hd__clkbuf_1
XFILLER_0_3_553 VGND VGND VPWR VPWR sky130_fd_sc_hd__decap_6
XFILLER_0_3_597 VPWR VGND VPWR VGND sky130_ef_sc_hd__decap_12
X_3576_ _0867_ _0880_ _0882_ VGND VGND VPWR VPWR _0883_ sky130_fd_sc_hd__or3b_1
X_6364_ u_pe_array.g_pe_row\[0\].g_pe_col\[2\].u_pe.act_val\[5\] _2128_ VGND VGND
+ VPWR VPWR _3034_ sky130_fd_sc_hd__nand2_1
X_5315_ _2205_ VGND VGND VPWR VPWR _2215_ sky130_fd_sc_hd__inv_2
X_6295_ u_pe_array.g_pe_row\[0\].g_pe_col\[2\].u_pe.psum_out\[11\] u_pe_array.g_pe_row\[0\].g_pe_col\[2\].u_pe.move_reg\[11\]
+ _2844_ VGND VGND VPWR VPWR _2985_ sky130_fd_sc_hd__mux2_1
XFILLER_0_11_364 VGND VGND VPWR VPWR sky130_fd_sc_hd__fill_1
X_5246_ _2156_ VGND VGND VPWR VPWR _0392_ sky130_fd_sc_hd__clkbuf_1
Xhold27 _0091_ VGND VGND VPWR VPWR net101 sky130_fd_sc_hd__dlygate4sd3_1
Xhold38 u_pe_array.act_from_left\[15\]\[7\] VGND VGND VPWR VPWR net112 sky130_fd_sc_hd__dlygate4sd3_1
Xhold16 _0095_ VGND VGND VPWR VPWR net90 sky130_fd_sc_hd__dlygate4sd3_1
X_5177_ _2112_ _2113_ VGND VGND VPWR VPWR _2114_ sky130_fd_sc_hd__and2_1
Xhold49 u_pe_array.act_from_right\[10\]\[5\] VGND VGND VPWR VPWR net123 sky130_fd_sc_hd__dlygate4sd3_1
X_4128_ net719 _1301_ _1169_ _1304_ VGND VGND VPWR VPWR _0126_ sky130_fd_sc_hd__a22o_1
XFILLER_0_97_139 VPWR VGND VPWR VGND sky130_ef_sc_hd__decap_12
X_4059_ _1248_ _1251_ _1256_ VGND VGND VPWR VPWR _1257_ sky130_fd_sc_hd__a21oi_2
XFILLER_0_78_331 VGND VGND VPWR VPWR sky130_fd_sc_hd__fill_1
XFILLER_0_109_606 VGND VGND VPWR VPWR sky130_fd_sc_hd__decap_8
X_7818_ clknet_leaf_89_clk _0723_ VGND VGND VPWR VPWR u_pe_array.u_fifo1.buffer\[8\]\[0\]
+ sky130_fd_sc_hd__dfxtp_1
X_7749_ clknet_leaf_42_clk net399 net946 VGND VGND VPWR VPWR u_pe_array.act_from_right\[0\]\[12\]
+ sky130_fd_sc_hd__dfrtp_1
XFILLER_0_46_250 VGND VGND VPWR VPWR sky130_fd_sc_hd__fill_2
XFILLER_0_117_661 VGND VGND VPWR VPWR sky130_fd_sc_hd__decap_8
XFILLER_0_46_283 VGND VGND VPWR VPWR sky130_fd_sc_hd__decap_6
XFILLER_0_116_171 VPWR VGND VPWR VGND sky130_ef_sc_hd__decap_12
XFILLER_0_104_344 VGND VGND VPWR VPWR sky130_fd_sc_hd__decap_4
XFILLER_0_61_297 VGND VGND VPWR VPWR sky130_fd_sc_hd__decap_4
XFILLER_0_104_377 VGND VGND VPWR VPWR sky130_fd_sc_hd__decap_3
XFILLER_0_30_640 VGND VGND VPWR VPWR sky130_fd_sc_hd__decap_4
XFILLER_0_100_550 VPWR VGND VPWR VGND sky130_ef_sc_hd__decap_12
XFILLER_0_107_39 VPWR VGND VPWR VGND sky130_ef_sc_hd__decap_12
XFILLER_0_16_15 VPWR VGND VPWR VGND sky130_ef_sc_hd__decap_12
XFILLER_0_69_386 VGND VGND VPWR VPWR sky130_fd_sc_hd__decap_6
XTAP_1040 VGND VPWR sky130_fd_sc_hd__tapvpwrvgnd_1
XTAP_1073 VGND VPWR sky130_fd_sc_hd__tapvpwrvgnd_1
XTAP_1062 VGND VPWR sky130_fd_sc_hd__tapvpwrvgnd_1
XTAP_1051 VGND VPWR sky130_fd_sc_hd__tapvpwrvgnd_1
XFILLER_0_57_548 VPWR VGND VPWR VGND sky130_ef_sc_hd__decap_12
XTAP_1084 VGND VPWR sky130_fd_sc_hd__tapvpwrvgnd_1
XTAP_1095 VGND VPWR sky130_fd_sc_hd__tapvpwrvgnd_1
XFILLER_0_4_306 VGND VGND VPWR VPWR sky130_fd_sc_hd__fill_2
XFILLER_0_4_339 VGND VGND VPWR VPWR sky130_fd_sc_hd__fill_1
XFILLER_0_4_317 VGND VGND VPWR VPWR sky130_fd_sc_hd__decap_3
XFILLER_0_13_607 VGND VGND VPWR VPWR sky130_fd_sc_hd__fill_1
XFILLER_0_52_253 VGND VGND VPWR VPWR sky130_fd_sc_hd__fill_1
Xhold508 u_pe_array.g_pe_row\[1\].g_pe_col\[1\].u_pe.psum_out\[6\] VGND VGND VPWR
+ VPWR net582 sky130_fd_sc_hd__dlygate4sd3_1
XFILLER_0_52_264 VGND VGND VPWR VPWR sky130_fd_sc_hd__fill_2
XFILLER_0_110_314 VGND VGND VPWR VPWR sky130_fd_sc_hd__decap_8
XFILLER_0_12_139 VGND VGND VPWR VPWR sky130_fd_sc_hd__fill_1
Xhold519 u_pe_array.u_fifo2.buffer\[2\]\[0\] VGND VGND VPWR VPWR net593 sky130_fd_sc_hd__dlygate4sd3_1
XFILLER_0_0_545 VGND VGND VPWR VPWR sky130_fd_sc_hd__decap_4
X_5100_ _2043_ VGND VGND VPWR VPWR _2044_ sky130_fd_sc_hd__inv_2
X_6080_ _2825_ _2826_ VGND VGND VPWR VPWR _2827_ sky130_fd_sc_hd__nand2_1
XFILLER_0_0_589 VGND VGND VPWR VPWR sky130_fd_sc_hd__decap_8
XTAP_802 VGND VPWR sky130_fd_sc_hd__tapvpwrvgnd_1
XTAP_813 VGND VPWR sky130_fd_sc_hd__tapvpwrvgnd_1
XTAP_824 VGND VPWR sky130_fd_sc_hd__tapvpwrvgnd_1
XTAP_835 VGND VPWR sky130_fd_sc_hd__tapvpwrvgnd_1
X_5031_ net879 _1732_ _1735_ _2002_ VGND VGND VPWR VPWR _0331_ sky130_fd_sc_hd__a22o_1
XFILLER_0_57_66 VGND VGND VPWR VPWR sky130_fd_sc_hd__decap_3
XTAP_846 VGND VPWR sky130_fd_sc_hd__tapvpwrvgnd_1
XTAP_857 VGND VPWR sky130_fd_sc_hd__tapvpwrvgnd_1
XTAP_868 VGND VPWR sky130_fd_sc_hd__tapvpwrvgnd_1
XTAP_879 VGND VPWR sky130_fd_sc_hd__tapvpwrvgnd_1
X_6982_ net911 _3471_ _3474_ _3482_ VGND VGND VPWR VPWR _0802_ sky130_fd_sc_hd__a211o_1
XFILLER_0_87_150 VPWR VGND VPWR VGND sky130_ef_sc_hd__decap_12
X_5933_ _2320_ _2700_ _2701_ _2343_ net598 VGND VGND VPWR VPWR _0534_ sky130_fd_sc_hd__a32o_1
X_5864_ net792 _2652_ _2273_ VGND VGND VPWR VPWR _2653_ sky130_fd_sc_hd__mux2_1
XFILLER_0_118_447 VGND VGND VPWR VPWR sky130_fd_sc_hd__fill_1
X_7603_ clknet_leaf_31_clk _0509_ net71 VGND VGND VPWR VPWR net41 sky130_fd_sc_hd__dfrtp_1
XFILLER_0_75_378 VPWR VGND VPWR VGND sky130_ef_sc_hd__decap_12
XFILLER_0_8_645 VPWR VGND VPWR VGND sky130_ef_sc_hd__decap_12
XFILLER_0_7_111 VGND VGND VPWR VPWR sky130_fd_sc_hd__fill_1
X_4815_ _1828_ _1830_ _1835_ VGND VGND VPWR VPWR _1836_ sky130_fd_sc_hd__or3_1
X_5795_ _2589_ _2591_ _2596_ VGND VGND VPWR VPWR _2598_ sky130_fd_sc_hd__o21a_1
X_7534_ clknet_leaf_92_clk _0440_ net948 VGND VGND VPWR VPWR u_pe_array.g_pe_row\[1\].g_pe_col\[2\].u_pe.act_val\[2\]
+ sky130_fd_sc_hd__dfrtp_1
XFILLER_0_113_93 VPWR VGND VPWR VGND sky130_ef_sc_hd__decap_12
X_4746_ u_pe_array.g_pe_row\[2\].g_pe_col\[2\].u_pe.act_val\[2\] VGND VGND VPWR VPWR
+ _1772_ sky130_fd_sc_hd__inv_2
XFILLER_0_16_445 VGND VGND VPWR VPWR sky130_fd_sc_hd__fill_1
X_7465_ clknet_leaf_65_clk _0371_ net946 VGND VGND VPWR VPWR u_pe_array.act_from_down\[3\]\[0\]
+ sky130_fd_sc_hd__dfrtp_1
XFILLER_0_16_489 VGND VGND VPWR VPWR sky130_fd_sc_hd__decap_4
X_4677_ _1731_ VGND VGND VPWR VPWR _1732_ sky130_fd_sc_hd__buf_8
X_7396_ clknet_leaf_22_clk net341 net943 VGND VGND VPWR VPWR u_pe_array.g_pe_row\[2\].g_pe_col\[1\].u_pe.act_val\[0\]
+ sky130_fd_sc_hd__dfrtp_2
X_6416_ u_pe_array.g_pe_row\[0\].g_pe_col\[2\].u_pe.psum_out\[7\] u_pe_array.g_pe_row\[0\].g_pe_col\[2\].u_pe.psum_out\[8\]
+ _2130_ VGND VGND VPWR VPWR _3081_ sky130_fd_sc_hd__o21a_1
XFILLER_0_12_640 VGND VGND VPWR VPWR sky130_fd_sc_hd__decap_4
X_3628_ _0920_ net616 _0918_ VGND VGND VPWR VPWR _0921_ sky130_fd_sc_hd__mux2_1
Xoutput39 net39 VGND VGND VPWR VPWR psum_out0[12] sky130_fd_sc_hd__clkbuf_4
XFILLER_0_3_383 VGND VGND VPWR VPWR sky130_fd_sc_hd__decap_8
X_6347_ _3017_ _3013_ _3015_ VGND VGND VPWR VPWR _3019_ sky130_fd_sc_hd__or3_1
X_3559_ _0864_ _0866_ VGND VGND VPWR VPWR _0867_ sky130_fd_sc_hd__and2_1
X_6278_ net332 _2006_ _2009_ _2976_ VGND VGND VPWR VPWR _0604_ sky130_fd_sc_hd__a22o_1
X_5229_ net1 net896 _0963_ VGND VGND VPWR VPWR _2148_ sky130_fd_sc_hd__mux2_1
XFILLER_0_94_610 VGND VGND VPWR VPWR sky130_fd_sc_hd__decap_8
XFILLER_0_78_194 VGND VGND VPWR VPWR sky130_fd_sc_hd__fill_2
XPHY_134 VGND VGND VPWR VPWR sky130_fd_sc_hd__decap_3
XPHY_123 VGND VGND VPWR VPWR sky130_fd_sc_hd__decap_3
XPHY_112 VGND VGND VPWR VPWR sky130_fd_sc_hd__decap_3
XPHY_101 VGND VGND VPWR VPWR sky130_fd_sc_hd__decap_3
XFILLER_0_109_447 VGND VGND VPWR VPWR sky130_fd_sc_hd__fill_1
XPHY_167 VGND VGND VPWR VPWR sky130_fd_sc_hd__decap_3
XPHY_156 VGND VGND VPWR VPWR sky130_fd_sc_hd__decap_3
XPHY_145 VGND VGND VPWR VPWR sky130_fd_sc_hd__decap_3
XPHY_189 VGND VGND VPWR VPWR sky130_fd_sc_hd__decap_3
XPHY_178 VGND VGND VPWR VPWR sky130_fd_sc_hd__decap_3
XFILLER_0_81_359 VPWR VGND VPWR VGND sky130_ef_sc_hd__decap_12
XFILLER_0_105_653 VPWR VGND VPWR VGND sky130_ef_sc_hd__decap_12
XFILLER_0_105_697 VGND VGND VPWR VPWR sky130_fd_sc_hd__decap_8
XFILLER_0_104_141 VPWR VGND VPWR VGND sky130_ef_sc_hd__decap_12
XFILLER_0_118_27 VGND VGND VPWR VPWR sky130_fd_sc_hd__fill_1
XFILLER_0_100_380 VPWR VGND VPWR VGND sky130_ef_sc_hd__decap_12
XFILLER_0_89_415 VGND VGND VPWR VPWR sky130_fd_sc_hd__fill_1
XFILLER_0_89_459 VGND VGND VPWR VPWR sky130_fd_sc_hd__decap_8
XPHY_3 VGND VGND VPWR VPWR sky130_fd_sc_hd__decap_3
XFILLER_0_57_389 VGND VGND VPWR VPWR sky130_fd_sc_hd__decap_3
X_4600_ _1650_ _1660_ _1664_ VGND VGND VPWR VPWR _1665_ sky130_fd_sc_hd__o21a_1
XFILLER_0_111_3 VPWR VGND VPWR VGND sky130_ef_sc_hd__decap_12
XFILLER_0_5_615 VGND VGND VPWR VPWR sky130_fd_sc_hd__fill_1
X_5580_ _2411_ _2421_ _2425_ VGND VGND VPWR VPWR _2427_ sky130_fd_sc_hd__nor3_1
XFILLER_0_87_9 VPWR VGND VPWR VGND sky130_ef_sc_hd__decap_12
XFILLER_0_25_253 VGND VGND VPWR VPWR sky130_fd_sc_hd__fill_2
X_4531_ net93 _1605_ _1611_ _1614_ VGND VGND VPWR VPWR _0219_ sky130_fd_sc_hd__a22o_1
Xhold305 _0304_ VGND VGND VPWR VPWR net379 sky130_fd_sc_hd__dlygate4sd3_1
Xhold316 u_pe_array.u_fifo2.wr_ptr\[3\] VGND VGND VPWR VPWR net390 sky130_fd_sc_hd__dlygate4sd3_1
X_7250_ clknet_leaf_3_clk _0156_ net69 VGND VGND VPWR VPWR net55 sky130_fd_sc_hd__dfrtp_1
X_4462_ u_pe_array.g_pe_row\[3\].g_pe_col\[0\].u_pe.psum_out\[8\] _1551_ VGND VGND
+ VPWR VPWR _1565_ sky130_fd_sc_hd__nor2_1
X_6201_ _2795_ _2910_ _2911_ _2621_ net351 VGND VGND VPWR VPWR _0592_ sky130_fd_sc_hd__a32o_1
Xhold349 u_pe_array.g_pe_row\[3\].g_pe_col\[1\].u_pe.psum_out\[4\] VGND VGND VPWR
+ VPWR net423 sky130_fd_sc_hd__dlygate4sd3_1
Xhold327 u_pe_array.act_from_right\[8\]\[11\] VGND VGND VPWR VPWR net401 sky130_fd_sc_hd__dlygate4sd3_1
XFILLER_0_7_57 VPWR VGND VPWR VGND sky130_ef_sc_hd__decap_12
Xhold338 u_pe_array.g_pe_row\[2\].g_pe_col\[2\].u_pe.move_reg\[8\] VGND VGND VPWR
+ VPWR net412 sky130_fd_sc_hd__dlygate4sd3_1
XFILLER_0_40_278 VGND VGND VPWR VPWR sky130_fd_sc_hd__decap_8
X_4393_ _1495_ _1501_ VGND VGND VPWR VPWR _1502_ sky130_fd_sc_hd__nor2_1
X_7181_ clknet_leaf_104_clk _0087_ net944 VGND VGND VPWR VPWR u_pe_array.g_pe_row\[3\].g_pe_col\[2\].u_pe.act_val\[3\]
+ sky130_fd_sc_hd__dfrtp_1
X_6132_ u_pe_array.g_pe_row\[0\].g_pe_col\[3\].u_pe.act_val\[1\] _2853_ _2847_ net171
+ VGND VGND VPWR VPWR _0575_ sky130_fd_sc_hd__a22o_1
XTAP_610 VGND VPWR sky130_fd_sc_hd__tapvpwrvgnd_1
XTAP_621 VGND VPWR sky130_fd_sc_hd__tapvpwrvgnd_1
XTAP_632 VGND VPWR sky130_fd_sc_hd__tapvpwrvgnd_1
XTAP_643 VGND VPWR sky130_fd_sc_hd__tapvpwrvgnd_1
XTAP_654 VGND VPWR sky130_fd_sc_hd__tapvpwrvgnd_1
XTAP_676 VGND VPWR sky130_fd_sc_hd__tapvpwrvgnd_1
XTAP_665 VGND VPWR sky130_fd_sc_hd__tapvpwrvgnd_1
X_6063_ u_pe_array.g_pe_row\[1\].g_pe_col\[0\].u_pe.psum_out\[8\] _2798_ VGND VGND
+ VPWR VPWR _2812_ sky130_fd_sc_hd__nor2_1
X_5014_ u_pe_array.g_pe_row\[2\].g_pe_col\[1\].u_pe.psum_out\[11\] _1990_ _1981_ VGND
+ VGND VPWR VPWR _1991_ sky130_fd_sc_hd__mux2_1
XTAP_687 VGND VPWR sky130_fd_sc_hd__tapvpwrvgnd_1
XTAP_698 VGND VPWR sky130_fd_sc_hd__tapvpwrvgnd_1
XFILLER_0_16_3 VPWR VGND VPWR VGND sky130_ef_sc_hd__decap_12
X_6965_ u_pe_array.u_fifo1.rd_ptr\[3\] _3468_ _3464_ VGND VGND VPWR VPWR _3470_ sky130_fd_sc_hd__o21ai_1
XFILLER_0_48_301 VGND VGND VPWR VPWR sky130_fd_sc_hd__decap_6
X_5916_ u_pe_array.u_fifo1.rd_ptr\[0\] _2682_ u_pe_array.u_fifo1.rd_ptr\[1\] VGND
+ VGND VPWR VPWR _2686_ sky130_fd_sc_hd__and3b_2
XFILLER_0_91_602 VPWR VGND VPWR VGND sky130_ef_sc_hd__decap_12
X_6896_ _0928_ net708 _3423_ VGND VGND VPWR VPWR _3429_ sky130_fd_sc_hd__mux2_1
XFILLER_0_36_518 VGND VGND VPWR VPWR sky130_fd_sc_hd__fill_1
X_5847_ net42 _2639_ _2273_ VGND VGND VPWR VPWR _2640_ sky130_fd_sc_hd__mux2_1
XFILLER_0_29_581 VGND VGND VPWR VPWR sky130_fd_sc_hd__fill_1
XFILLER_0_118_277 VGND VGND VPWR VPWR sky130_fd_sc_hd__decap_3
X_5778_ _2580_ _2581_ VGND VGND VPWR VPWR _2582_ sky130_fd_sc_hd__and2_1
XFILLER_0_8_475 VGND VGND VPWR VPWR sky130_fd_sc_hd__fill_1
X_7517_ clknet_leaf_67_clk _0423_ net946 VGND VGND VPWR VPWR u_pe_array.act_from_right\[5\]\[11\]
+ sky130_fd_sc_hd__dfrtp_1
XFILLER_0_16_253 VGND VGND VPWR VPWR sky130_fd_sc_hd__fill_2
X_4729_ _1753_ _1756_ VGND VGND VPWR VPWR _1757_ sky130_fd_sc_hd__xnor2_1
XFILLER_0_102_612 VGND VGND VPWR VPWR sky130_fd_sc_hd__fill_2
XFILLER_0_102_601 VGND VGND VPWR VPWR sky130_fd_sc_hd__decap_4
X_7448_ clknet_leaf_36_clk net249 net951 VGND VGND VPWR VPWR u_pe_array.g_pe_row\[2\].g_pe_col\[0\].u_pe.move_reg\[11\]
+ sky130_fd_sc_hd__dfrtp_1
XFILLER_0_31_223 VGND VGND VPWR VPWR sky130_fd_sc_hd__fill_1
XFILLER_0_102_645 VPWR VGND VPWR VGND sky130_ef_sc_hd__decap_12
Xhold850 u_pe_array.g_pe_row\[1\].g_pe_col\[1\].u_pe.act_val\[3\] VGND VGND VPWR VPWR
+ net924 sky130_fd_sc_hd__dlygate4sd3_1
Xhold861 u_pe_array.g_pe_row\[3\].g_pe_col\[3\].u_pe.psum_out\[7\] VGND VGND VPWR
+ VPWR net935 sky130_fd_sc_hd__dlygate4sd3_1
X_7379_ clknet_leaf_0_clk _0285_ net944 VGND VGND VPWR VPWR u_pe_array.g_pe_row\[2\].g_pe_col\[2\].u_pe.psum_out\[11\]
+ sky130_fd_sc_hd__dfrtp_1
XFILLER_0_12_492 VGND VGND VPWR VPWR sky130_fd_sc_hd__decap_3
XFILLER_0_98_212 VGND VGND VPWR VPWR sky130_fd_sc_hd__fill_2
XFILLER_0_86_429 VGND VGND VPWR VPWR sky130_fd_sc_hd__decap_8
XFILLER_0_109_200 VGND VGND VPWR VPWR sky130_fd_sc_hd__decap_8
XFILLER_0_104_29 VPWR VGND VPWR VGND sky130_ef_sc_hd__decap_12
XFILLER_0_13_27 VPWR VGND VPWR VGND sky130_ef_sc_hd__decap_12
XFILLER_0_94_473 VGND VGND VPWR VPWR sky130_fd_sc_hd__decap_3
XFILLER_0_66_197 VGND VGND VPWR VPWR sky130_fd_sc_hd__decap_4
XFILLER_0_109_277 VGND VGND VPWR VPWR sky130_fd_sc_hd__decap_3
XFILLER_0_81_167 VGND VGND VPWR VPWR sky130_fd_sc_hd__fill_1
Xclkbuf_leaf_101_clk clknet_3_1__leaf_clk VGND VGND VPWR VPWR clknet_leaf_101_clk
+ sky130_fd_sc_hd__clkbuf_16
XFILLER_0_50_521 VGND VGND VPWR VPWR sky130_fd_sc_hd__fill_2
XFILLER_0_50_554 VPWR VGND VPWR VGND sky130_ef_sc_hd__decap_12
XFILLER_0_38_46 VPWR VGND VPWR VGND sky130_ef_sc_hd__decap_12
XFILLER_0_38_68 VGND VGND VPWR VPWR sky130_fd_sc_hd__fill_2
XFILLER_0_89_223 VGND VGND VPWR VPWR sky130_fd_sc_hd__fill_1
XFILLER_0_54_23 VGND VGND VPWR VPWR sky130_fd_sc_hd__decap_4
X_6750_ _3331_ _3332_ VGND VGND VPWR VPWR _3333_ sky130_fd_sc_hd__and2_1
X_5701_ u_pe_array.g_pe_row\[1\].g_pe_col\[1\].u_pe.act_val\[0\] u_pe_array.g_pe_row\[1\].g_pe_col\[1\].u_pe.w_out\[0\]
+ u_pe_array.g_pe_row\[1\].g_pe_col\[1\].u_pe.psum_out\[0\] VGND VGND VPWR VPWR _2512_
+ sky130_fd_sc_hd__a21o_1
X_3962_ _0939_ VGND VGND VPWR VPWR _1175_ sky130_fd_sc_hd__clkbuf_8
X_6681_ _3269_ _3270_ VGND VGND VPWR VPWR _3271_ sky130_fd_sc_hd__or2_1
XFILLER_0_85_484 VGND VGND VPWR VPWR sky130_fd_sc_hd__decap_4
XFILLER_0_73_646 VGND VGND VPWR VPWR sky130_fd_sc_hd__fill_1
X_3893_ u_pe_array.g_pe_row\[3\].g_pe_col\[2\].u_pe.act_val\[5\] VGND VGND VPWR VPWR
+ _1133_ sky130_fd_sc_hd__inv_2
XFILLER_0_72_134 VGND VGND VPWR VPWR sky130_fd_sc_hd__decap_6
XFILLER_0_5_401 VGND VGND VPWR VPWR sky130_fd_sc_hd__decap_3
X_5632_ _2469_ _2473_ VGND VGND VPWR VPWR _2474_ sky130_fd_sc_hd__nand2_1
XFILLER_0_115_225 VPWR VGND VPWR VGND sky130_ef_sc_hd__decap_12
X_5563_ _2282_ u_pe_array.g_pe_row\[1\].g_pe_col\[2\].u_pe.psum_out\[4\] _1597_ VGND
+ VGND VPWR VPWR _2411_ sky130_fd_sc_hd__and3_1
X_7302_ clknet_leaf_107_clk _0208_ net944 VGND VGND VPWR VPWR u_pe_array.act_from_right\[10\]\[1\]
+ sky130_fd_sc_hd__dfrtp_1
XFILLER_0_41_521 VGND VGND VPWR VPWR sky130_fd_sc_hd__decap_6
X_4514_ _0938_ VGND VGND VPWR VPWR _1605_ sky130_fd_sc_hd__clkbuf_8
Xhold102 _0657_ VGND VGND VPWR VPWR net176 sky130_fd_sc_hd__dlygate4sd3_1
Xhold135 _0544_ VGND VGND VPWR VPWR net209 sky130_fd_sc_hd__dlygate4sd3_1
Xhold113 u_pe_array.act_from_right\[5\]\[11\] VGND VGND VPWR VPWR net187 sky130_fd_sc_hd__dlygate4sd3_1
Xhold124 u_pe_array.act_from_up\[12\]\[6\] VGND VGND VPWR VPWR net198 sky130_fd_sc_hd__dlygate4sd3_1
X_5494_ u_pe_array.act_from_up\[6\]\[2\] _2341_ VGND VGND VPWR VPWR _2357_ sky130_fd_sc_hd__or2_1
Xhold168 u_pe_array.act_from_right\[0\]\[2\] VGND VGND VPWR VPWR net242 sky130_fd_sc_hd__dlygate4sd3_1
XFILLER_0_110_83 VGND VGND VPWR VPWR sky130_fd_sc_hd__fill_1
Xhold157 _0708_ VGND VGND VPWR VPWR net231 sky130_fd_sc_hd__dlygate4sd3_1
Xhold146 u_pe_array.g_pe_row\[2\].g_pe_col\[0\].u_pe.move_reg\[7\] VGND VGND VPWR
+ VPWR net220 sky130_fd_sc_hd__dlygate4sd3_1
X_7233_ clknet_leaf_21_clk _0139_ net943 VGND VGND VPWR VPWR u_pe_array.g_pe_row\[3\].g_pe_col\[1\].u_pe.psum_out\[1\]
+ sky130_fd_sc_hd__dfrtp_1
X_4445_ _1538_ _1540_ VGND VGND VPWR VPWR _1549_ sky130_fd_sc_hd__nor2_1
XFILLER_0_41_587 VGND VGND VPWR VPWR sky130_fd_sc_hd__fill_2
Xhold179 u_pe_array.act_from_down\[1\]\[4\] VGND VGND VPWR VPWR net253 sky130_fd_sc_hd__dlygate4sd3_1
XFILLER_0_111_497 VGND VGND VPWR VPWR sky130_fd_sc_hd__fill_1
X_4376_ _1033_ _1484_ _1486_ _1356_ net554 VGND VGND VPWR VPWR _0192_ sky130_fd_sc_hd__a32o_1
XFILLER_0_1_673 VPWR VGND VPWR VGND sky130_ef_sc_hd__decap_12
X_7164_ clknet_leaf_11_clk _0070_ net945 VGND VGND VPWR VPWR u_pe_array.act_from_right\[13\]\[12\]
+ sky130_fd_sc_hd__dfrtp_1
X_6115_ net238 _2499_ _2847_ _2851_ VGND VGND VPWR VPWR _0566_ sky130_fd_sc_hd__a22o_1
XTAP_440 VGND VPWR sky130_fd_sc_hd__tapvpwrvgnd_1
XTAP_451 VGND VPWR sky130_fd_sc_hd__tapvpwrvgnd_1
XTAP_462 VGND VPWR sky130_fd_sc_hd__tapvpwrvgnd_1
XTAP_473 VGND VPWR sky130_fd_sc_hd__tapvpwrvgnd_1
XTAP_484 VGND VPWR sky130_fd_sc_hd__tapvpwrvgnd_1
X_7095_ clknet_leaf_83_clk _0001_ net948 VGND VGND VPWR VPWR u_fsm.cnt\[1\] sky130_fd_sc_hd__dfrtp_1
XTAP_495 VGND VPWR sky130_fd_sc_hd__tapvpwrvgnd_1
X_6046_ _2784_ _2786_ VGND VGND VPWR VPWR _2796_ sky130_fd_sc_hd__nor2_1
XTAP_1606 VGND VPWR sky130_fd_sc_hd__tapvpwrvgnd_1
XFILLER_0_68_418 VGND VGND VPWR VPWR sky130_fd_sc_hd__fill_2
XTAP_1639 VGND VPWR sky130_fd_sc_hd__tapvpwrvgnd_1
XTAP_1628 VGND VPWR sky130_fd_sc_hd__tapvpwrvgnd_1
XTAP_1617 VGND VPWR sky130_fd_sc_hd__tapvpwrvgnd_1
X_6948_ u_pe_array.u_fifo1.wr_ptr\[0\] u_pe_array.u_fifo1.wr_ptr\[1\] _3349_ VGND
+ VGND VPWR VPWR _3459_ sky130_fd_sc_hd__and3_1
X_6879_ _3419_ VGND VGND VPWR VPWR _0762_ sky130_fd_sc_hd__clkbuf_1
XFILLER_0_48_197 VGND VGND VPWR VPWR sky130_fd_sc_hd__fill_2
XFILLER_0_63_167 VGND VGND VPWR VPWR sky130_fd_sc_hd__fill_1
XFILLER_0_32_554 VGND VGND VPWR VPWR sky130_fd_sc_hd__fill_2
XFILLER_0_102_475 VGND VGND VPWR VPWR sky130_fd_sc_hd__fill_1
Xhold680 u_pe_array.g_pe_row\[1\].g_pe_col\[3\].u_pe.psum_out\[6\] VGND VGND VPWR
+ VPWR net754 sky130_fd_sc_hd__dlygate4sd3_1
XFILLER_0_5_3 VPWR VGND VPWR VGND sky130_ef_sc_hd__decap_12
Xhold691 u_pe_array.u_fifo1.buffer\[1\]\[0\] VGND VGND VPWR VPWR net765 sky130_fd_sc_hd__dlygate4sd3_1
XFILLER_0_55_613 VGND VGND VPWR VPWR sky130_fd_sc_hd__decap_3
XFILLER_0_27_326 VGND VGND VPWR VPWR sky130_fd_sc_hd__fill_2
XFILLER_0_55_668 VGND VGND VPWR VPWR sky130_fd_sc_hd__decap_4
XFILLER_0_6_209 VPWR VGND VPWR VGND sky130_ef_sc_hd__decap_12
Xload_slew3 net943 VGND VGND VPWR VPWR net942 sky130_fd_sc_hd__buf_12
XFILLER_0_70_627 VGND VGND VPWR VPWR sky130_fd_sc_hd__fill_2
XFILLER_0_23_554 VGND VGND VPWR VPWR sky130_fd_sc_hd__fill_1
XFILLER_0_23_576 VGND VGND VPWR VPWR sky130_fd_sc_hd__fill_1
XFILLER_0_49_45 VGND VGND VPWR VPWR sky130_fd_sc_hd__fill_1
X_4230_ _1362_ _1363_ _1374_ _1384_ VGND VGND VPWR VPWR _1387_ sky130_fd_sc_hd__or4_1
X_4161_ _1323_ u_pe_array.g_pe_row\[3\].g_pe_col\[1\].u_pe.psum_out\[1\] _1106_ VGND
+ VGND VPWR VPWR _1324_ sky130_fd_sc_hd__o21a_1
X_4092_ _1284_ u_pe_array.g_pe_row\[3\].g_pe_col\[0\].u_pe.w_out\[0\] _0931_ VGND
+ VGND VPWR VPWR _1285_ sky130_fd_sc_hd__mux2_1
XFILLER_0_65_44 VGND VGND VPWR VPWR sky130_fd_sc_hd__fill_1
X_7920_ clknet_leaf_76_clk _0825_ VGND VGND VPWR VPWR u_pe_array.u_fifo1.buffer\[3\]\[4\]
+ sky130_fd_sc_hd__dfxtp_1
X_7851_ clknet_leaf_100_clk _0756_ VGND VGND VPWR VPWR u_pe_array.u_fifo2.buffer\[2\]\[3\]
+ sky130_fd_sc_hd__dfxtp_1
XFILLER_0_77_237 VGND VGND VPWR VPWR sky130_fd_sc_hd__decap_6
X_6802_ _2322_ _3371_ VGND VGND VPWR VPWR _3372_ sky130_fd_sc_hd__nand2_1
X_4994_ u_pe_array.g_pe_row\[2\].g_pe_col\[1\].u_pe.psum_out\[9\] _1105_ VGND VGND
+ VPWR VPWR _1973_ sky130_fd_sc_hd__nand2_1
X_7782_ clknet_leaf_75_clk _0688_ net13 VGND VGND VPWR VPWR u_pe_array.act_from_up\[4\]\[4\]
+ sky130_fd_sc_hd__dfrtp_1
X_6733_ u_pe_array.g_pe_row\[0\].g_pe_col\[0\].u_pe.psum_out\[8\] _2488_ VGND VGND
+ VPWR VPWR _3318_ sky130_fd_sc_hd__or2_1
X_3945_ _0983_ _1150_ _1166_ net139 VGND VGND VPWR VPWR _0081_ sky130_fd_sc_hd__a22o_1
X_6664_ u_pe_array.g_pe_row\[0\].g_pe_col\[0\].u_pe.psum_out\[1\] _2488_ VGND VGND
+ VPWR VPWR _3255_ sky130_fd_sc_hd__nand2_1
XFILLER_0_73_443 VGND VGND VPWR VPWR sky130_fd_sc_hd__decap_4
XFILLER_0_73_476 VGND VGND VPWR VPWR sky130_fd_sc_hd__fill_1
X_3876_ u_pe_array.g_pe_row\[3\].g_pe_col\[2\].u_pe.psum_out\[1\] _1108_ _1110_ _1119_
+ VGND VGND VPWR VPWR _1120_ sky130_fd_sc_hd__o211a_1
XFILLER_0_45_167 VGND VGND VPWR VPWR sky130_fd_sc_hd__fill_1
X_5615_ _2443_ _2457_ _2458_ VGND VGND VPWR VPWR _2459_ sky130_fd_sc_hd__a21o_1
X_6595_ u_pe_array.g_pe_row\[0\].g_pe_col\[1\].u_pe.psum_out\[11\] _2268_ VGND VGND
+ VPWR VPWR _3218_ sky130_fd_sc_hd__and2b_1
XFILLER_0_83_3 VPWR VGND VPWR VGND sky130_ef_sc_hd__decap_12
XFILLER_0_60_137 VGND VGND VPWR VPWR sky130_fd_sc_hd__decap_3
XFILLER_0_14_510 VGND VGND VPWR VPWR sky130_fd_sc_hd__decap_3
XFILLER_0_26_392 VGND VGND VPWR VPWR sky130_fd_sc_hd__fill_2
X_5546_ u_pe_array.g_pe_row\[1\].g_pe_col\[2\].u_pe.act_val\[1\] u_pe_array.g_pe_row\[1\].g_pe_col\[2\].u_pe.psum_out\[2\]
+ _1597_ VGND VGND VPWR VPWR _2395_ sky130_fd_sc_hd__and3b_1
X_5477_ u_pe_array.act_from_up\[6\]\[0\] _2341_ VGND VGND VPWR VPWR _2342_ sky130_fd_sc_hd__or2_1
X_7216_ clknet_leaf_35_clk _0122_ net942 VGND VGND VPWR VPWR u_pe_array.act_from_down\[9\]\[10\]
+ sky130_fd_sc_hd__dfrtp_1
X_4428_ _1522_ _1525_ _1533_ VGND VGND VPWR VPWR _1534_ sky130_fd_sc_hd__or3_1
X_7147_ clknet_leaf_23_clk _0053_ net943 VGND VGND VPWR VPWR u_pe_array.g_pe_row\[3\].g_pe_col\[3\].u_pe.psum_out\[10\]
+ sky130_fd_sc_hd__dfrtp_2
X_4359_ net18 u_pe_array.act_from_up\[12\]\[3\] _0857_ VGND VGND VPWR VPWR _1480_
+ sky130_fd_sc_hd__mux2_1
XTAP_270 VGND VPWR sky130_fd_sc_hd__tapvpwrvgnd_1
XTAP_281 VGND VPWR sky130_fd_sc_hd__tapvpwrvgnd_1
XTAP_292 VGND VPWR sky130_fd_sc_hd__tapvpwrvgnd_1
X_7078_ u_pe_array.u_fifo1.wr_ptr\[0\] u_pe_array.u_fifo1.wr_ptr\[1\] _3513_ VGND
+ VGND VPWR VPWR _3536_ sky130_fd_sc_hd__and3_2
X_6029_ _2768_ _2771_ _2779_ VGND VGND VPWR VPWR _2781_ sky130_fd_sc_hd__o21ai_1
XTAP_1403 VGND VPWR sky130_fd_sc_hd__tapvpwrvgnd_1
XTAP_1414 VGND VPWR sky130_fd_sc_hd__tapvpwrvgnd_1
XTAP_1447 VGND VPWR sky130_fd_sc_hd__tapvpwrvgnd_1
XTAP_1436 VGND VPWR sky130_fd_sc_hd__tapvpwrvgnd_1
XTAP_1425 VGND VPWR sky130_fd_sc_hd__tapvpwrvgnd_1
XTAP_1469 VGND VPWR sky130_fd_sc_hd__tapvpwrvgnd_1
XTAP_1458 VGND VPWR sky130_fd_sc_hd__tapvpwrvgnd_1
Xfanout74 net13 VGND VGND VPWR VPWR net74 sky130_fd_sc_hd__clkbuf_16
XFILLER_0_64_421 VGND VGND VPWR VPWR sky130_fd_sc_hd__fill_2
XFILLER_0_107_556 VGND VGND VPWR VPWR sky130_fd_sc_hd__fill_1
XFILLER_0_52_638 VGND VGND VPWR VPWR sky130_fd_sc_hd__decap_6
XFILLER_0_24_329 VGND VGND VPWR VPWR sky130_fd_sc_hd__decap_6
XFILLER_0_60_682 VGND VGND VPWR VPWR sky130_fd_sc_hd__fill_1
XFILLER_0_20_568 VGND VGND VPWR VPWR sky130_fd_sc_hd__fill_2
XFILLER_0_19_15 VPWR VGND VPWR VGND sky130_ef_sc_hd__decap_12
XFILLER_0_35_25 VGND VGND VPWR VPWR sky130_fd_sc_hd__fill_1
X_3730_ u_pe_array.g_pe_row\[3\].g_pe_col\[3\].u_pe.act_val\[0\] _0988_ VGND VGND
+ VPWR VPWR _0989_ sky130_fd_sc_hd__nand2_1
XFILLER_0_28_668 VPWR VGND VPWR VGND sky130_ef_sc_hd__decap_12
XFILLER_0_82_262 VGND VGND VPWR VPWR sky130_fd_sc_hd__decap_4
XFILLER_0_55_476 VGND VGND VPWR VPWR sky130_fd_sc_hd__fill_2
X_3661_ _0946_ VGND VGND VPWR VPWR _0947_ sky130_fd_sc_hd__clkbuf_16
XFILLER_0_27_189 VGND VGND VPWR VPWR sky130_fd_sc_hd__fill_1
XFILLER_0_113_526 VPWR VGND VPWR VGND sky130_ef_sc_hd__decap_12
X_6380_ _3044_ _3045_ _3047_ VGND VGND VPWR VPWR _3049_ sky130_fd_sc_hd__a21o_1
X_5400_ u_pe_array.g_pe_row\[1\].g_pe_col\[2\].u_pe.psum_out\[4\] _1108_ _1110_ _2286_
+ VGND VGND VPWR VPWR _2287_ sky130_fd_sc_hd__o211a_1
X_3592_ _0864_ _0865_ VGND VGND VPWR VPWR net35 sky130_fd_sc_hd__nor2_2
X_5331_ u_pe_array.g_pe_row\[1\].g_pe_col\[3\].u_pe.psum_out\[7\] _2228_ _2229_ VGND
+ VGND VPWR VPWR _2230_ sky130_fd_sc_hd__mux2_1
XFILLER_0_2_245 VGND VGND VPWR VPWR sky130_fd_sc_hd__decap_6
XFILLER_0_23_373 VGND VGND VPWR VPWR sky130_fd_sc_hd__decap_3
XFILLER_0_23_384 VGND VGND VPWR VPWR sky130_fd_sc_hd__decap_8
X_5262_ u_pe_array.g_pe_row\[1\].g_pe_col\[3\].u_pe.act_val\[1\] _1423_ _2165_ VGND
+ VGND VPWR VPWR _2167_ sky130_fd_sc_hd__nand3_1
X_7001_ _3493_ VGND VGND VPWR VPWR _0810_ sky130_fd_sc_hd__clkbuf_1
X_5193_ net759 _1904_ _2127_ _1726_ VGND VGND VPWR VPWR _0368_ sky130_fd_sc_hd__a22o_1
X_4213_ _1368_ _1369_ _1371_ VGND VGND VPWR VPWR _1372_ sky130_fd_sc_hd__and3_1
X_4144_ net179 _1310_ _1175_ u_pe_array.g_pe_row\[3\].g_pe_col\[1\].u_pe.move_reg\[11\]
+ VGND VGND VPWR VPWR _0136_ sky130_fd_sc_hd__a22o_1
XFILLER_0_92_53 VPWR VGND VPWR VGND sky130_ef_sc_hd__decap_12
X_4075_ _1266_ _1270_ VGND VGND VPWR VPWR _1271_ sky130_fd_sc_hd__nand2_1
X_7903_ clknet_leaf_72_clk _0808_ VGND VGND VPWR VPWR u_pe_array.u_fifo1.buffer\[0\]\[5\]
+ sky130_fd_sc_hd__dfxtp_1
X_7834_ clknet_leaf_85_clk _0739_ net948 VGND VGND VPWR VPWR u_pe_array.u_fifo2.count\[2\]
+ sky130_fd_sc_hd__dfrtp_4
Xclkbuf_leaf_90_clk clknet_3_4__leaf_clk VGND VGND VPWR VPWR clknet_leaf_90_clk sky130_fd_sc_hd__clkbuf_16
X_7765_ clknet_leaf_53_clk _0671_ net74 VGND VGND VPWR VPWR u_pe_array.g_pe_row\[0\].g_pe_col\[1\].u_pe.psum_out\[2\]
+ sky130_fd_sc_hd__dfrtp_1
X_4977_ _1953_ _1957_ VGND VGND VPWR VPWR _1958_ sky130_fd_sc_hd__or2_1
XFILLER_0_108_309 VPWR VGND VPWR VGND sky130_ef_sc_hd__decap_12
X_6716_ _3275_ _3282_ _3291_ _3302_ _3290_ VGND VGND VPWR VPWR _3303_ sky130_fd_sc_hd__o32a_2
XFILLER_0_58_292 VGND VGND VPWR VPWR sky130_fd_sc_hd__decap_8
XFILLER_0_58_281 VGND VGND VPWR VPWR sky130_fd_sc_hd__decap_8
XFILLER_0_18_134 VGND VGND VPWR VPWR sky130_fd_sc_hd__decap_6
XFILLER_0_46_421 VGND VGND VPWR VPWR sky130_fd_sc_hd__fill_1
X_3928_ _1114_ net811 _1159_ VGND VGND VPWR VPWR _1160_ sky130_fd_sc_hd__mux2_1
X_7696_ clknet_leaf_75_clk _0602_ net949 VGND VGND VPWR VPWR u_pe_array.act_from_up\[6\]\[0\]
+ sky130_fd_sc_hd__dfrtp_1
X_3859_ u_pe_array.g_pe_row\[2\].g_pe_col\[1\].u_pe.w_out\[1\] VGND VGND VPWR VPWR
+ _1105_ sky130_fd_sc_hd__clkbuf_8
X_6647_ net117 _0866_ _0940_ u_pe_array.g_pe_row\[0\].g_pe_col\[0\].u_pe.move_reg\[10\]
+ VGND VGND VPWR VPWR _0707_ sky130_fd_sc_hd__a22o_1
XFILLER_0_6_562 VPWR VGND VPWR VGND sky130_ef_sc_hd__decap_12
XFILLER_0_18_189 VGND VGND VPWR VPWR sky130_fd_sc_hd__fill_1
XFILLER_0_104_526 VGND VGND VPWR VPWR sky130_fd_sc_hd__decap_6
X_6578_ u_pe_array.g_pe_row\[0\].g_pe_col\[1\].u_pe.psum_out\[9\] _2268_ VGND VGND
+ VPWR VPWR _3203_ sky130_fd_sc_hd__nand2_1
XFILLER_0_14_340 VGND VGND VPWR VPWR sky130_fd_sc_hd__decap_3
X_5529_ _2233_ _2379_ _2380_ _2173_ net550 VGND VGND VPWR VPWR _0451_ sky130_fd_sc_hd__a32o_1
XFILLER_0_42_682 VGND VGND VPWR VPWR sky130_fd_sc_hd__decap_3
XFILLER_0_41_192 VGND VGND VPWR VPWR sky130_fd_sc_hd__decap_3
XFILLER_0_96_365 VGND VGND VPWR VPWR sky130_fd_sc_hd__decap_3
XTAP_1222 VGND VPWR sky130_fd_sc_hd__tapvpwrvgnd_1
XTAP_1211 VGND VPWR sky130_fd_sc_hd__tapvpwrvgnd_1
XTAP_1200 VGND VPWR sky130_fd_sc_hd__tapvpwrvgnd_1
XFILLER_0_69_557 VGND VGND VPWR VPWR sky130_fd_sc_hd__decap_3
XTAP_1266 VGND VPWR sky130_fd_sc_hd__tapvpwrvgnd_1
XTAP_1244 VGND VPWR sky130_fd_sc_hd__tapvpwrvgnd_1
XTAP_1255 VGND VPWR sky130_fd_sc_hd__tapvpwrvgnd_1
XTAP_1233 VGND VPWR sky130_fd_sc_hd__tapvpwrvgnd_1
XFILLER_0_56_229 VGND VGND VPWR VPWR sky130_fd_sc_hd__decap_8
Xclkbuf_leaf_81_clk clknet_3_5__leaf_clk VGND VGND VPWR VPWR clknet_leaf_81_clk sky130_fd_sc_hd__clkbuf_16
XTAP_1299 VGND VPWR sky130_fd_sc_hd__tapvpwrvgnd_1
XTAP_1288 VGND VPWR sky130_fd_sc_hd__tapvpwrvgnd_1
XTAP_1277 VGND VPWR sky130_fd_sc_hd__tapvpwrvgnd_1
XFILLER_0_77_590 VGND VGND VPWR VPWR sky130_fd_sc_hd__fill_1
XFILLER_0_112_29 VPWR VGND VPWR VGND sky130_ef_sc_hd__decap_12
XFILLER_0_112_18 VGND VGND VPWR VPWR sky130_fd_sc_hd__decap_8
XFILLER_0_37_498 VGND VGND VPWR VPWR sky130_fd_sc_hd__decap_6
XFILLER_0_52_446 VGND VGND VPWR VPWR sky130_fd_sc_hd__decap_4
XFILLER_0_33_671 VGND VGND VPWR VPWR sky130_fd_sc_hd__fill_1
XFILLER_0_103_581 VGND VGND VPWR VPWR sky130_fd_sc_hd__fill_2
XFILLER_0_20_365 VPWR VGND VPWR VGND sky130_ef_sc_hd__decap_12
XFILLER_0_20_398 VGND VGND VPWR VPWR sky130_fd_sc_hd__fill_1
XFILLER_0_1_15 VPWR VGND VPWR VGND sky130_ef_sc_hd__decap_12
X_4900_ _1884_ _1885_ _1887_ _1803_ net500 VGND VGND VPWR VPWR _0315_ sky130_fd_sc_hd__a32o_1
XFILLER_0_62_45 VPWR VGND VPWR VGND sky130_ef_sc_hd__decap_12
X_5880_ net869 _2664_ _2273_ VGND VGND VPWR VPWR _2665_ sky130_fd_sc_hd__mux2_1
X_4831_ u_pe_array.g_pe_row\[2\].g_pe_col\[2\].u_pe.psum_out\[10\] _1839_ VGND VGND
+ VPWR VPWR _1850_ sky130_fd_sc_hd__nor2_1
Xclkbuf_leaf_72_clk clknet_3_5__leaf_clk VGND VGND VPWR VPWR clknet_leaf_72_clk sky130_fd_sc_hd__clkbuf_16
XFILLER_0_47_218 VGND VGND VPWR VPWR sky130_fd_sc_hd__decap_6
XFILLER_0_118_629 VPWR VGND VPWR VGND sky130_ef_sc_hd__decap_12
XFILLER_0_7_304 VPWR VGND VPWR VGND sky130_ef_sc_hd__decap_12
XFILLER_0_28_410 VGND VGND VPWR VPWR sky130_fd_sc_hd__decap_4
XFILLER_0_28_421 VGND VGND VPWR VPWR sky130_fd_sc_hd__fill_2
X_4762_ u_pe_array.g_pe_row\[2\].g_pe_col\[2\].u_pe.psum_out\[4\] _1786_ VGND VGND
+ VPWR VPWR _1787_ sky130_fd_sc_hd__xnor2_1
XFILLER_0_7_337 VGND VGND VPWR VPWR sky130_fd_sc_hd__decap_6
X_7550_ clknet_leaf_95_clk _0456_ net951 VGND VGND VPWR VPWR u_pe_array.g_pe_row\[1\].g_pe_col\[2\].u_pe.psum_out\[5\]
+ sky130_fd_sc_hd__dfrtp_1
X_6501_ _3126_ _3132_ VGND VGND VPWR VPWR _3133_ sky130_fd_sc_hd__nor2_1
X_3713_ net818 _0939_ VGND VGND VPWR VPWR _0975_ sky130_fd_sc_hd__and2_1
X_7481_ clknet_leaf_39_clk net802 net947 VGND VGND VPWR VPWR u_pe_array.g_pe_row\[1\].g_pe_col\[3\].u_pe.act_val\[3\]
+ sky130_fd_sc_hd__dfrtp_2
XFILLER_0_55_273 VGND VGND VPWR VPWR sky130_fd_sc_hd__decap_6
X_4693_ u_pe_array.g_pe_row\[2\].g_pe_col\[2\].u_pe.psum_out\[6\] u_pe_array.g_pe_row\[2\].g_pe_col\[2\].u_pe.move_reg\[6\]
+ _1599_ VGND VGND VPWR VPWR _1742_ sky130_fd_sc_hd__mux2_1
X_3644_ u_pe_array.g_pe_row\[2\].g_pe_col\[2\].u_pe.w_out\[0\] u_pe_array.g_pe_row\[3\].g_pe_col\[2\].u_pe.w_out\[0\]
+ _0931_ VGND VGND VPWR VPWR _0932_ sky130_fd_sc_hd__mux2_1
X_6432_ u_pe_array.g_pe_row\[0\].g_pe_col\[2\].u_pe.psum_out\[9\] u_pe_array.g_pe_row\[0\].g_pe_col\[2\].u_pe.psum_out\[10\]
+ _2130_ VGND VGND VPWR VPWR _3095_ sky130_fd_sc_hd__o21a_1
X_3575_ _0853_ _0852_ _0881_ VGND VGND VPWR VPWR _0882_ sky130_fd_sc_hd__or3_1
X_6363_ u_pe_array.g_pe_row\[0\].g_pe_col\[2\].u_pe.act_val\[4\] _2128_ _3024_ VGND
+ VGND VPWR VPWR _3033_ sky130_fd_sc_hd__and3_1
XFILLER_0_87_64 VGND VGND VPWR VPWR sky130_fd_sc_hd__fill_2
X_5314_ _1884_ _2213_ _2214_ _2173_ net521 VGND VGND VPWR VPWR _0402_ sky130_fd_sc_hd__a32o_1
X_6294_ net104 _1731_ _2009_ _2984_ VGND VGND VPWR VPWR _0612_ sky130_fd_sc_hd__a22o_1
X_5245_ net483 _0939_ VGND VGND VPWR VPWR _2156_ sky130_fd_sc_hd__and2_1
XFILLER_0_11_387 VGND VGND VPWR VPWR sky130_fd_sc_hd__decap_4
Xhold17 u_pe_array.act_from_down\[9\]\[5\] VGND VGND VPWR VPWR net91 sky130_fd_sc_hd__dlygate4sd3_1
Xhold28 u_pe_array.act_from_up\[14\]\[6\] VGND VGND VPWR VPWR net102 sky130_fd_sc_hd__dlygate4sd3_1
X_5176_ u_pe_array.g_pe_row\[2\].g_pe_col\[0\].u_pe.psum_out\[10\] _1286_ VGND VGND
+ VPWR VPWR _2113_ sky130_fd_sc_hd__or2_1
Xhold39 u_pe_array.act_from_left\[15\]\[6\] VGND VGND VPWR VPWR net113 sky130_fd_sc_hd__dlygate4sd3_1
X_4127_ u_pe_array.act_from_right\[13\]\[1\] net828 _0963_ VGND VGND VPWR VPWR _1304_
+ sky130_fd_sc_hd__mux2_1
X_4058_ _1240_ _1254_ _1255_ VGND VGND VPWR VPWR _1256_ sky130_fd_sc_hd__a21o_1
XFILLER_0_78_365 VGND VGND VPWR VPWR sky130_fd_sc_hd__fill_1
Xclkbuf_leaf_63_clk clknet_3_7__leaf_clk VGND VGND VPWR VPWR clknet_leaf_63_clk sky130_fd_sc_hd__clkbuf_16
XFILLER_0_93_335 VGND VGND VPWR VPWR sky130_fd_sc_hd__fill_1
X_7817_ clknet_leaf_64_clk _0722_ net74 VGND VGND VPWR VPWR u_pe_array.g_pe_row\[0\].g_pe_col\[0\].u_pe.psum_out\[12\]
+ sky130_fd_sc_hd__dfrtp_1
XFILLER_0_19_410 VGND VGND VPWR VPWR sky130_fd_sc_hd__decap_4
XFILLER_0_108_128 VPWR VGND VPWR VGND sky130_ef_sc_hd__decap_12
X_7748_ clknet_leaf_43_clk _0654_ net946 VGND VGND VPWR VPWR u_pe_array.act_from_right\[0\]\[11\]
+ sky130_fd_sc_hd__dfrtp_1
X_7679_ clknet_leaf_64_clk net184 net74 VGND VGND VPWR VPWR u_pe_array.g_pe_row\[0\].g_pe_col\[3\].u_pe.move_reg\[11\]
+ sky130_fd_sc_hd__dfrtp_1
XFILLER_0_117_673 VPWR VGND VPWR VGND sky130_ef_sc_hd__decap_12
XFILLER_0_116_161 VGND VGND VPWR VPWR sky130_fd_sc_hd__fill_1
XFILLER_0_116_183 VPWR VGND VPWR VGND sky130_ef_sc_hd__decap_12
XFILLER_0_100_562 VGND VGND VPWR VPWR sky130_fd_sc_hd__decap_6
XFILLER_0_16_27 VGND VGND VPWR VPWR sky130_fd_sc_hd__fill_1
Xclkbuf_leaf_54_clk clknet_3_7__leaf_clk VGND VGND VPWR VPWR clknet_leaf_54_clk sky130_fd_sc_hd__clkbuf_16
XFILLER_0_84_313 VPWR VGND VPWR VGND sky130_ef_sc_hd__decap_12
XTAP_1030 VGND VPWR sky130_fd_sc_hd__tapvpwrvgnd_1
XFILLER_0_57_505 VGND VGND VPWR VPWR sky130_fd_sc_hd__decap_4
XTAP_1074 VGND VPWR sky130_fd_sc_hd__tapvpwrvgnd_1
XTAP_1063 VGND VPWR sky130_fd_sc_hd__tapvpwrvgnd_1
XTAP_1052 VGND VPWR sky130_fd_sc_hd__tapvpwrvgnd_1
XTAP_1041 VGND VPWR sky130_fd_sc_hd__tapvpwrvgnd_1
XFILLER_0_32_26 VGND VGND VPWR VPWR sky130_fd_sc_hd__fill_2
XTAP_1085 VGND VPWR sky130_fd_sc_hd__tapvpwrvgnd_1
XTAP_1096 VGND VPWR sky130_fd_sc_hd__tapvpwrvgnd_1
XFILLER_0_114_109 VPWR VGND VPWR VGND sky130_ef_sc_hd__decap_12
XFILLER_0_25_446 VGND VGND VPWR VPWR sky130_fd_sc_hd__fill_2
XFILLER_0_25_468 VGND VGND VPWR VPWR sky130_fd_sc_hd__decap_3
Xhold509 u_pe_array.g_pe_row\[0\].g_pe_col\[0\].u_pe.psum_out\[12\] VGND VGND VPWR
+ VPWR net583 sky130_fd_sc_hd__dlygate4sd3_1
XFILLER_0_12_118 VGND VGND VPWR VPWR sky130_fd_sc_hd__fill_1
XFILLER_0_110_337 VGND VGND VPWR VPWR sky130_fd_sc_hd__decap_6
XTAP_803 VGND VPWR sky130_fd_sc_hd__tapvpwrvgnd_1
XTAP_814 VGND VPWR sky130_fd_sc_hd__tapvpwrvgnd_1
XTAP_825 VGND VPWR sky130_fd_sc_hd__tapvpwrvgnd_1
X_5030_ u_pe_array.g_pe_row\[2\].g_pe_col\[0\].u_pe.psum_out\[1\] u_pe_array.g_pe_row\[2\].g_pe_col\[0\].u_pe.act_val\[1\]
+ _1867_ VGND VGND VPWR VPWR _2002_ sky130_fd_sc_hd__mux2_1
XFILLER_0_20_195 VGND VGND VPWR VPWR sky130_fd_sc_hd__fill_1
XTAP_847 VGND VPWR sky130_fd_sc_hd__tapvpwrvgnd_1
XTAP_836 VGND VPWR sky130_fd_sc_hd__tapvpwrvgnd_1
XTAP_858 VGND VPWR sky130_fd_sc_hd__tapvpwrvgnd_1
XTAP_869 VGND VPWR sky130_fd_sc_hd__tapvpwrvgnd_1
XFILLER_0_73_22 VPWR VGND VPWR VGND sky130_ef_sc_hd__decap_12
XFILLER_0_79_118 VGND VGND VPWR VPWR sky130_fd_sc_hd__decap_8
X_6981_ _3480_ _3481_ _3471_ VGND VGND VPWR VPWR _3482_ sky130_fd_sc_hd__a21oi_1
XFILLER_0_73_66 VGND VGND VPWR VPWR sky130_fd_sc_hd__decap_6
X_5932_ u_pe_array.act_from_up\[4\]\[1\] _2341_ VGND VGND VPWR VPWR _2701_ sky130_fd_sc_hd__or2_1
Xclkbuf_leaf_45_clk clknet_3_6__leaf_clk VGND VGND VPWR VPWR clknet_leaf_45_clk sky130_fd_sc_hd__clkbuf_16
XFILLER_0_87_162 VGND VGND VPWR VPWR sky130_fd_sc_hd__decap_6
XFILLER_0_48_527 VGND VGND VPWR VPWR sky130_fd_sc_hd__decap_4
X_5863_ u_pe_array.g_pe_row\[1\].g_pe_col\[0\].u_pe.psum_out\[7\] _1112_ _1109_ _2651_
+ VGND VGND VPWR VPWR _2652_ sky130_fd_sc_hd__o211a_1
XFILLER_0_48_549 VGND VGND VPWR VPWR sky130_fd_sc_hd__decap_6
X_5794_ _2589_ _2591_ _2596_ VGND VGND VPWR VPWR _2597_ sky130_fd_sc_hd__or3_1
XFILLER_0_90_305 VGND VGND VPWR VPWR sky130_fd_sc_hd__decap_3
X_7602_ clknet_leaf_74_clk _0508_ net72 VGND VGND VPWR VPWR net40 sky130_fd_sc_hd__dfrtp_1
X_4814_ _1820_ _1833_ _1834_ VGND VGND VPWR VPWR _1835_ sky130_fd_sc_hd__a21oi_1
XFILLER_0_28_251 VGND VGND VPWR VPWR sky130_fd_sc_hd__fill_1
X_4745_ _1761_ _1767_ _1770_ VGND VGND VPWR VPWR _1771_ sky130_fd_sc_hd__a21o_1
XFILLER_0_8_657 VGND VGND VPWR VPWR sky130_fd_sc_hd__fill_2
X_7533_ clknet_leaf_88_clk net895 net948 VGND VGND VPWR VPWR u_pe_array.g_pe_row\[1\].g_pe_col\[2\].u_pe.act_val\[1\]
+ sky130_fd_sc_hd__dfrtp_2
XFILLER_0_114_621 VPWR VGND VPWR VGND sky130_ef_sc_hd__decap_12
XFILLER_0_98_41 VPWR VGND VPWR VGND sky130_ef_sc_hd__decap_12
X_7464_ clknet_leaf_95_clk _0370_ net951 VGND VGND VPWR VPWR u_pe_array.g_pe_row\[1\].g_pe_col\[2\].u_pe.w_out\[1\]
+ sky130_fd_sc_hd__dfrtp_1
X_4676_ _1730_ VGND VGND VPWR VPWR _1731_ sky130_fd_sc_hd__clkbuf_8
XFILLER_0_98_85 VPWR VGND VPWR VGND sky130_ef_sc_hd__decap_12
X_7395_ clknet_leaf_36_clk net455 net942 VGND VGND VPWR VPWR u_pe_array.act_from_right\[8\]\[12\]
+ sky130_fd_sc_hd__dfrtp_1
X_6415_ _2795_ _3079_ _3080_ _1005_ net912 VGND VGND VPWR VPWR _0637_ sky130_fd_sc_hd__a32o_1
X_3627_ u_pe_array.act_from_up\[14\]\[1\] _0869_ _0854_ VGND VGND VPWR VPWR _0920_
+ sky130_fd_sc_hd__and3_2
XFILLER_0_31_449 VGND VGND VPWR VPWR sky130_fd_sc_hd__decap_3
X_3558_ _0865_ VGND VGND VPWR VPWR _0866_ sky130_fd_sc_hd__inv_8
X_6346_ _3013_ _3015_ _3017_ VGND VGND VPWR VPWR _3018_ sky130_fd_sc_hd__o21ai_1
X_6277_ u_pe_array.g_pe_row\[0\].g_pe_col\[2\].u_pe.psum_out\[2\] u_pe_array.g_pe_row\[0\].g_pe_col\[2\].u_pe.act_val\[2\]
+ _2844_ VGND VGND VPWR VPWR _2976_ sky130_fd_sc_hd__mux2_1
X_5228_ net147 _2143_ _2132_ _2147_ VGND VGND VPWR VPWR _0383_ sky130_fd_sc_hd__a22o_1
X_5159_ u_pe_array.g_pe_row\[2\].g_pe_col\[0\].u_pe.psum_out\[8\] _1286_ VGND VGND
+ VPWR VPWR _2098_ sky130_fd_sc_hd__or2_1
Xclkbuf_leaf_36_clk clknet_3_3__leaf_clk VGND VGND VPWR VPWR clknet_leaf_36_clk sky130_fd_sc_hd__clkbuf_16
XFILLER_0_79_685 VGND VGND VPWR VPWR sky130_fd_sc_hd__fill_1
XFILLER_0_39_505 VGND VGND VPWR VPWR sky130_fd_sc_hd__decap_3
XFILLER_0_66_324 VGND VGND VPWR VPWR sky130_fd_sc_hd__decap_4
XPHY_124 VGND VGND VPWR VPWR sky130_fd_sc_hd__decap_3
XPHY_113 VGND VGND VPWR VPWR sky130_fd_sc_hd__decap_3
XPHY_102 VGND VGND VPWR VPWR sky130_fd_sc_hd__decap_3
XFILLER_0_93_143 VGND VGND VPWR VPWR sky130_fd_sc_hd__decap_6
XPHY_157 VGND VGND VPWR VPWR sky130_fd_sc_hd__decap_3
XPHY_146 VGND VGND VPWR VPWR sky130_fd_sc_hd__decap_3
XPHY_135 VGND VGND VPWR VPWR sky130_fd_sc_hd__decap_3
XFILLER_0_94_699 VGND VGND VPWR VPWR sky130_fd_sc_hd__fill_1
XPHY_179 VGND VGND VPWR VPWR sky130_fd_sc_hd__decap_3
XPHY_168 VGND VGND VPWR VPWR sky130_fd_sc_hd__decap_3
XFILLER_0_19_273 VGND VGND VPWR VPWR sky130_fd_sc_hd__fill_1
XFILLER_0_105_665 VGND VGND VPWR VPWR sky130_fd_sc_hd__decap_6
XFILLER_0_104_153 VPWR VGND VPWR VGND sky130_ef_sc_hd__decap_12
XFILLER_0_22_449 VPWR VGND VPWR VGND sky130_ef_sc_hd__decap_12
XFILLER_0_30_493 VGND VGND VPWR VPWR sky130_fd_sc_hd__decap_8
XFILLER_0_100_392 VGND VGND VPWR VPWR sky130_fd_sc_hd__decap_8
XFILLER_0_89_449 VGND VGND VPWR VPWR sky130_fd_sc_hd__fill_1
Xclkbuf_leaf_27_clk clknet_3_2__leaf_clk VGND VGND VPWR VPWR clknet_leaf_27_clk sky130_fd_sc_hd__clkbuf_16
XFILLER_0_97_471 VGND VGND VPWR VPWR sky130_fd_sc_hd__decap_3
XPHY_4 VGND VGND VPWR VPWR sky130_fd_sc_hd__decap_3
XFILLER_0_45_508 VGND VGND VPWR VPWR sky130_fd_sc_hd__decap_3
XFILLER_0_5_627 VPWR VGND VPWR VGND sky130_ef_sc_hd__decap_12
XFILLER_0_25_221 VGND VGND VPWR VPWR sky130_fd_sc_hd__decap_3
XFILLER_0_104_3 VPWR VGND VPWR VGND sky130_ef_sc_hd__decap_12
XFILLER_0_25_265 VGND VGND VPWR VPWR sky130_fd_sc_hd__decap_8
X_4530_ u_pe_array.g_pe_row\[2\].g_pe_col\[3\].u_pe.psum_out\[12\] net397 _1599_ VGND
+ VGND VPWR VPWR _1614_ sky130_fd_sc_hd__mux2_1
Xhold306 u_pe_array.act_from_right\[0\]\[7\] VGND VGND VPWR VPWR net380 sky130_fd_sc_hd__dlygate4sd3_1
XFILLER_0_40_213 VGND VGND VPWR VPWR sky130_fd_sc_hd__fill_1
Xhold317 u_pe_array.act_from_right\[10\]\[8\] VGND VGND VPWR VPWR net391 sky130_fd_sc_hd__dlygate4sd3_1
X_4461_ _1562_ _1563_ VGND VGND VPWR VPWR _1564_ sky130_fd_sc_hd__nand2_1
X_6200_ _2898_ _2901_ _2909_ VGND VGND VPWR VPWR _2911_ sky130_fd_sc_hd__o21ai_1
Xhold328 _0300_ VGND VGND VPWR VPWR net402 sky130_fd_sc_hd__dlygate4sd3_1
XFILLER_0_68_33 VGND VGND VPWR VPWR sky130_fd_sc_hd__fill_1
X_7180_ clknet_leaf_102_clk _0086_ net944 VGND VGND VPWR VPWR u_pe_array.g_pe_row\[3\].g_pe_col\[2\].u_pe.act_val\[2\]
+ sky130_fd_sc_hd__dfrtp_1
XFILLER_0_7_69 VPWR VGND VPWR VGND sky130_ef_sc_hd__decap_12
Xhold339 _1744_ VGND VGND VPWR VPWR net413 sky130_fd_sc_hd__dlygate4sd3_1
XFILLER_0_40_257 VGND VGND VPWR VPWR sky130_fd_sc_hd__fill_1
X_6131_ u_pe_array.g_pe_row\[0\].g_pe_col\[3\].u_pe.act_val\[0\] _2853_ _2847_ net154
+ VGND VGND VPWR VPWR _0574_ sky130_fd_sc_hd__a22o_1
XFILLER_0_68_55 VGND VGND VPWR VPWR sky130_fd_sc_hd__fill_2
X_4392_ _1496_ _1500_ VGND VGND VPWR VPWR _1501_ sky130_fd_sc_hd__xor2_1
XFILLER_0_0_354 VGND VGND VPWR VPWR sky130_fd_sc_hd__fill_1
XFILLER_0_21_460 VGND VGND VPWR VPWR sky130_fd_sc_hd__decap_8
XTAP_600 VGND VPWR sky130_fd_sc_hd__tapvpwrvgnd_1
XFILLER_0_0_365 VPWR VGND VPWR VGND sky130_ef_sc_hd__decap_12
XTAP_611 VGND VPWR sky130_fd_sc_hd__tapvpwrvgnd_1
XTAP_622 VGND VPWR sky130_fd_sc_hd__tapvpwrvgnd_1
XTAP_633 VGND VPWR sky130_fd_sc_hd__tapvpwrvgnd_1
XTAP_644 VGND VPWR sky130_fd_sc_hd__tapvpwrvgnd_1
XTAP_655 VGND VPWR sky130_fd_sc_hd__tapvpwrvgnd_1
XTAP_677 VGND VPWR sky130_fd_sc_hd__tapvpwrvgnd_1
XTAP_666 VGND VPWR sky130_fd_sc_hd__tapvpwrvgnd_1
X_6062_ _2809_ _2810_ VGND VGND VPWR VPWR _2811_ sky130_fd_sc_hd__nand2_1
X_5013_ _1988_ _1989_ VGND VGND VPWR VPWR _1990_ sky130_fd_sc_hd__or2_1
XTAP_688 VGND VPWR sky130_fd_sc_hd__tapvpwrvgnd_1
XTAP_699 VGND VPWR sky130_fd_sc_hd__tapvpwrvgnd_1
XFILLER_0_108_83 VGND VGND VPWR VPWR sky130_fd_sc_hd__fill_1
XFILLER_0_17_70 VPWR VGND VPWR VGND sky130_ef_sc_hd__decap_12
XFILLER_0_76_611 VGND VGND VPWR VPWR sky130_fd_sc_hd__decap_4
Xclkbuf_leaf_18_clk clknet_3_2__leaf_clk VGND VGND VPWR VPWR clknet_leaf_18_clk sky130_fd_sc_hd__clkbuf_16
X_6964_ _3468_ _3469_ VGND VGND VPWR VPWR _0797_ sky130_fd_sc_hd__nor2_1
X_5915_ u_pe_array.u_fifo1.rd_ptr\[1\] u_pe_array.u_fifo1.rd_ptr\[0\] _2682_ VGND
+ VGND VPWR VPWR _2685_ sky130_fd_sc_hd__and3_2
X_6895_ _3428_ VGND VGND VPWR VPWR _0769_ sky130_fd_sc_hd__clkbuf_1
X_5846_ u_pe_array.g_pe_row\[1\].g_pe_col\[0\].u_pe.psum_out\[3\] _1108_ _1110_ _2638_
+ VGND VGND VPWR VPWR _2639_ sky130_fd_sc_hd__o211a_2
XFILLER_0_118_245 VGND VGND VPWR VPWR sky130_fd_sc_hd__decap_3
XFILLER_0_91_614 VGND VGND VPWR VPWR sky130_fd_sc_hd__fill_2
XFILLER_0_8_443 VGND VGND VPWR VPWR sky130_fd_sc_hd__fill_1
X_5777_ u_pe_array.g_pe_row\[1\].g_pe_col\[1\].u_pe.psum_out\[7\] _1728_ VGND VGND
+ VPWR VPWR _2581_ sky130_fd_sc_hd__or2_1
X_7516_ clknet_leaf_68_clk _0422_ net72 VGND VGND VPWR VPWR u_pe_array.act_from_right\[5\]\[10\]
+ sky130_fd_sc_hd__dfrtp_1
X_4728_ _1754_ _1755_ VGND VGND VPWR VPWR _1756_ sky130_fd_sc_hd__xor2_1
X_7447_ clknet_leaf_34_clk net196 net951 VGND VGND VPWR VPWR u_pe_array.g_pe_row\[2\].g_pe_col\[0\].u_pe.move_reg\[10\]
+ sky130_fd_sc_hd__dfrtp_1
X_4659_ _1427_ u_pe_array.g_pe_row\[2\].g_pe_col\[3\].u_pe.psum_out\[11\] VGND VGND
+ VPWR VPWR _1718_ sky130_fd_sc_hd__and2b_1
XFILLER_0_3_181 VPWR VGND VPWR VGND sky130_ef_sc_hd__decap_12
Xhold862 u_pe_array.g_pe_row\[2\].g_pe_col\[1\].u_pe.psum_out\[7\] VGND VGND VPWR
+ VPWR net936 sky130_fd_sc_hd__dlygate4sd3_1
XFILLER_0_102_657 VPWR VGND VPWR VGND sky130_ef_sc_hd__decap_12
Xhold851 u_pe_array.g_pe_row\[1\].g_pe_col\[3\].u_pe.act_val\[5\] VGND VGND VPWR VPWR
+ net925 sky130_fd_sc_hd__dlygate4sd3_1
XFILLER_0_12_460 VPWR VGND VPWR VGND sky130_ef_sc_hd__decap_12
Xhold840 u_pe_array.g_pe_row\[3\].g_pe_col\[2\].u_pe.psum_out\[8\] VGND VGND VPWR
+ VPWR net914 sky130_fd_sc_hd__dlygate4sd3_1
X_7378_ clknet_leaf_0_clk _0284_ net944 VGND VGND VPWR VPWR u_pe_array.g_pe_row\[2\].g_pe_col\[2\].u_pe.psum_out\[10\]
+ sky130_fd_sc_hd__dfrtp_2
X_6329_ _2999_ _3001_ VGND VGND VPWR VPWR _3002_ sky130_fd_sc_hd__xnor2_1
XFILLER_0_86_419 VGND VGND VPWR VPWR sky130_fd_sc_hd__fill_1
XFILLER_0_39_335 VGND VGND VPWR VPWR sky130_fd_sc_hd__fill_1
XFILLER_0_13_39 VPWR VGND VPWR VGND sky130_ef_sc_hd__decap_12
XFILLER_0_82_625 VGND VGND VPWR VPWR sky130_fd_sc_hd__decap_4
XFILLER_0_81_113 VGND VGND VPWR VPWR sky130_fd_sc_hd__fill_1
XFILLER_0_54_316 VPWR VGND VPWR VGND sky130_ef_sc_hd__decap_12
XFILLER_0_54_305 VGND VGND VPWR VPWR sky130_fd_sc_hd__decap_3
XFILLER_0_82_658 VGND VGND VPWR VPWR sky130_fd_sc_hd__decap_3
XFILLER_0_47_390 VGND VGND VPWR VPWR sky130_fd_sc_hd__fill_2
XFILLER_0_62_360 VGND VGND VPWR VPWR sky130_fd_sc_hd__decap_4
XFILLER_0_105_495 VGND VGND VPWR VPWR sky130_fd_sc_hd__fill_1
XFILLER_0_50_566 VGND VGND VPWR VPWR sky130_fd_sc_hd__fill_2
XFILLER_0_38_58 VGND VGND VPWR VPWR sky130_fd_sc_hd__fill_1
X_3961_ net739 _1167_ _1169_ _1174_ VGND VGND VPWR VPWR _0089_ sky130_fd_sc_hd__a22o_1
X_5700_ net240 _2016_ _2511_ u_pe_array.g_pe_row\[1\].g_pe_col\[1\].u_pe.move_reg\[12\]
+ VGND VGND VPWR VPWR _0491_ sky130_fd_sc_hd__a22o_1
X_6680_ _3257_ net940 _3267_ _3268_ VGND VGND VPWR VPWR _3270_ sky130_fd_sc_hd__o211a_1
XFILLER_0_57_165 VGND VGND VPWR VPWR sky130_fd_sc_hd__decap_3
X_3892_ _1132_ VGND VGND VPWR VPWR _0062_ sky130_fd_sc_hd__clkbuf_1
X_5631_ u_pe_array.g_pe_row\[1\].g_pe_col\[2\].u_pe.psum_out\[10\] _2472_ _2462_ VGND
+ VGND VPWR VPWR _2473_ sky130_fd_sc_hd__mux2_1
XFILLER_0_115_237 VPWR VGND VPWR VGND sky130_ef_sc_hd__decap_12
X_5562_ _2282_ _1597_ u_pe_array.g_pe_row\[1\].g_pe_col\[2\].u_pe.psum_out\[4\] VGND
+ VGND VPWR VPWR _2410_ sky130_fd_sc_hd__a21oi_1
XFILLER_0_53_360 VGND VGND VPWR VPWR sky130_fd_sc_hd__decap_8
X_7301_ clknet_leaf_0_clk _0207_ net944 VGND VGND VPWR VPWR u_pe_array.act_from_right\[10\]\[0\]
+ sky130_fd_sc_hd__dfrtp_1
X_4513_ net250 _1301_ _1305_ _1604_ VGND VGND VPWR VPWR _0211_ sky130_fd_sc_hd__a22o_1
X_7232_ clknet_leaf_23_clk _0138_ net942 VGND VGND VPWR VPWR u_pe_array.g_pe_row\[3\].g_pe_col\[1\].u_pe.psum_out\[0\]
+ sky130_fd_sc_hd__dfrtp_1
Xhold114 _0490_ VGND VGND VPWR VPWR net188 sky130_fd_sc_hd__dlygate4sd3_1
Xhold125 _0185_ VGND VGND VPWR VPWR net199 sky130_fd_sc_hd__dlygate4sd3_1
X_5493_ u_pe_array.u_fifo2.buffer\[8\]\[2\] _2322_ _2351_ _2355_ _0857_ VGND VGND
+ VPWR VPWR _2356_ sky130_fd_sc_hd__a221o_1
Xhold103 u_pe_array.act_from_right\[10\]\[1\] VGND VGND VPWR VPWR net177 sky130_fd_sc_hd__dlygate4sd3_1
Xhold136 u_pe_array.g_pe_row\[0\].g_pe_col\[0\].u_pe.move_reg\[6\] VGND VGND VPWR
+ VPWR net210 sky130_fd_sc_hd__dlygate4sd3_1
Xhold147 _0350_ VGND VGND VPWR VPWR net221 sky130_fd_sc_hd__dlygate4sd3_1
Xhold158 u_pe_array.g_pe_row\[2\].g_pe_col\[0\].u_pe.move_reg\[9\] VGND VGND VPWR
+ VPWR net232 sky130_fd_sc_hd__dlygate4sd3_1
X_4444_ _1487_ _1547_ _1548_ _1356_ net555 VGND VGND VPWR VPWR _0198_ sky130_fd_sc_hd__a32o_1
XFILLER_0_13_279 VGND VGND VPWR VPWR sky130_fd_sc_hd__fill_1
XFILLER_0_1_641 VPWR VGND VPWR VGND sky130_ef_sc_hd__decap_12
Xclkbuf_leaf_7_clk clknet_3_0__leaf_clk VGND VGND VPWR VPWR clknet_leaf_7_clk sky130_fd_sc_hd__clkbuf_16
Xhold169 _0699_ VGND VGND VPWR VPWR net243 sky130_fd_sc_hd__dlygate4sd3_1
X_4375_ _1485_ VGND VGND VPWR VPWR _1486_ sky130_fd_sc_hd__inv_2
XFILLER_0_1_685 VPWR VGND VPWR VGND sky130_ef_sc_hd__decap_12
X_7163_ clknet_leaf_9_clk _0069_ net945 VGND VGND VPWR VPWR u_pe_array.act_from_right\[13\]\[11\]
+ sky130_fd_sc_hd__dfrtp_1
X_6114_ u_pe_array.g_pe_row\[0\].g_pe_col\[3\].u_pe.psum_out\[5\] u_pe_array.g_pe_row\[0\].g_pe_col\[3\].u_pe.act_val\[5\]
+ _2844_ VGND VGND VPWR VPWR _2851_ sky130_fd_sc_hd__mux2_1
XTAP_430 VGND VPWR sky130_fd_sc_hd__tapvpwrvgnd_1
XFILLER_0_0_195 VGND VGND VPWR VPWR sky130_fd_sc_hd__fill_1
XTAP_441 VGND VPWR sky130_fd_sc_hd__tapvpwrvgnd_1
X_7094_ clknet_leaf_89_clk _0000_ net948 VGND VGND VPWR VPWR u_fsm.cnt\[0\] sky130_fd_sc_hd__dfrtp_1
X_6045_ _0977_ VGND VGND VPWR VPWR _2795_ sky130_fd_sc_hd__buf_8
XTAP_452 VGND VPWR sky130_fd_sc_hd__tapvpwrvgnd_1
XTAP_463 VGND VPWR sky130_fd_sc_hd__tapvpwrvgnd_1
XTAP_474 VGND VPWR sky130_fd_sc_hd__tapvpwrvgnd_1
XTAP_485 VGND VPWR sky130_fd_sc_hd__tapvpwrvgnd_1
XTAP_496 VGND VPWR sky130_fd_sc_hd__tapvpwrvgnd_1
XTAP_1629 VGND VPWR sky130_fd_sc_hd__tapvpwrvgnd_1
XTAP_1618 VGND VPWR sky130_fd_sc_hd__tapvpwrvgnd_1
XTAP_1607 VGND VPWR sky130_fd_sc_hd__tapvpwrvgnd_1
XFILLER_0_95_216 VGND VGND VPWR VPWR sky130_fd_sc_hd__fill_1
XFILLER_0_48_110 VPWR VGND VPWR VGND sky130_ef_sc_hd__decap_12
X_6947_ net931 VGND VGND VPWR VPWR _3458_ sky130_fd_sc_hd__inv_2
XFILLER_0_64_625 VGND VGND VPWR VPWR sky130_fd_sc_hd__decap_6
X_6878_ net654 _0924_ _3415_ VGND VGND VPWR VPWR _3419_ sky130_fd_sc_hd__mux2_1
XFILLER_0_48_176 VGND VGND VPWR VPWR sky130_fd_sc_hd__decap_6
X_5829_ _2626_ VGND VGND VPWR VPWR _0505_ sky130_fd_sc_hd__clkbuf_1
XFILLER_0_8_251 VGND VGND VPWR VPWR sky130_fd_sc_hd__fill_1
XFILLER_0_72_680 VGND VGND VPWR VPWR sky130_fd_sc_hd__decap_3
XFILLER_0_17_596 VGND VGND VPWR VPWR sky130_fd_sc_hd__fill_2
XFILLER_0_32_533 VGND VGND VPWR VPWR sky130_fd_sc_hd__decap_4
Xhold681 u_pe_array.g_pe_row\[2\].g_pe_col\[0\].u_pe.psum_out\[10\] VGND VGND VPWR
+ VPWR net755 sky130_fd_sc_hd__dlygate4sd3_1
Xhold670 u_pe_array.g_pe_row\[1\].g_pe_col\[3\].u_pe.psum_out\[11\] VGND VGND VPWR
+ VPWR net744 sky130_fd_sc_hd__dlygate4sd3_1
Xhold692 u_pe_array.act_from_right\[13\]\[5\] VGND VGND VPWR VPWR net766 sky130_fd_sc_hd__dlygate4sd3_1
XFILLER_0_86_205 VGND VGND VPWR VPWR sky130_fd_sc_hd__decap_4
XFILLER_0_99_599 VGND VGND VPWR VPWR sky130_fd_sc_hd__fill_2
XFILLER_0_86_249 VGND VGND VPWR VPWR sky130_fd_sc_hd__decap_3
XFILLER_0_79_290 VGND VGND VPWR VPWR sky130_fd_sc_hd__fill_2
XFILLER_0_67_441 VGND VGND VPWR VPWR sky130_fd_sc_hd__fill_1
XFILLER_0_39_121 VGND VGND VPWR VPWR sky130_fd_sc_hd__fill_1
XFILLER_0_27_316 VGND VGND VPWR VPWR sky130_fd_sc_hd__decap_8
XFILLER_0_40_15 VPWR VGND VPWR VGND sky130_ef_sc_hd__decap_12
Xload_slew4 net70 VGND VGND VPWR VPWR net943 sky130_fd_sc_hd__buf_12
XFILLER_0_63_680 VGND VGND VPWR VPWR sky130_fd_sc_hd__fill_1
XFILLER_0_50_363 VGND VGND VPWR VPWR sky130_fd_sc_hd__fill_1
XFILLER_0_50_374 VGND VGND VPWR VPWR sky130_fd_sc_hd__fill_2
XFILLER_0_50_385 VGND VGND VPWR VPWR sky130_fd_sc_hd__fill_2
XFILLER_0_50_396 VPWR VGND VPWR VGND sky130_ef_sc_hd__decap_12
X_4160_ u_pe_array.g_pe_row\[3\].g_pe_col\[1\].u_pe.act_val\[0\] VGND VGND VPWR VPWR
+ _1323_ sky130_fd_sc_hd__inv_2
XFILLER_0_4_26 VGND VGND VPWR VPWR sky130_fd_sc_hd__fill_2
X_4091_ u_pe_array.g_pe_row\[2\].g_pe_col\[0\].u_pe.w_out\[0\] VGND VGND VPWR VPWR
+ _1284_ sky130_fd_sc_hd__clkbuf_4
X_7850_ clknet_leaf_101_clk _0755_ VGND VGND VPWR VPWR u_pe_array.u_fifo2.buffer\[2\]\[2\]
+ sky130_fd_sc_hd__dfxtp_1
X_6801_ u_pe_array.u_fifo2.count\[1\] u_pe_array.u_fifo2.count\[2\] u_pe_array.u_fifo2.count\[0\]
+ u_pe_array.u_fifo2.count\[3\] _2341_ VGND VGND VPWR VPWR _3371_ sky130_fd_sc_hd__o41a_2
X_4993_ u_pe_array.g_pe_row\[2\].g_pe_col\[1\].u_pe.psum_out\[8\] _1904_ _1970_ _1972_
+ VGND VGND VPWR VPWR _0323_ sky130_fd_sc_hd__a22o_1
X_7781_ clknet_leaf_75_clk _0687_ net13 VGND VGND VPWR VPWR u_pe_array.act_from_up\[4\]\[3\]
+ sky130_fd_sc_hd__dfrtp_1
X_6732_ u_pe_array.g_pe_row\[0\].g_pe_col\[0\].u_pe.psum_out\[8\] _2488_ VGND VGND
+ VPWR VPWR _3317_ sky130_fd_sc_hd__nand2_1
XFILLER_0_58_485 VGND VGND VPWR VPWR sky130_fd_sc_hd__decap_4
X_3944_ _0983_ _1147_ _1166_ net135 VGND VGND VPWR VPWR _0080_ sky130_fd_sc_hd__a22o_1
X_6663_ _1092_ _3251_ _3254_ _1005_ net698 VGND VGND VPWR VPWR _0711_ sky130_fd_sc_hd__a32o_1
X_3875_ u_pe_array.g_pe_row\[3\].g_pe_col\[2\].u_pe.act_val\[1\] _1118_ VGND VGND
+ VPWR VPWR _1119_ sky130_fd_sc_hd__or2_1
XFILLER_0_45_146 VGND VGND VPWR VPWR sky130_fd_sc_hd__fill_1
X_5614_ u_pe_array.g_pe_row\[1\].g_pe_col\[2\].u_pe.psum_out\[8\] _2443_ VGND VGND
+ VPWR VPWR _2458_ sky130_fd_sc_hd__nor2_1
XFILLER_0_116_579 VGND VGND VPWR VPWR sky130_fd_sc_hd__fill_2
X_6594_ _3216_ _3217_ u_pe_array.g_pe_row\[0\].g_pe_col\[1\].u_pe.psum_out\[10\] _1007_
+ VGND VGND VPWR VPWR _0679_ sky130_fd_sc_hd__a2bb2o_1
XFILLER_0_60_116 VGND VGND VPWR VPWR sky130_fd_sc_hd__fill_1
XFILLER_0_5_254 VGND VGND VPWR VPWR sky130_fd_sc_hd__decap_8
XFILLER_0_5_287 VGND VGND VPWR VPWR sky130_fd_sc_hd__fill_1
X_5545_ net844 _1904_ _2394_ _1726_ VGND VGND VPWR VPWR _0453_ sky130_fd_sc_hd__a22o_1
XFILLER_0_76_3 VGND VGND VPWR VPWR sky130_fd_sc_hd__decap_8
X_5476_ _2340_ VGND VGND VPWR VPWR _2341_ sky130_fd_sc_hd__buf_4
XFILLER_0_41_363 VPWR VGND VPWR VGND sky130_ef_sc_hd__decap_12
X_7215_ clknet_leaf_35_clk _0121_ net942 VGND VGND VPWR VPWR u_pe_array.act_from_down\[9\]\[9\]
+ sky130_fd_sc_hd__dfrtp_1
X_4427_ _1530_ _1532_ VGND VGND VPWR VPWR _1533_ sky130_fd_sc_hd__xor2_1
XFILLER_0_111_273 VGND VGND VPWR VPWR sky130_fd_sc_hd__decap_6
X_7146_ clknet_leaf_24_clk _0052_ net943 VGND VGND VPWR VPWR u_pe_array.g_pe_row\[3\].g_pe_col\[3\].u_pe.psum_out\[9\]
+ sky130_fd_sc_hd__dfrtp_1
XTAP_260 VGND VPWR sky130_fd_sc_hd__tapvpwrvgnd_1
X_4358_ net820 _1301_ _1305_ _1479_ VGND VGND VPWR VPWR _0181_ sky130_fd_sc_hd__a22o_1
X_4289_ u_pe_array.g_pe_row\[3\].g_pe_col\[0\].u_pe.psum_out\[2\] _1108_ _1110_ _1436_
+ VGND VGND VPWR VPWR _1437_ sky130_fd_sc_hd__o211a_1
XTAP_271 VGND VPWR sky130_fd_sc_hd__tapvpwrvgnd_1
XTAP_282 VGND VPWR sky130_fd_sc_hd__tapvpwrvgnd_1
XTAP_293 VGND VPWR sky130_fd_sc_hd__tapvpwrvgnd_1
X_7077_ _3535_ VGND VGND VPWR VPWR _0844_ sky130_fd_sc_hd__clkbuf_1
X_6028_ _2768_ _2771_ _2779_ VGND VGND VPWR VPWR _2780_ sky130_fd_sc_hd__or3_1
XTAP_1404 VGND VPWR sky130_fd_sc_hd__tapvpwrvgnd_1
XTAP_1415 VGND VPWR sky130_fd_sc_hd__tapvpwrvgnd_1
XTAP_1448 VGND VPWR sky130_fd_sc_hd__tapvpwrvgnd_1
XTAP_1437 VGND VPWR sky130_fd_sc_hd__tapvpwrvgnd_1
XTAP_1426 VGND VPWR sky130_fd_sc_hd__tapvpwrvgnd_1
XTAP_1459 VGND VPWR sky130_fd_sc_hd__tapvpwrvgnd_1
XFILLER_0_37_625 VGND VGND VPWR VPWR sky130_fd_sc_hd__fill_2
XFILLER_0_9_582 VGND VGND VPWR VPWR sky130_fd_sc_hd__fill_2
XFILLER_0_10_29 VPWR VGND VPWR VGND sky130_ef_sc_hd__decap_12
XFILLER_0_44_190 VGND VGND VPWR VPWR sky130_fd_sc_hd__fill_1
XFILLER_0_102_251 VGND VGND VPWR VPWR sky130_fd_sc_hd__fill_1
XFILLER_0_19_27 VPWR VGND VPWR VGND sky130_ef_sc_hd__decap_12
XFILLER_0_35_15 VGND VGND VPWR VPWR sky130_fd_sc_hd__decap_4
XFILLER_0_95_580 VGND VGND VPWR VPWR sky130_fd_sc_hd__decap_6
XFILLER_0_27_113 VPWR VGND VPWR VGND sky130_ef_sc_hd__decap_12
XFILLER_0_55_455 VGND VGND VPWR VPWR sky130_fd_sc_hd__fill_1
XFILLER_0_43_617 VGND VGND VPWR VPWR sky130_fd_sc_hd__decap_8
XFILLER_0_36_691 VGND VGND VPWR VPWR sky130_fd_sc_hd__decap_8
XFILLER_0_42_105 VGND VGND VPWR VPWR sky130_fd_sc_hd__decap_4
X_3660_ _0945_ VGND VGND VPWR VPWR _0946_ sky130_fd_sc_hd__buf_8
X_3591_ _0866_ VGND VGND VPWR VPWR u_fsm.psum_shift_en sky130_fd_sc_hd__buf_4
X_5330_ _2216_ VGND VGND VPWR VPWR _2229_ sky130_fd_sc_hd__inv_2
XFILLER_0_11_503 VGND VGND VPWR VPWR sky130_fd_sc_hd__fill_1
X_5261_ u_pe_array.g_pe_row\[1\].g_pe_col\[3\].u_pe.act_val\[1\] _1423_ _2165_ VGND
+ VGND VPWR VPWR _2166_ sky130_fd_sc_hd__a21o_1
XFILLER_0_62_9 VGND VGND VPWR VPWR sky130_fd_sc_hd__fill_2
XFILLER_0_76_11 VGND VGND VPWR VPWR sky130_fd_sc_hd__fill_2
X_4212_ u_pe_array.g_pe_row\[3\].g_pe_col\[1\].u_pe.act_val\[4\] _1370_ _1360_ _1358_
+ VGND VGND VPWR VPWR _1371_ sky130_fd_sc_hd__o22ai_2
X_7000_ net657 _3354_ _3491_ VGND VGND VPWR VPWR _3493_ sky130_fd_sc_hd__mux2_1
X_5192_ _2125_ _2126_ VGND VGND VPWR VPWR _2127_ sky130_fd_sc_hd__xnor2_1
XFILLER_0_76_66 VGND VGND VPWR VPWR sky130_fd_sc_hd__fill_1
X_4143_ net165 _1310_ _1175_ u_pe_array.g_pe_row\[3\].g_pe_col\[1\].u_pe.move_reg\[10\]
+ VGND VGND VPWR VPWR _0135_ sky130_fd_sc_hd__a22o_1
X_4074_ u_pe_array.g_pe_row\[3\].g_pe_col\[2\].u_pe.psum_out\[10\] _1269_ _1259_ VGND
+ VGND VPWR VPWR _1270_ sky130_fd_sc_hd__mux2_1
X_7902_ clknet_leaf_82_clk _0807_ VGND VGND VPWR VPWR u_pe_array.u_fifo1.buffer\[0\]\[4\]
+ sky130_fd_sc_hd__dfxtp_1
XFILLER_0_92_65 VPWR VGND VPWR VGND sky130_ef_sc_hd__decap_12
XFILLER_0_116_83 VGND VGND VPWR VPWR sky130_fd_sc_hd__fill_1
X_7833_ clknet_leaf_84_clk _0738_ net948 VGND VGND VPWR VPWR u_pe_array.u_fifo2.count\[1\]
+ sky130_fd_sc_hd__dfrtp_1
X_7764_ clknet_leaf_52_clk _0670_ net74 VGND VGND VPWR VPWR u_pe_array.g_pe_row\[0\].g_pe_col\[1\].u_pe.psum_out\[1\]
+ sky130_fd_sc_hd__dfrtp_1
X_4976_ _1956_ u_pe_array.g_pe_row\[2\].g_pe_col\[1\].u_pe.psum_out\[7\] _1939_ VGND
+ VGND VPWR VPWR _1957_ sky130_fd_sc_hd__mux2_1
X_6715_ _3292_ _3289_ VGND VGND VPWR VPWR _3302_ sky130_fd_sc_hd__nor2_1
X_7695_ clknet_leaf_30_clk _0601_ net71 VGND VGND VPWR VPWR u_pe_array.g_pe_row\[0\].g_pe_col\[1\].u_pe.w_out\[1\]
+ sky130_fd_sc_hd__dfrtp_1
XFILLER_0_116_321 VPWR VGND VPWR VGND sky130_ef_sc_hd__decap_12
X_3927_ _1158_ VGND VGND VPWR VPWR _1159_ sky130_fd_sc_hd__clkbuf_16
XFILLER_0_19_669 VGND VGND VPWR VPWR sky130_fd_sc_hd__decap_3
XFILLER_0_46_455 VGND VGND VPWR VPWR sky130_fd_sc_hd__decap_3
X_6646_ net137 _0866_ _0940_ u_pe_array.g_pe_row\[0\].g_pe_col\[0\].u_pe.move_reg\[9\]
+ VGND VGND VPWR VPWR _0706_ sky130_fd_sc_hd__a22o_1
X_3858_ _1104_ VGND VGND VPWR VPWR _0056_ sky130_fd_sc_hd__clkbuf_1
XFILLER_0_33_105 VGND VGND VPWR VPWR sky130_fd_sc_hd__decap_6
XFILLER_0_116_365 VGND VGND VPWR VPWR sky130_fd_sc_hd__fill_1
X_6577_ net843 _2586_ _3200_ _3202_ VGND VGND VPWR VPWR _0677_ sky130_fd_sc_hd__a22o_1
X_3789_ u_pe_array.g_pe_row\[3\].g_pe_col\[3\].u_pe.act_val\[5\] VGND VGND VPWR VPWR
+ _1043_ sky130_fd_sc_hd__inv_2
XFILLER_0_61_447 VGND VGND VPWR VPWR sky130_fd_sc_hd__fill_1
XFILLER_0_6_574 VGND VGND VPWR VPWR sky130_fd_sc_hd__decap_4
XFILLER_0_26_190 VGND VGND VPWR VPWR sky130_fd_sc_hd__decap_3
X_5528_ u_pe_array.g_pe_row\[1\].g_pe_col\[2\].u_pe.psum_out\[0\] u_pe_array.g_pe_row\[1\].g_pe_col\[2\].u_pe.act_val\[0\]
+ _1595_ VGND VGND VPWR VPWR _2380_ sky130_fd_sc_hd__nand3_1
X_5459_ _2322_ _2323_ VGND VGND VPWR VPWR _2324_ sky130_fd_sc_hd__or2_2
X_7129_ clknet_leaf_19_clk _0035_ net70 VGND VGND VPWR VPWR u_pe_array.g_pe_row\[3\].g_pe_col\[3\].u_pe.act_val\[5\]
+ sky130_fd_sc_hd__dfrtp_2
XFILLER_0_69_503 VGND VGND VPWR VPWR sky130_fd_sc_hd__fill_1
XTAP_1223 VGND VPWR sky130_fd_sc_hd__tapvpwrvgnd_1
XTAP_1212 VGND VPWR sky130_fd_sc_hd__tapvpwrvgnd_1
XTAP_1201 VGND VPWR sky130_fd_sc_hd__tapvpwrvgnd_1
XFILLER_0_69_569 VPWR VGND VPWR VGND sky130_ef_sc_hd__decap_12
XFILLER_0_96_388 VGND VGND VPWR VPWR sky130_fd_sc_hd__decap_8
XTAP_1245 VGND VPWR sky130_fd_sc_hd__tapvpwrvgnd_1
XTAP_1256 VGND VPWR sky130_fd_sc_hd__tapvpwrvgnd_1
XTAP_1234 VGND VPWR sky130_fd_sc_hd__tapvpwrvgnd_1
XTAP_1289 VGND VPWR sky130_fd_sc_hd__tapvpwrvgnd_1
XTAP_1278 VGND VPWR sky130_fd_sc_hd__tapvpwrvgnd_1
XTAP_1267 VGND VPWR sky130_fd_sc_hd__tapvpwrvgnd_1
XFILLER_0_49_271 VGND VGND VPWR VPWR sky130_fd_sc_hd__decap_8
XFILLER_0_107_321 VPWR VGND VPWR VGND sky130_ef_sc_hd__decap_12
XFILLER_0_92_572 VGND VGND VPWR VPWR sky130_fd_sc_hd__decap_6
XFILLER_0_32_182 VGND VGND VPWR VPWR sky130_fd_sc_hd__fill_1
XFILLER_0_20_377 VGND VGND VPWR VPWR sky130_fd_sc_hd__decap_4
XFILLER_0_1_27 VPWR VGND VPWR VGND sky130_ef_sc_hd__decap_12
X_4830_ _1847_ _1848_ VGND VGND VPWR VPWR _1849_ sky130_fd_sc_hd__nand2_1
X_4761_ _1784_ _1785_ VGND VGND VPWR VPWR _1786_ sky130_fd_sc_hd__xnor2_1
XFILLER_0_7_316 VGND VGND VPWR VPWR sky130_fd_sc_hd__fill_1
X_6500_ _3127_ _3131_ VGND VGND VPWR VPWR _3132_ sky130_fd_sc_hd__xor2_1
X_3712_ _0974_ VGND VGND VPWR VPWR _0040_ sky130_fd_sc_hd__clkbuf_1
X_7480_ clknet_leaf_67_clk net822 net946 VGND VGND VPWR VPWR u_pe_array.g_pe_row\[1\].g_pe_col\[3\].u_pe.act_val\[2\]
+ sky130_fd_sc_hd__dfrtp_2
X_4692_ net511 _1732_ _1735_ _1741_ VGND VGND VPWR VPWR _0253_ sky130_fd_sc_hd__a22o_1
XFILLER_0_28_477 VGND VGND VPWR VPWR sky130_fd_sc_hd__decap_4
XFILLER_0_43_414 VGND VGND VPWR VPWR sky130_fd_sc_hd__decap_8
XFILLER_0_102_41 VPWR VGND VPWR VGND sky130_ef_sc_hd__decap_12
X_3643_ _0930_ VGND VGND VPWR VPWR _0931_ sky130_fd_sc_hd__buf_12
XFILLER_0_43_469 VGND VGND VPWR VPWR sky130_fd_sc_hd__fill_1
X_6431_ net751 _2586_ _3094_ _0978_ VGND VGND VPWR VPWR _0639_ sky130_fd_sc_hd__a22o_1
XFILLER_0_102_85 VPWR VGND VPWR VGND sky130_ef_sc_hd__decap_12
XFILLER_0_11_83 VGND VGND VPWR VPWR sky130_fd_sc_hd__decap_4
X_6362_ _2795_ _3031_ _3032_ _2621_ net528 VGND VGND VPWR VPWR _0632_ sky130_fd_sc_hd__a32o_1
XFILLER_0_87_21 VPWR VGND VPWR VGND sky130_ef_sc_hd__decap_12
X_5313_ _2210_ _2212_ VGND VGND VPWR VPWR _2214_ sky130_fd_sc_hd__or2_1
X_3574_ u_fsm.state\[1\] u_fsm.state\[0\] VGND VGND VPWR VPWR _0881_ sky130_fd_sc_hd__nand2_1
X_6293_ u_pe_array.g_pe_row\[0\].g_pe_col\[2\].u_pe.psum_out\[10\] u_pe_array.g_pe_row\[0\].g_pe_col\[2\].u_pe.move_reg\[10\]
+ _2844_ VGND VGND VPWR VPWR _2984_ sky130_fd_sc_hd__mux2_1
X_5244_ _2155_ VGND VGND VPWR VPWR _0391_ sky130_fd_sc_hd__clkbuf_1
X_5175_ u_pe_array.g_pe_row\[2\].g_pe_col\[0\].u_pe.psum_out\[10\] _1286_ VGND VGND
+ VPWR VPWR _2112_ sky130_fd_sc_hd__nand2_1
Xhold18 _0307_ VGND VGND VPWR VPWR net92 sky130_fd_sc_hd__dlygate4sd3_1
Xhold29 _0090_ VGND VGND VPWR VPWR net103 sky130_fd_sc_hd__dlygate4sd3_1
XFILLER_0_39_3 VGND VGND VPWR VPWR sky130_fd_sc_hd__decap_6
X_4126_ u_pe_array.g_pe_row\[3\].g_pe_col\[1\].u_pe.act_val\[0\] _1301_ _1169_ _1303_
+ VGND VGND VPWR VPWR _0125_ sky130_fd_sc_hd__a22o_1
XFILLER_0_98_609 VPWR VGND VPWR VGND sky130_ef_sc_hd__decap_12
X_4057_ u_pe_array.g_pe_row\[3\].g_pe_col\[2\].u_pe.psum_out\[8\] _1240_ VGND VGND
+ VPWR VPWR _1255_ sky130_fd_sc_hd__nor2_1
XFILLER_0_93_303 VPWR VGND VPWR VGND sky130_ef_sc_hd__decap_12
X_7816_ clknet_leaf_56_clk _0721_ net74 VGND VGND VPWR VPWR u_pe_array.g_pe_row\[0\].g_pe_col\[0\].u_pe.psum_out\[11\]
+ sky130_fd_sc_hd__dfrtp_1
X_4959_ _1939_ _1940_ VGND VGND VPWR VPWR _1941_ sky130_fd_sc_hd__or2_1
X_7747_ clknet_leaf_50_clk _0653_ net946 VGND VGND VPWR VPWR u_pe_array.act_from_right\[0\]\[10\]
+ sky130_fd_sc_hd__dfrtp_1
XFILLER_0_62_701 VGND VGND VPWR VPWR sky130_fd_sc_hd__decap_4
X_7678_ clknet_leaf_63_clk net133 net74 VGND VGND VPWR VPWR u_pe_array.g_pe_row\[0\].g_pe_col\[3\].u_pe.move_reg\[10\]
+ sky130_fd_sc_hd__dfrtp_1
XFILLER_0_117_685 VPWR VGND VPWR VGND sky130_ef_sc_hd__decap_12
X_6629_ u_pe_array.g_pe_row\[0\].g_pe_col\[0\].u_pe.psum_out\[9\] u_pe_array.g_pe_row\[0\].g_pe_col\[0\].u_pe.move_reg\[9\]
+ _3102_ VGND VGND VPWR VPWR _3239_ sky130_fd_sc_hd__mux2_1
XFILLER_0_116_195 VGND VGND VPWR VPWR sky130_fd_sc_hd__fill_1
XFILLER_0_96_141 VGND VGND VPWR VPWR sky130_fd_sc_hd__decap_6
XTAP_1031 VGND VPWR sky130_fd_sc_hd__tapvpwrvgnd_1
XTAP_1020 VGND VPWR sky130_fd_sc_hd__tapvpwrvgnd_1
XFILLER_0_57_517 VGND VGND VPWR VPWR sky130_fd_sc_hd__decap_4
XFILLER_0_84_325 VPWR VGND VPWR VGND sky130_ef_sc_hd__decap_12
XTAP_1064 VGND VPWR sky130_fd_sc_hd__tapvpwrvgnd_1
XTAP_1053 VGND VPWR sky130_fd_sc_hd__tapvpwrvgnd_1
XTAP_1042 VGND VPWR sky130_fd_sc_hd__tapvpwrvgnd_1
XTAP_1086 VGND VPWR sky130_fd_sc_hd__tapvpwrvgnd_1
XTAP_1097 VGND VPWR sky130_fd_sc_hd__tapvpwrvgnd_1
XTAP_1075 VGND VPWR sky130_fd_sc_hd__tapvpwrvgnd_1
XFILLER_0_107_162 VGND VGND VPWR VPWR sky130_fd_sc_hd__fill_1
XFILLER_0_80_553 VGND VGND VPWR VPWR sky130_fd_sc_hd__decap_8
XFILLER_0_20_141 VPWR VGND VPWR VGND sky130_ef_sc_hd__decap_12
XFILLER_0_20_174 VGND VGND VPWR VPWR sky130_fd_sc_hd__fill_1
XTAP_804 VGND VPWR sky130_fd_sc_hd__tapvpwrvgnd_1
XTAP_815 VGND VPWR sky130_fd_sc_hd__tapvpwrvgnd_1
XTAP_826 VGND VPWR sky130_fd_sc_hd__tapvpwrvgnd_1
XTAP_848 VGND VPWR sky130_fd_sc_hd__tapvpwrvgnd_1
XTAP_837 VGND VPWR sky130_fd_sc_hd__tapvpwrvgnd_1
XTAP_859 VGND VPWR sky130_fd_sc_hd__tapvpwrvgnd_1
XFILLER_0_73_34 VGND VGND VPWR VPWR sky130_fd_sc_hd__decap_8
X_6980_ u_pe_array.u_fifo1.count\[3\] _3478_ VGND VGND VPWR VPWR _3481_ sky130_fd_sc_hd__or2_1
XFILLER_0_88_642 VGND VGND VPWR VPWR sky130_fd_sc_hd__fill_2
X_5931_ u_pe_array.u_fifo1.buffer\[8\]\[1\] _2676_ _2695_ _2699_ _0857_ VGND VGND
+ VPWR VPWR _2700_ sky130_fd_sc_hd__a221o_1
X_5862_ u_pe_array.g_pe_row\[1\].g_pe_col\[0\].u_pe.move_reg\[7\] net62 VGND VGND
+ VPWR VPWR _2651_ sky130_fd_sc_hd__or2_1
XFILLER_0_48_539 VGND VGND VPWR VPWR sky130_fd_sc_hd__decap_3
X_5793_ _2580_ _2594_ _2595_ VGND VGND VPWR VPWR _2596_ sky130_fd_sc_hd__a21oi_1
XFILLER_0_8_636 VGND VGND VPWR VPWR sky130_fd_sc_hd__decap_8
XFILLER_0_7_113 VPWR VGND VPWR VGND sky130_ef_sc_hd__decap_12
X_7601_ clknet_leaf_102_clk _0507_ net950 VGND VGND VPWR VPWR net36 sky130_fd_sc_hd__dfrtp_1
X_4813_ u_pe_array.g_pe_row\[2\].g_pe_col\[2\].u_pe.psum_out\[8\] _1820_ VGND VGND
+ VPWR VPWR _1834_ sky130_fd_sc_hd__nor2_1
XFILLER_0_28_230 VGND VGND VPWR VPWR sky130_fd_sc_hd__fill_1
XFILLER_0_118_449 VPWR VGND VPWR VGND sky130_ef_sc_hd__decap_12
XFILLER_0_113_51 VGND VGND VPWR VPWR sky130_fd_sc_hd__decap_4
XFILLER_0_7_157 VGND VGND VPWR VPWR sky130_fd_sc_hd__decap_3
X_4744_ _1762_ _1766_ VGND VGND VPWR VPWR _1770_ sky130_fd_sc_hd__nor2_1
X_7532_ clknet_leaf_91_clk net718 net948 VGND VGND VPWR VPWR u_pe_array.g_pe_row\[1\].g_pe_col\[2\].u_pe.act_val\[0\]
+ sky130_fd_sc_hd__dfrtp_2
XFILLER_0_44_701 VGND VGND VPWR VPWR sky130_fd_sc_hd__decap_4
XFILLER_0_28_296 VGND VGND VPWR VPWR sky130_fd_sc_hd__fill_2
XFILLER_0_43_233 VGND VGND VPWR VPWR sky130_fd_sc_hd__decap_8
XFILLER_0_114_633 VGND VGND VPWR VPWR sky130_fd_sc_hd__decap_8
XFILLER_0_98_53 VPWR VGND VPWR VGND sky130_ef_sc_hd__decap_12
X_7463_ clknet_leaf_88_clk _0369_ net948 VGND VGND VPWR VPWR u_pe_array.g_pe_row\[1\].g_pe_col\[2\].u_pe.w_out\[0\]
+ sky130_fd_sc_hd__dfrtp_1
X_4675_ _0857_ _0936_ _0941_ VGND VGND VPWR VPWR _1730_ sky130_fd_sc_hd__a21oi_1
X_7394_ clknet_leaf_36_clk net402 net942 VGND VGND VPWR VPWR u_pe_array.act_from_right\[8\]\[11\]
+ sky130_fd_sc_hd__dfrtp_1
X_3626_ _0919_ VGND VGND VPWR VPWR _0009_ sky130_fd_sc_hd__clkbuf_1
X_6414_ _3071_ _3073_ _3078_ VGND VGND VPWR VPWR _3080_ sky130_fd_sc_hd__or3_1
XFILLER_0_114_699 VGND VGND VPWR VPWR sky130_fd_sc_hd__fill_1
XFILLER_0_98_97 VPWR VGND VPWR VGND sky130_ef_sc_hd__decap_12
X_3557_ _0853_ _0862_ VGND VGND VPWR VPWR _0865_ sky130_fd_sc_hd__nand2_8
X_6345_ _3002_ _3003_ _3016_ VGND VGND VPWR VPWR _3017_ sky130_fd_sc_hd__o21a_1
X_6276_ net415 _2006_ _2009_ _2975_ VGND VGND VPWR VPWR _0603_ sky130_fd_sc_hd__a22o_1
X_5227_ u_pe_array.g_pe_row\[1\].g_pe_col\[3\].u_pe.psum_out\[12\] u_pe_array.g_pe_row\[1\].g_pe_col\[3\].u_pe.move_reg\[12\]
+ _2133_ VGND VGND VPWR VPWR _2147_ sky130_fd_sc_hd__mux2_1
X_5158_ u_pe_array.g_pe_row\[2\].g_pe_col\[0\].u_pe.psum_out\[8\] _1286_ VGND VGND
+ VPWR VPWR _2097_ sky130_fd_sc_hd__nand2_1
X_5089_ net799 _1904_ _2033_ _1726_ VGND VGND VPWR VPWR _0358_ sky130_fd_sc_hd__a22o_1
X_4109_ net91 _1167_ _1169_ _1294_ VGND VGND VPWR VPWR _0117_ sky130_fd_sc_hd__a22o_1
XFILLER_0_78_141 VGND VGND VPWR VPWR sky130_fd_sc_hd__decap_6
XFILLER_0_109_405 VGND VGND VPWR VPWR sky130_fd_sc_hd__decap_6
XFILLER_0_94_645 VGND VGND VPWR VPWR sky130_fd_sc_hd__fill_2
XFILLER_0_78_174 VPWR VGND VPWR VGND sky130_ef_sc_hd__decap_12
XFILLER_0_66_336 VPWR VGND VPWR VGND sky130_ef_sc_hd__decap_12
XPHY_125 VGND VGND VPWR VPWR sky130_fd_sc_hd__decap_3
XPHY_114 VGND VGND VPWR VPWR sky130_fd_sc_hd__decap_3
XPHY_103 VGND VGND VPWR VPWR sky130_fd_sc_hd__decap_3
XFILLER_0_94_667 VPWR VGND VPWR VGND sky130_ef_sc_hd__decap_12
XPHY_158 VGND VGND VPWR VPWR sky130_fd_sc_hd__decap_3
XPHY_147 VGND VGND VPWR VPWR sky130_fd_sc_hd__decap_3
XPHY_136 VGND VGND VPWR VPWR sky130_fd_sc_hd__decap_3
XFILLER_0_109_449 VGND VGND VPWR VPWR sky130_fd_sc_hd__decap_6
XFILLER_0_93_177 VGND VGND VPWR VPWR sky130_fd_sc_hd__decap_6
XPHY_169 VGND VGND VPWR VPWR sky130_fd_sc_hd__decap_3
XFILLER_0_47_561 VGND VGND VPWR VPWR sky130_fd_sc_hd__decap_4
XFILLER_0_105_611 VGND VGND VPWR VPWR sky130_fd_sc_hd__decap_4
XFILLER_0_118_29 VPWR VGND VPWR VGND sky130_ef_sc_hd__decap_12
XFILLER_0_84_122 VPWR VGND VPWR VGND sky130_ef_sc_hd__decap_12
XPHY_5 VGND VGND VPWR VPWR sky130_fd_sc_hd__decap_3
XFILLER_0_26_701 VGND VGND VPWR VPWR sky130_fd_sc_hd__decap_4
XFILLER_0_65_391 VGND VGND VPWR VPWR sky130_fd_sc_hd__fill_1
XFILLER_0_5_639 VPWR VGND VPWR VGND sky130_ef_sc_hd__decap_12
XFILLER_0_5_617 VGND VGND VPWR VPWR sky130_fd_sc_hd__decap_6
XFILLER_0_13_417 VGND VGND VPWR VPWR sky130_fd_sc_hd__fill_2
XFILLER_0_41_704 VGND VGND VPWR VPWR sky130_fd_sc_hd__fill_1
XFILLER_0_7_15 VPWR VGND VPWR VGND sky130_ef_sc_hd__decap_12
Xhold307 u_pe_array.act_from_right\[13\]\[6\] VGND VGND VPWR VPWR net381 sky130_fd_sc_hd__dlygate4sd3_1
X_4460_ u_pe_array.g_pe_row\[3\].g_pe_col\[0\].u_pe.psum_out\[8\] _1287_ VGND VGND
+ VPWR VPWR _1563_ sky130_fd_sc_hd__or2_1
Xhold329 u_pe_array.act_from_right\[2\]\[8\] VGND VGND VPWR VPWR net403 sky130_fd_sc_hd__dlygate4sd3_1
X_4391_ u_pe_array.g_pe_row\[3\].g_pe_col\[0\].u_pe.psum_out\[2\] _1499_ VGND VGND
+ VPWR VPWR _1500_ sky130_fd_sc_hd__xnor2_1
Xhold318 u_pe_array.act_from_right\[10\]\[10\] VGND VGND VPWR VPWR net392 sky130_fd_sc_hd__dlygate4sd3_1
X_6130_ net335 _2853_ _2847_ _2859_ VGND VGND VPWR VPWR _0573_ sky130_fd_sc_hd__a22o_1
XFILLER_0_0_377 VPWR VGND VPWR VGND sky130_ef_sc_hd__decap_12
XTAP_601 VGND VPWR sky130_fd_sc_hd__tapvpwrvgnd_1
XTAP_612 VGND VPWR sky130_fd_sc_hd__tapvpwrvgnd_1
XTAP_623 VGND VPWR sky130_fd_sc_hd__tapvpwrvgnd_1
XTAP_634 VGND VPWR sky130_fd_sc_hd__tapvpwrvgnd_1
XTAP_645 VGND VPWR sky130_fd_sc_hd__tapvpwrvgnd_1
XTAP_656 VGND VPWR sky130_fd_sc_hd__tapvpwrvgnd_1
XTAP_667 VGND VPWR sky130_fd_sc_hd__tapvpwrvgnd_1
X_6061_ u_pe_array.g_pe_row\[1\].g_pe_col\[0\].u_pe.psum_out\[8\] _1865_ VGND VGND
+ VPWR VPWR _2810_ sky130_fd_sc_hd__or2_1
X_5012_ _1105_ u_pe_array.g_pe_row\[2\].g_pe_col\[1\].u_pe.psum_out\[11\] VGND VGND
+ VPWR VPWR _1989_ sky130_fd_sc_hd__and2b_1
XTAP_678 VGND VPWR sky130_fd_sc_hd__tapvpwrvgnd_1
XTAP_689 VGND VPWR sky130_fd_sc_hd__tapvpwrvgnd_1
XFILLER_0_17_82 VGND VGND VPWR VPWR sky130_fd_sc_hd__decap_4
XFILLER_0_76_601 VGND VGND VPWR VPWR sky130_fd_sc_hd__decap_3
X_6963_ u_pe_array.u_fifo1.rd_ptr\[2\] _3466_ VGND VGND VPWR VPWR _3469_ sky130_fd_sc_hd__nor2_1
XFILLER_0_88_483 VGND VGND VPWR VPWR sky130_fd_sc_hd__fill_1
XFILLER_0_76_645 VGND VGND VPWR VPWR sky130_fd_sc_hd__fill_1
XFILLER_0_75_111 VGND VGND VPWR VPWR sky130_fd_sc_hd__fill_1
X_6894_ _0926_ net703 _3423_ VGND VGND VPWR VPWR _3428_ sky130_fd_sc_hd__mux2_1
X_5914_ u_pe_array.u_fifo1.buffer\[7\]\[0\] _2681_ _2683_ u_pe_array.u_fifo1.buffer\[1\]\[0\]
+ VGND VGND VPWR VPWR _2684_ sky130_fd_sc_hd__a22o_1
X_5845_ u_pe_array.g_pe_row\[1\].g_pe_col\[0\].u_pe.act_val\[3\] _1118_ VGND VGND
+ VPWR VPWR _2638_ sky130_fd_sc_hd__or2_1
XFILLER_0_91_637 VGND VGND VPWR VPWR sky130_fd_sc_hd__fill_2
XFILLER_0_75_177 VGND VGND VPWR VPWR sky130_fd_sc_hd__decap_3
XFILLER_0_75_166 VGND VGND VPWR VPWR sky130_fd_sc_hd__fill_2
XFILLER_0_29_561 VGND VGND VPWR VPWR sky130_fd_sc_hd__decap_4
X_5776_ u_pe_array.g_pe_row\[1\].g_pe_col\[1\].u_pe.psum_out\[7\] _1728_ VGND VGND
+ VPWR VPWR _2580_ sky130_fd_sc_hd__nand2_1
XFILLER_0_8_477 VGND VGND VPWR VPWR sky130_fd_sc_hd__decap_4
XFILLER_0_44_531 VGND VGND VPWR VPWR sky130_fd_sc_hd__fill_1
X_7515_ clknet_leaf_67_clk _0421_ net946 VGND VGND VPWR VPWR u_pe_array.act_from_right\[5\]\[9\]
+ sky130_fd_sc_hd__dfrtp_1
X_4727_ u_pe_array.g_pe_row\[2\].g_pe_col\[2\].u_pe.act_val\[0\] _0933_ VGND VGND
+ VPWR VPWR _1755_ sky130_fd_sc_hd__nand2_1
X_7446_ clknet_leaf_36_clk net233 net951 VGND VGND VPWR VPWR u_pe_array.g_pe_row\[2\].g_pe_col\[0\].u_pe.move_reg\[9\]
+ sky130_fd_sc_hd__dfrtp_1
XFILLER_0_31_203 VGND VGND VPWR VPWR sky130_fd_sc_hd__decap_6
XFILLER_0_31_225 VGND VGND VPWR VPWR sky130_fd_sc_hd__fill_2
XFILLER_0_44_597 VGND VGND VPWR VPWR sky130_fd_sc_hd__fill_1
X_4658_ u_pe_array.g_pe_row\[2\].g_pe_col\[3\].u_pe.psum_out\[11\] _1427_ VGND VGND
+ VPWR VPWR _1717_ sky130_fd_sc_hd__and2b_1
XFILLER_0_114_485 VGND VGND VPWR VPWR sky130_fd_sc_hd__fill_1
Xhold830 u_pe_array.g_pe_row\[0\].g_pe_col\[0\].u_pe.psum_out\[10\] VGND VGND VPWR
+ VPWR net904 sky130_fd_sc_hd__dlygate4sd3_1
X_3609_ _0904_ _0905_ u_fsm.v_cnt\[0\] VGND VGND VPWR VPWR _0906_ sky130_fd_sc_hd__o21ai_1
XFILLER_0_102_669 VPWR VGND VPWR VGND sky130_ef_sc_hd__decap_12
Xhold852 net40 VGND VGND VPWR VPWR net926 sky130_fd_sc_hd__dlygate4sd3_1
XFILLER_0_12_472 VGND VGND VPWR VPWR sky130_fd_sc_hd__decap_4
XFILLER_0_3_193 VPWR VGND VPWR VGND sky130_ef_sc_hd__decap_12
X_7377_ clknet_leaf_0_clk _0283_ net944 VGND VGND VPWR VPWR u_pe_array.g_pe_row\[2\].g_pe_col\[2\].u_pe.psum_out\[9\]
+ sky130_fd_sc_hd__dfrtp_2
Xhold841 u_pe_array.g_pe_row\[3\].g_pe_col\[2\].u_pe.psum_out\[11\] VGND VGND VPWR
+ VPWR net915 sky130_fd_sc_hd__dlygate4sd3_1
X_4589_ _1652_ _1653_ VGND VGND VPWR VPWR _1655_ sky130_fd_sc_hd__nor2_1
Xhold863 u_pe_array.act_from_right\[13\]\[10\] VGND VGND VPWR VPWR net937 sky130_fd_sc_hd__dlygate4sd3_1
X_6328_ _3000_ u_pe_array.g_pe_row\[0\].g_pe_col\[2\].u_pe.psum_out\[1\] _2130_ VGND
+ VGND VPWR VPWR _3001_ sky130_fd_sc_hd__o21a_1
X_6259_ _2962_ _2963_ VGND VGND VPWR VPWR _2964_ sky130_fd_sc_hd__or2_1
XFILLER_0_98_269 VPWR VGND VPWR VGND sky130_ef_sc_hd__decap_12
XFILLER_0_109_235 VGND VGND VPWR VPWR sky130_fd_sc_hd__decap_8
XFILLER_0_54_328 VPWR VGND VPWR VGND sky130_ef_sc_hd__decap_12
XFILLER_0_81_169 VGND VGND VPWR VPWR sky130_fd_sc_hd__decap_6
XFILLER_0_22_203 VPWR VGND VPWR VGND sky130_ef_sc_hd__decap_12
XFILLER_0_22_247 VGND VGND VPWR VPWR sky130_fd_sc_hd__decap_4
XFILLER_0_50_589 VGND VGND VPWR VPWR sky130_fd_sc_hd__decap_4
XFILLER_0_38_15 VPWR VGND VPWR VGND sky130_ef_sc_hd__decap_12
XFILLER_0_57_100 VGND VGND VPWR VPWR sky130_fd_sc_hd__fill_1
X_3960_ net26 net511 _0857_ VGND VGND VPWR VPWR _1174_ sky130_fd_sc_hd__mux2_1
XFILLER_0_85_453 VGND VGND VPWR VPWR sky130_fd_sc_hd__fill_1
XFILLER_0_70_24 VGND VGND VPWR VPWR sky130_fd_sc_hd__decap_4
XFILLER_0_70_46 VPWR VGND VPWR VGND sky130_ef_sc_hd__decap_12
X_3891_ net641 _1131_ _1116_ VGND VGND VPWR VPWR _1132_ sky130_fd_sc_hd__mux2_1
XFILLER_0_115_205 VPWR VGND VPWR VGND sky130_ef_sc_hd__decap_12
XFILLER_0_38_380 VGND VGND VPWR VPWR sky130_fd_sc_hd__decap_3
X_5630_ _2470_ _2471_ VGND VGND VPWR VPWR _2472_ sky130_fd_sc_hd__and2_1
XFILLER_0_60_309 VGND VGND VPWR VPWR sky130_fd_sc_hd__decap_6
X_5561_ u_pe_array.g_pe_row\[1\].g_pe_col\[2\].u_pe.act_val\[4\] _1595_ VGND VGND
+ VPWR VPWR _2409_ sky130_fd_sc_hd__nand2_1
XFILLER_0_115_249 VPWR VGND VPWR VGND sky130_ef_sc_hd__decap_12
X_5492_ u_pe_array.u_fifo2.buffer\[4\]\[2\] net68 _2352_ _2354_ VGND VGND VPWR VPWR
+ _2355_ sky130_fd_sc_hd__a211o_1
X_7300_ clknet_leaf_95_clk _0206_ net951 VGND VGND VPWR VPWR u_pe_array.g_pe_row\[2\].g_pe_col\[2\].u_pe.w_out\[1\]
+ sky130_fd_sc_hd__dfrtp_1
X_4512_ u_pe_array.g_pe_row\[2\].g_pe_col\[3\].u_pe.psum_out\[4\] u_pe_array.g_pe_row\[2\].g_pe_col\[3\].u_pe.act_val\[4\]
+ _1599_ VGND VGND VPWR VPWR _1604_ sky130_fd_sc_hd__mux2_1
XFILLER_0_111_400 VPWR VGND VPWR VGND sky130_ef_sc_hd__decap_12
XFILLER_0_110_41 VPWR VGND VPWR VGND sky130_ef_sc_hd__decap_12
X_7231_ clknet_leaf_13_clk net111 net942 VGND VGND VPWR VPWR u_pe_array.g_pe_row\[3\].g_pe_col\[1\].u_pe.move_reg\[12\]
+ sky130_fd_sc_hd__dfrtp_1
Xhold126 u_pe_array.g_pe_row\[1\].g_pe_col\[2\].u_pe.move_reg\[9\] VGND VGND VPWR
+ VPWR net200 sky130_fd_sc_hd__dlygate4sd3_1
Xhold104 _0262_ VGND VGND VPWR VPWR net178 sky130_fd_sc_hd__dlygate4sd3_1
XFILLER_0_41_556 VGND VGND VPWR VPWR sky130_fd_sc_hd__decap_4
Xhold115 u_pe_array.act_from_down\[11\]\[0\] VGND VGND VPWR VPWR net189 sky130_fd_sc_hd__dlygate4sd3_1
XFILLER_0_110_85 VPWR VGND VPWR VGND sky130_ef_sc_hd__decap_12
Xhold137 _0703_ VGND VGND VPWR VPWR net211 sky130_fd_sc_hd__dlygate4sd3_1
Xhold159 _0352_ VGND VGND VPWR VPWR net233 sky130_fd_sc_hd__dlygate4sd3_1
Xhold148 u_pe_array.g_pe_row\[0\].g_pe_col\[0\].u_pe.move_reg\[12\] VGND VGND VPWR
+ VPWR net222 sky130_fd_sc_hd__dlygate4sd3_1
X_4443_ _1541_ _1546_ VGND VGND VPWR VPWR _1548_ sky130_fd_sc_hd__nand2_1
XFILLER_0_1_653 VPWR VGND VPWR VGND sky130_ef_sc_hd__decap_12
X_4374_ u_pe_array.g_pe_row\[3\].g_pe_col\[0\].u_pe.psum_out\[0\] u_pe_array.g_pe_row\[3\].g_pe_col\[0\].u_pe.act_val\[0\]
+ u_pe_array.g_pe_row\[3\].g_pe_col\[0\].u_pe.w_out\[0\] VGND VGND VPWR VPWR _1485_
+ sky130_fd_sc_hd__and3_1
XFILLER_0_0_141 VPWR VGND VPWR VGND sky130_ef_sc_hd__decap_12
X_7162_ clknet_leaf_9_clk _0068_ net945 VGND VGND VPWR VPWR u_pe_array.act_from_right\[13\]\[10\]
+ sky130_fd_sc_hd__dfrtp_1
X_6113_ net259 _2499_ _2847_ _2850_ VGND VGND VPWR VPWR _0565_ sky130_fd_sc_hd__a22o_1
XTAP_431 VGND VPWR sky130_fd_sc_hd__tapvpwrvgnd_1
XFILLER_0_1_697 VGND VGND VPWR VPWR sky130_fd_sc_hd__decap_8
XTAP_420 VGND VPWR sky130_fd_sc_hd__tapvpwrvgnd_1
XTAP_442 VGND VPWR sky130_fd_sc_hd__tapvpwrvgnd_1
X_7093_ clknet_leaf_89_clk u_fsm.next_state\[2\] net949 VGND VGND VPWR VPWR u_fsm.state\[2\]
+ sky130_fd_sc_hd__dfrtp_1
XTAP_453 VGND VPWR sky130_fd_sc_hd__tapvpwrvgnd_1
XTAP_464 VGND VPWR sky130_fd_sc_hd__tapvpwrvgnd_1
XTAP_475 VGND VPWR sky130_fd_sc_hd__tapvpwrvgnd_1
X_6044_ _2233_ _2793_ _2794_ _2621_ net543 VGND VGND VPWR VPWR _0552_ sky130_fd_sc_hd__a32o_1
XTAP_486 VGND VPWR sky130_fd_sc_hd__tapvpwrvgnd_1
XTAP_497 VGND VPWR sky130_fd_sc_hd__tapvpwrvgnd_1
XTAP_1619 VGND VPWR sky130_fd_sc_hd__tapvpwrvgnd_1
XTAP_1608 VGND VPWR sky130_fd_sc_hd__tapvpwrvgnd_1
X_6946_ _3457_ VGND VGND VPWR VPWR _0791_ sky130_fd_sc_hd__clkbuf_1
XFILLER_0_48_122 VGND VGND VPWR VPWR sky130_fd_sc_hd__decap_8
XFILLER_0_64_604 VGND VGND VPWR VPWR sky130_fd_sc_hd__fill_1
X_6877_ _3418_ VGND VGND VPWR VPWR _0761_ sky130_fd_sc_hd__clkbuf_1
X_5828_ net33 u_pe_array.g_pe_row\[0\].g_pe_col\[3\].u_pe.w_out\[0\] _0931_ VGND VGND
+ VPWR VPWR _2626_ sky130_fd_sc_hd__mux2_1
XFILLER_0_106_205 VPWR VGND VPWR VGND sky130_ef_sc_hd__decap_12
X_5759_ u_pe_array.g_pe_row\[1\].g_pe_col\[1\].u_pe.act_val\[5\] VGND VGND VPWR VPWR
+ _2564_ sky130_fd_sc_hd__inv_2
XFILLER_0_63_169 VGND VGND VPWR VPWR sky130_fd_sc_hd__decap_4
XFILLER_0_44_361 VGND VGND VPWR VPWR sky130_fd_sc_hd__decap_3
X_7429_ clknet_leaf_13_clk _0335_ net951 VGND VGND VPWR VPWR u_pe_array.act_from_up\[12\]\[5\]
+ sky130_fd_sc_hd__dfrtp_1
XFILLER_0_102_477 VGND VGND VPWR VPWR sky130_fd_sc_hd__fill_2
Xhold660 u_pe_array.u_fifo1.rd_ptr\[0\] VGND VGND VPWR VPWR net734 sky130_fd_sc_hd__dlygate4sd3_1
Xhold671 u_pe_array.g_pe_row\[1\].g_pe_col\[0\].u_pe.act_val\[3\] VGND VGND VPWR VPWR
+ net745 sky130_fd_sc_hd__dlygate4sd3_1
Xhold682 u_pe_array.g_pe_row\[1\].g_pe_col\[3\].u_pe.move_reg\[7\] VGND VGND VPWR
+ VPWR net756 sky130_fd_sc_hd__dlygate4sd3_1
Xhold693 u_pe_array.u_fifo2.buffer\[6\]\[3\] VGND VGND VPWR VPWR net767 sky130_fd_sc_hd__dlygate4sd3_1
XFILLER_0_39_111 VGND VGND VPWR VPWR sky130_fd_sc_hd__fill_1
XFILLER_0_67_486 VGND VGND VPWR VPWR sky130_fd_sc_hd__decap_8
XFILLER_0_94_294 VGND VGND VPWR VPWR sky130_fd_sc_hd__decap_8
XFILLER_0_40_27 VGND VGND VPWR VPWR sky130_fd_sc_hd__fill_1
XFILLER_0_82_467 VGND VGND VPWR VPWR sky130_fd_sc_hd__fill_1
XFILLER_0_70_618 VGND VGND VPWR VPWR sky130_fd_sc_hd__fill_1
XFILLER_0_42_309 VPWR VGND VPWR VGND sky130_ef_sc_hd__decap_12
Xload_slew5 net945 VGND VGND VPWR VPWR net944 sky130_fd_sc_hd__buf_12
XFILLER_0_65_57 VGND VGND VPWR VPWR sky130_fd_sc_hd__decap_8
X_4090_ net808 _1273_ _1283_ _1021_ VGND VGND VPWR VPWR _0109_ sky130_fd_sc_hd__a22o_1
XFILLER_0_81_23 VGND VGND VPWR VPWR sky130_fd_sc_hd__fill_2
XFILLER_0_77_217 VGND VGND VPWR VPWR sky130_fd_sc_hd__fill_1
X_6800_ net390 _3368_ _3370_ VGND VGND VPWR VPWR _0732_ sky130_fd_sc_hd__a21oi_1
X_4992_ _1003_ _1971_ VGND VGND VPWR VPWR _1972_ sky130_fd_sc_hd__nor2_1
X_7780_ clknet_leaf_73_clk _0686_ net13 VGND VGND VPWR VPWR u_pe_array.act_from_up\[4\]\[2\]
+ sky130_fd_sc_hd__dfrtp_1
X_6731_ _3303_ _3314_ _3315_ VGND VGND VPWR VPWR _3316_ sky130_fd_sc_hd__o21ai_2
XFILLER_0_85_250 VGND VGND VPWR VPWR sky130_fd_sc_hd__fill_2
XFILLER_0_14_72 VPWR VGND VPWR VGND sky130_ef_sc_hd__decap_12
X_3943_ _0983_ _1144_ _1166_ net116 VGND VGND VPWR VPWR _0079_ sky130_fd_sc_hd__a22o_1
X_6662_ u_pe_array.g_pe_row\[0\].g_pe_col\[0\].u_pe.act_val\[0\] _3246_ _3252_ _3253_
+ VGND VGND VPWR VPWR _3254_ sky130_fd_sc_hd__a2bb2o_1
XFILLER_0_58_497 VGND VGND VPWR VPWR sky130_fd_sc_hd__decap_3
XFILLER_0_6_701 VGND VGND VPWR VPWR sky130_fd_sc_hd__decap_4
X_3874_ u_pe_array.g_pe_row\[0\].g_pe_col\[0\].u_pe.psum_shift_en_d _0865_ VGND VGND
+ VPWR VPWR _1118_ sky130_fd_sc_hd__nor2_8
Xclkbuf_3_2__f_clk clknet_0_clk VGND VGND VPWR VPWR clknet_3_2__leaf_clk sky130_fd_sc_hd__clkbuf_16
X_5613_ _2455_ _2456_ VGND VGND VPWR VPWR _2457_ sky130_fd_sc_hd__nand2_1
XFILLER_0_116_558 VGND VGND VPWR VPWR sky130_fd_sc_hd__fill_1
X_6593_ _3210_ _3215_ _0977_ VGND VGND VPWR VPWR _3217_ sky130_fd_sc_hd__o21ai_1
XFILLER_0_5_277 VGND VGND VPWR VPWR sky130_fd_sc_hd__decap_3
XFILLER_0_30_82 VGND VGND VPWR VPWR sky130_fd_sc_hd__fill_2
X_5544_ _2392_ _2393_ VGND VGND VPWR VPWR _2394_ sky130_fd_sc_hd__xor2_1
XFILLER_0_14_589 VGND VGND VPWR VPWR sky130_fd_sc_hd__decap_3
X_5475_ _0853_ _0855_ VGND VGND VPWR VPWR _2340_ sky130_fd_sc_hd__and2_1
XFILLER_0_41_375 VGND VGND VPWR VPWR sky130_fd_sc_hd__decap_8
X_7214_ clknet_leaf_35_clk net406 net942 VGND VGND VPWR VPWR u_pe_array.act_from_down\[9\]\[8\]
+ sky130_fd_sc_hd__dfrtp_1
XFILLER_0_69_3 VGND VGND VPWR VPWR sky130_fd_sc_hd__decap_4
X_4426_ u_pe_array.g_pe_row\[3\].g_pe_col\[0\].u_pe.psum_out\[4\] _1519_ _1531_ VGND
+ VGND VPWR VPWR _1532_ sky130_fd_sc_hd__a21oi_2
XFILLER_0_1_461 VPWR VGND VPWR VGND sky130_ef_sc_hd__decap_12
X_7145_ clknet_leaf_20_clk _0051_ net943 VGND VGND VPWR VPWR u_pe_array.g_pe_row\[3\].g_pe_col\[3\].u_pe.psum_out\[8\]
+ sky130_fd_sc_hd__dfrtp_2
XTAP_250 VGND VPWR sky130_fd_sc_hd__tapvpwrvgnd_1
X_4357_ net17 u_pe_array.act_from_up\[12\]\[2\] _0857_ VGND VGND VPWR VPWR _1479_
+ sky130_fd_sc_hd__mux2_1
X_4288_ _1435_ _1112_ VGND VGND VPWR VPWR _1436_ sky130_fd_sc_hd__nand2_1
XTAP_272 VGND VPWR sky130_fd_sc_hd__tapvpwrvgnd_1
XTAP_261 VGND VPWR sky130_fd_sc_hd__tapvpwrvgnd_1
XTAP_283 VGND VPWR sky130_fd_sc_hd__tapvpwrvgnd_1
X_7076_ net656 _3362_ _3529_ VGND VGND VPWR VPWR _3535_ sky130_fd_sc_hd__mux2_1
XTAP_294 VGND VPWR sky130_fd_sc_hd__tapvpwrvgnd_1
X_6027_ _2776_ _2778_ VGND VGND VPWR VPWR _2779_ sky130_fd_sc_hd__xor2_1
XTAP_1405 VGND VPWR sky130_fd_sc_hd__tapvpwrvgnd_1
XFILLER_0_68_206 VPWR VGND VPWR VGND sky130_ef_sc_hd__decap_12
XFILLER_0_96_559 VGND VGND VPWR VPWR sky130_fd_sc_hd__decap_3
XTAP_1438 VGND VPWR sky130_fd_sc_hd__tapvpwrvgnd_1
XTAP_1427 VGND VPWR sky130_fd_sc_hd__tapvpwrvgnd_1
XTAP_1416 VGND VPWR sky130_fd_sc_hd__tapvpwrvgnd_1
XTAP_1449 VGND VPWR sky130_fd_sc_hd__tapvpwrvgnd_1
XFILLER_0_76_250 VGND VGND VPWR VPWR sky130_fd_sc_hd__fill_2
X_6929_ _0920_ net651 _3446_ VGND VGND VPWR VPWR _3448_ sky130_fd_sc_hd__mux2_1
XFILLER_0_37_615 VGND VGND VPWR VPWR sky130_fd_sc_hd__fill_1
XFILLER_0_49_453 VGND VGND VPWR VPWR sky130_fd_sc_hd__fill_1
XFILLER_0_24_309 VGND VGND VPWR VPWR sky130_fd_sc_hd__fill_1
XFILLER_0_52_629 VGND VGND VPWR VPWR sky130_fd_sc_hd__decap_3
XFILLER_0_60_640 VGND VGND VPWR VPWR sky130_fd_sc_hd__decap_4
XFILLER_0_20_504 VGND VGND VPWR VPWR sky130_fd_sc_hd__fill_1
XFILLER_0_20_548 VGND VGND VPWR VPWR sky130_fd_sc_hd__decap_4
Xhold490 u_pe_array.act_from_up\[14\]\[1\] VGND VGND VPWR VPWR net564 sky130_fd_sc_hd__dlygate4sd3_1
XFILLER_0_19_39 VPWR VGND VPWR VGND sky130_ef_sc_hd__decap_12
XFILLER_0_87_537 VGND VGND VPWR VPWR sky130_fd_sc_hd__decap_6
XFILLER_0_87_559 VGND VGND VPWR VPWR sky130_fd_sc_hd__fill_1
XFILLER_0_55_401 VGND VGND VPWR VPWR sky130_fd_sc_hd__fill_2
XFILLER_0_27_125 VGND VGND VPWR VPWR sky130_fd_sc_hd__decap_6
XFILLER_0_82_253 VGND VGND VPWR VPWR sky130_fd_sc_hd__fill_1
XFILLER_0_27_136 VGND VGND VPWR VPWR sky130_fd_sc_hd__decap_8
X_3590_ _0864_ net694 _0886_ VGND VGND VPWR VPWR _0003_ sky130_fd_sc_hd__a21oi_1
XFILLER_0_51_673 VGND VGND VPWR VPWR sky130_fd_sc_hd__decap_4
X_5260_ u_pe_array.g_pe_row\[1\].g_pe_col\[3\].u_pe.psum_out\[1\] _1426_ VGND VGND
+ VPWR VPWR _2165_ sky130_fd_sc_hd__xor2_1
X_4211_ u_pe_array.g_pe_row\[3\].g_pe_col\[1\].u_pe.psum_out\[5\] _1106_ VGND VGND
+ VPWR VPWR _1370_ sky130_fd_sc_hd__nand2_1
X_5191_ u_pe_array.g_pe_row\[2\].g_pe_col\[0\].u_pe.psum_out\[12\] _2119_ VGND VGND
+ VPWR VPWR _2126_ sky130_fd_sc_hd__xnor2_1
X_4142_ _0866_ VGND VGND VPWR VPWR _1310_ sky130_fd_sc_hd__clkbuf_8
X_4073_ _1267_ _1268_ VGND VGND VPWR VPWR _1269_ sky130_fd_sc_hd__and2_1
X_7901_ clknet_leaf_76_clk _0806_ VGND VGND VPWR VPWR u_pe_array.u_fifo1.buffer\[0\]\[3\]
+ sky130_fd_sc_hd__dfxtp_1
XFILLER_0_92_77 VGND VGND VPWR VPWR sky130_fd_sc_hd__decap_6
XFILLER_0_92_99 VGND VGND VPWR VPWR sky130_fd_sc_hd__decap_8
X_7832_ clknet_leaf_84_clk _0737_ net948 VGND VGND VPWR VPWR u_pe_array.u_fifo2.count\[0\]
+ sky130_fd_sc_hd__dfrtp_4
X_4975_ _1954_ _1955_ VGND VGND VPWR VPWR _1956_ sky130_fd_sc_hd__and2_1
X_7763_ clknet_leaf_52_clk _0669_ net74 VGND VGND VPWR VPWR u_pe_array.g_pe_row\[0\].g_pe_col\[1\].u_pe.psum_out\[0\]
+ sky130_fd_sc_hd__dfrtp_1
XFILLER_0_19_615 VGND VGND VPWR VPWR sky130_fd_sc_hd__fill_1
X_6714_ _3299_ _3300_ VGND VGND VPWR VPWR _3301_ sky130_fd_sc_hd__or2_1
X_3926_ _0941_ _0983_ VGND VGND VPWR VPWR _1158_ sky130_fd_sc_hd__nor2_8
X_7694_ clknet_leaf_26_clk _0600_ net943 VGND VGND VPWR VPWR u_pe_array.g_pe_row\[0\].g_pe_col\[1\].u_pe.w_out\[0\]
+ sky130_fd_sc_hd__dfrtp_4
XFILLER_0_116_344 VGND VGND VPWR VPWR sky130_fd_sc_hd__decap_3
XFILLER_0_116_333 VGND VGND VPWR VPWR sky130_fd_sc_hd__decap_8
X_6645_ net128 _0866_ _0940_ u_pe_array.g_pe_row\[0\].g_pe_col\[0\].u_pe.move_reg\[8\]
+ VGND VGND VPWR VPWR _0705_ sky130_fd_sc_hd__a22o_1
X_3857_ u_pe_array.g_pe_row\[2\].g_pe_col\[1\].u_pe.w_out\[0\] u_pe_array.g_pe_row\[3\].g_pe_col\[1\].u_pe.w_out\[0\]
+ _0931_ VGND VGND VPWR VPWR _1104_ sky130_fd_sc_hd__mux2_1
XFILLER_0_6_531 VGND VGND VPWR VPWR sky130_fd_sc_hd__fill_1
XFILLER_0_27_670 VGND VGND VPWR VPWR sky130_fd_sc_hd__fill_2
XFILLER_0_34_629 VGND VGND VPWR VPWR sky130_fd_sc_hd__decap_3
XFILLER_0_41_81 VPWR VGND VPWR VGND sky130_ef_sc_hd__decap_12
X_6576_ _1003_ _3201_ VGND VGND VPWR VPWR _3202_ sky130_fd_sc_hd__nor2_1
X_3788_ _1033_ _1041_ _1042_ _0986_ net438 VGND VGND VPWR VPWR _0048_ sky130_fd_sc_hd__a32o_1
XFILLER_0_26_180 VGND VGND VPWR VPWR sky130_fd_sc_hd__fill_2
XFILLER_0_6_597 VGND VGND VPWR VPWR sky130_fd_sc_hd__fill_2
X_5527_ u_pe_array.g_pe_row\[1\].g_pe_col\[2\].u_pe.act_val\[0\] _1595_ u_pe_array.g_pe_row\[1\].g_pe_col\[2\].u_pe.psum_out\[0\]
+ VGND VGND VPWR VPWR _2379_ sky130_fd_sc_hd__a21o_1
XFILLER_0_42_662 VPWR VGND VPWR VGND sky130_ef_sc_hd__decap_12
XFILLER_0_100_701 VGND VGND VPWR VPWR sky130_fd_sc_hd__decap_4
X_5458_ u_pe_array.u_fifo2.rd_ptr\[2\] _2321_ u_pe_array.u_fifo2.rd_ptr\[3\] VGND
+ VGND VPWR VPWR _2323_ sky130_fd_sc_hd__o21ba_1
X_5389_ u_pe_array.g_pe_row\[1\].g_pe_col\[2\].u_pe.act_val\[2\] VGND VGND VPWR VPWR
+ _2278_ sky130_fd_sc_hd__inv_2
X_4409_ _1505_ _1513_ _1512_ VGND VGND VPWR VPWR _1516_ sky130_fd_sc_hd__a21oi_1
X_7128_ clknet_leaf_19_clk _0034_ net70 VGND VGND VPWR VPWR u_pe_array.g_pe_row\[3\].g_pe_col\[3\].u_pe.act_val\[4\]
+ sky130_fd_sc_hd__dfrtp_1
XFILLER_0_5_81 VPWR VGND VPWR VGND sky130_ef_sc_hd__decap_12
X_7059_ _3525_ VGND VGND VPWR VPWR _0836_ sky130_fd_sc_hd__clkbuf_1
XFILLER_0_96_312 VPWR VGND VPWR VGND sky130_ef_sc_hd__decap_12
XTAP_1213 VGND VPWR sky130_fd_sc_hd__tapvpwrvgnd_1
XTAP_1202 VGND VPWR sky130_fd_sc_hd__tapvpwrvgnd_1
XTAP_1246 VGND VPWR sky130_fd_sc_hd__tapvpwrvgnd_1
XTAP_1257 VGND VPWR sky130_fd_sc_hd__tapvpwrvgnd_1
XTAP_1235 VGND VPWR sky130_fd_sc_hd__tapvpwrvgnd_1
XTAP_1224 VGND VPWR sky130_fd_sc_hd__tapvpwrvgnd_1
XTAP_1279 VGND VPWR sky130_fd_sc_hd__tapvpwrvgnd_1
XTAP_1268 VGND VPWR sky130_fd_sc_hd__tapvpwrvgnd_1
XFILLER_0_64_220 VGND VGND VPWR VPWR sky130_fd_sc_hd__decap_4
XFILLER_0_37_412 VGND VGND VPWR VPWR sky130_fd_sc_hd__decap_6
XFILLER_0_64_253 VGND VGND VPWR VPWR sky130_fd_sc_hd__decap_6
XFILLER_0_107_333 VGND VGND VPWR VPWR sky130_fd_sc_hd__decap_3
XFILLER_0_24_139 VGND VGND VPWR VPWR sky130_fd_sc_hd__fill_1
XFILLER_0_33_673 VPWR VGND VPWR VGND sky130_ef_sc_hd__decap_12
XFILLER_0_103_550 VGND VGND VPWR VPWR sky130_fd_sc_hd__decap_3
XFILLER_0_20_334 VGND VGND VPWR VPWR sky130_fd_sc_hd__decap_4
XFILLER_0_99_172 VPWR VGND VPWR VGND sky130_ef_sc_hd__decap_12
XFILLER_0_87_312 VGND VGND VPWR VPWR sky130_fd_sc_hd__fill_1
XFILLER_0_87_301 VGND VGND VPWR VPWR sky130_fd_sc_hd__fill_2
XFILLER_0_1_39 VPWR VGND VPWR VGND sky130_ef_sc_hd__decap_12
XFILLER_0_118_609 VGND VGND VPWR VPWR sky130_fd_sc_hd__decap_6
X_4760_ u_pe_array.g_pe_row\[2\].g_pe_col\[2\].u_pe.act_val\[4\] u_pe_array.g_pe_row\[2\].g_pe_col\[2\].u_pe.w_out\[0\]
+ VGND VGND VPWR VPWR _1785_ sky130_fd_sc_hd__nand2_1
XFILLER_0_28_456 VGND VGND VPWR VPWR sky130_fd_sc_hd__decap_8
X_3711_ net411 _0939_ VGND VGND VPWR VPWR _0974_ sky130_fd_sc_hd__and2_1
XFILLER_0_15_117 VGND VGND VPWR VPWR sky130_fd_sc_hd__decap_8
X_4691_ u_pe_array.g_pe_row\[2\].g_pe_col\[2\].u_pe.psum_out\[5\] u_pe_array.g_pe_row\[2\].g_pe_col\[2\].u_pe.act_val\[5\]
+ _1599_ VGND VGND VPWR VPWR _1741_ sky130_fd_sc_hd__mux2_1
XFILLER_0_102_53 VPWR VGND VPWR VGND sky130_ef_sc_hd__decap_12
XFILLER_0_70_223 VGND VGND VPWR VPWR sky130_fd_sc_hd__decap_8
XFILLER_0_11_51 VGND VGND VPWR VPWR sky130_fd_sc_hd__decap_4
X_3642_ _0860_ _0862_ _0894_ VGND VGND VPWR VPWR _0930_ sky130_fd_sc_hd__a21oi_4
X_6430_ _3089_ _3093_ VGND VGND VPWR VPWR _3094_ sky130_fd_sc_hd__xor2_1
XFILLER_0_102_97 VPWR VGND VPWR VGND sky130_ef_sc_hd__decap_12
XFILLER_0_23_150 VPWR VGND VPWR VGND sky130_ef_sc_hd__decap_12
X_6361_ _3029_ _3030_ VGND VGND VPWR VPWR _3032_ sky130_fd_sc_hd__nand2_1
XFILLER_0_87_33 VGND VGND VPWR VPWR sky130_fd_sc_hd__decap_6
X_5312_ _2210_ _2212_ VGND VGND VPWR VPWR _2213_ sky130_fd_sc_hd__nand2_1
X_3573_ _0879_ _0871_ _0858_ _0852_ VGND VGND VPWR VPWR _0880_ sky130_fd_sc_hd__a2bb2o_1
X_6292_ net648 _2006_ _2009_ _2983_ VGND VGND VPWR VPWR _0611_ sky130_fd_sc_hd__a22o_1
XFILLER_0_11_334 VGND VGND VPWR VPWR sky130_fd_sc_hd__fill_2
X_5243_ net756 _0939_ VGND VGND VPWR VPWR _2155_ sky130_fd_sc_hd__and2_1
X_5174_ _2104_ _2105_ _2110_ _2107_ _2102_ VGND VGND VPWR VPWR _2111_ sky130_fd_sc_hd__a32o_1
Xhold19 u_pe_array.act_from_right\[10\]\[12\] VGND VGND VPWR VPWR net93 sky130_fd_sc_hd__dlygate4sd3_1
X_4125_ u_pe_array.act_from_right\[13\]\[0\] u_pe_array.act_from_left\[13\]\[0\] _0963_
+ VGND VGND VPWR VPWR _1303_ sky130_fd_sc_hd__mux2_1
X_4056_ _1252_ _1253_ VGND VGND VPWR VPWR _1254_ sky130_fd_sc_hd__nand2_1
X_7815_ clknet_leaf_56_clk _0720_ net74 VGND VGND VPWR VPWR u_pe_array.g_pe_row\[0\].g_pe_col\[0\].u_pe.psum_out\[10\]
+ sky130_fd_sc_hd__dfrtp_2
XFILLER_0_93_337 VGND VGND VPWR VPWR sky130_fd_sc_hd__decap_6
XFILLER_0_93_315 VGND VGND VPWR VPWR sky130_fd_sc_hd__fill_2
XFILLER_0_59_570 VGND VGND VPWR VPWR sky130_fd_sc_hd__decap_6
X_4958_ _1938_ _1105_ u_pe_array.g_pe_row\[2\].g_pe_col\[1\].u_pe.psum_out\[6\] VGND
+ VGND VPWR VPWR _1940_ sky130_fd_sc_hd__a21oi_1
X_7746_ clknet_leaf_50_clk _0652_ net946 VGND VGND VPWR VPWR u_pe_array.act_from_right\[0\]\[9\]
+ sky130_fd_sc_hd__dfrtp_1
XFILLER_0_116_130 VGND VGND VPWR VPWR sky130_fd_sc_hd__decap_8
X_4889_ net75 _1750_ _1483_ u_pe_array.g_pe_row\[2\].g_pe_col\[1\].u_pe.move_reg\[7\]
+ VGND VGND VPWR VPWR _0309_ sky130_fd_sc_hd__a22o_1
X_7677_ clknet_leaf_63_clk net194 net74 VGND VGND VPWR VPWR u_pe_array.g_pe_row\[0\].g_pe_col\[3\].u_pe.move_reg\[9\]
+ sky130_fd_sc_hd__dfrtp_1
X_3909_ _1145_ VGND VGND VPWR VPWR _0066_ sky130_fd_sc_hd__clkbuf_1
XFILLER_0_46_253 VGND VGND VPWR VPWR sky130_fd_sc_hd__decap_6
XFILLER_0_116_141 VPWR VGND VPWR VGND sky130_ef_sc_hd__decap_12
X_6628_ net477 _1731_ _1734_ _3238_ VGND VGND VPWR VPWR _0692_ sky130_fd_sc_hd__a22o_1
XFILLER_0_61_223 VGND VGND VPWR VPWR sky130_fd_sc_hd__fill_1
XFILLER_0_117_697 VGND VGND VPWR VPWR sky130_fd_sc_hd__decap_8
XFILLER_0_15_673 VPWR VGND VPWR VGND sky130_ef_sc_hd__decap_12
X_6559_ _3184_ _3185_ VGND VGND VPWR VPWR _3186_ sky130_fd_sc_hd__and2_1
XFILLER_0_61_289 VGND VGND VPWR VPWR sky130_fd_sc_hd__decap_3
XFILLER_0_14_183 VPWR VGND VPWR VGND sky130_ef_sc_hd__decap_12
XFILLER_0_30_610 VGND VGND VPWR VPWR sky130_fd_sc_hd__decap_8
XFILLER_0_42_470 VGND VGND VPWR VPWR sky130_fd_sc_hd__fill_1
XFILLER_0_16_29 VPWR VGND VPWR VGND sky130_ef_sc_hd__decap_12
XFILLER_0_69_356 VPWR VGND VPWR VGND sky130_ef_sc_hd__decap_12
XTAP_1021 VGND VPWR sky130_fd_sc_hd__tapvpwrvgnd_1
XTAP_1010 VGND VPWR sky130_fd_sc_hd__tapvpwrvgnd_1
XFILLER_0_96_197 VGND VGND VPWR VPWR sky130_fd_sc_hd__fill_1
XFILLER_0_84_337 VGND VGND VPWR VPWR sky130_fd_sc_hd__decap_3
XTAP_1065 VGND VPWR sky130_fd_sc_hd__tapvpwrvgnd_1
XTAP_1054 VGND VPWR sky130_fd_sc_hd__tapvpwrvgnd_1
XTAP_1043 VGND VPWR sky130_fd_sc_hd__tapvpwrvgnd_1
XTAP_1032 VGND VPWR sky130_fd_sc_hd__tapvpwrvgnd_1
XFILLER_0_84_359 VGND VGND VPWR VPWR sky130_fd_sc_hd__decap_4
XFILLER_0_84_348 VGND VGND VPWR VPWR sky130_fd_sc_hd__fill_2
XTAP_1087 VGND VPWR sky130_fd_sc_hd__tapvpwrvgnd_1
XTAP_1098 VGND VPWR sky130_fd_sc_hd__tapvpwrvgnd_1
XTAP_1076 VGND VPWR sky130_fd_sc_hd__tapvpwrvgnd_1
XFILLER_0_37_242 VGND VGND VPWR VPWR sky130_fd_sc_hd__decap_3
XFILLER_0_80_510 VGND VGND VPWR VPWR sky130_fd_sc_hd__fill_2
XFILLER_0_52_234 VGND VGND VPWR VPWR sky130_fd_sc_hd__decap_8
XFILLER_0_110_306 VGND VGND VPWR VPWR sky130_fd_sc_hd__fill_2
XFILLER_0_103_380 VGND VGND VPWR VPWR sky130_fd_sc_hd__fill_1
XFILLER_0_0_559 VGND VGND VPWR VPWR sky130_fd_sc_hd__fill_1
XTAP_805 VGND VPWR sky130_fd_sc_hd__tapvpwrvgnd_1
XTAP_816 VGND VPWR sky130_fd_sc_hd__tapvpwrvgnd_1
XTAP_838 VGND VPWR sky130_fd_sc_hd__tapvpwrvgnd_1
XTAP_827 VGND VPWR sky130_fd_sc_hd__tapvpwrvgnd_1
XTAP_849 VGND VPWR sky130_fd_sc_hd__tapvpwrvgnd_1
X_5930_ u_pe_array.u_fifo1.buffer\[4\]\[1\] _2680_ _2696_ _2698_ VGND VGND VPWR VPWR
+ _2699_ sky130_fd_sc_hd__a211o_1
XFILLER_0_75_304 VGND VGND VPWR VPWR sky130_fd_sc_hd__decap_4
XFILLER_0_75_337 VGND VGND VPWR VPWR sky130_fd_sc_hd__fill_1
X_7600_ clknet_leaf_74_clk _0506_ net72 VGND VGND VPWR VPWR u_pe_array.g_pe_row\[0\].g_pe_col\[3\].u_pe.w_out\[1\]
+ sky130_fd_sc_hd__dfrtp_1
X_5861_ _2650_ VGND VGND VPWR VPWR _0513_ sky130_fd_sc_hd__clkbuf_1
X_5792_ u_pe_array.g_pe_row\[1\].g_pe_col\[1\].u_pe.psum_out\[8\] _2580_ VGND VGND
+ VPWR VPWR _2595_ sky130_fd_sc_hd__nor2_1
X_4812_ _1831_ _1832_ VGND VGND VPWR VPWR _1833_ sky130_fd_sc_hd__nand2_1
X_7531_ clknet_leaf_66_clk _0437_ net946 VGND VGND VPWR VPWR u_pe_array.act_from_left\[7\]\[12\]
+ sky130_fd_sc_hd__dfrtp_1
X_4743_ _1768_ _1769_ net813 _1006_ VGND VGND VPWR VPWR _0276_ sky130_fd_sc_hd__a2bb2o_1
XFILLER_0_7_125 VPWR VGND VPWR VGND sky130_ef_sc_hd__decap_12
XFILLER_0_28_253 VPWR VGND VPWR VGND sky130_ef_sc_hd__decap_12
X_7462_ clknet_leaf_32_clk _0368_ net71 VGND VGND VPWR VPWR u_pe_array.g_pe_row\[2\].g_pe_col\[0\].u_pe.psum_out\[12\]
+ sky130_fd_sc_hd__dfrtp_2
XFILLER_0_71_543 VGND VGND VPWR VPWR sky130_fd_sc_hd__decap_8
XFILLER_0_7_169 VPWR VGND VPWR VGND sky130_ef_sc_hd__decap_12
XFILLER_0_22_83 VGND VGND VPWR VPWR sky130_fd_sc_hd__fill_1
XFILLER_0_114_645 VPWR VGND VPWR VGND sky130_ef_sc_hd__decap_12
XFILLER_0_113_111 VGND VGND VPWR VPWR sky130_fd_sc_hd__fill_1
X_4674_ _1729_ VGND VGND VPWR VPWR _0247_ sky130_fd_sc_hd__clkbuf_1
XFILLER_0_71_565 VGND VGND VPWR VPWR sky130_fd_sc_hd__fill_1
XFILLER_0_43_278 VGND VGND VPWR VPWR sky130_fd_sc_hd__fill_2
X_6413_ _3071_ _3073_ _3078_ VGND VGND VPWR VPWR _3079_ sky130_fd_sc_hd__o21ai_1
XFILLER_0_98_65 VPWR VGND VPWR VGND sky130_ef_sc_hd__decap_12
X_7393_ clknet_leaf_34_clk _0299_ net942 VGND VGND VPWR VPWR u_pe_array.act_from_right\[8\]\[10\]
+ sky130_fd_sc_hd__dfrtp_1
XFILLER_0_3_353 VGND VGND VPWR VPWR sky130_fd_sc_hd__fill_2
X_3625_ _0911_ net612 _0918_ VGND VGND VPWR VPWR _0919_ sky130_fd_sc_hd__mux2_1
XFILLER_0_11_120 VGND VGND VPWR VPWR sky130_fd_sc_hd__fill_1
X_3556_ u_fsm.cnt\[3\] _0863_ VGND VGND VPWR VPWR _0864_ sky130_fd_sc_hd__or2_2
X_6344_ _2999_ _3001_ VGND VGND VPWR VPWR _3016_ sky130_fd_sc_hd__nand2_1
X_6275_ u_pe_array.g_pe_row\[0\].g_pe_col\[2\].u_pe.psum_out\[1\] u_pe_array.g_pe_row\[0\].g_pe_col\[2\].u_pe.act_val\[1\]
+ _2844_ VGND VGND VPWR VPWR _2975_ sky130_fd_sc_hd__mux2_1
X_5226_ net183 _2143_ _2132_ _2146_ VGND VGND VPWR VPWR _0382_ sky130_fd_sc_hd__a22o_1
XFILLER_0_11_186 VPWR VGND VPWR VGND sky130_ef_sc_hd__decap_12
XFILLER_0_51_3 VGND VGND VPWR VPWR sky130_fd_sc_hd__decap_6
X_5157_ _2079_ _2089_ _2094_ _2095_ VGND VGND VPWR VPWR _2096_ sky130_fd_sc_hd__o31a_1
X_5088_ _2031_ _2032_ VGND VGND VPWR VPWR _2033_ sky130_fd_sc_hd__xor2_1
X_4108_ u_pe_array.g_pe_row\[3\].g_pe_col\[1\].u_pe.psum_out\[5\] u_pe_array.g_pe_row\[3\].g_pe_col\[1\].u_pe.act_val\[5\]
+ _0947_ VGND VGND VPWR VPWR _1294_ sky130_fd_sc_hd__mux2_1
X_4039_ _1233_ _1236_ _1232_ VGND VGND VPWR VPWR _1238_ sky130_fd_sc_hd__a21oi_1
XFILLER_0_94_624 VGND VGND VPWR VPWR sky130_fd_sc_hd__fill_2
XFILLER_0_78_197 VPWR VGND VPWR VGND sky130_ef_sc_hd__decap_12
XFILLER_0_78_186 VGND VGND VPWR VPWR sky130_fd_sc_hd__decap_8
XFILLER_0_66_304 VGND VGND VPWR VPWR sky130_fd_sc_hd__decap_4
XPHY_115 VGND VGND VPWR VPWR sky130_fd_sc_hd__decap_3
XPHY_104 VGND VGND VPWR VPWR sky130_fd_sc_hd__decap_3
XFILLER_0_94_679 VPWR VGND VPWR VGND sky130_ef_sc_hd__decap_12
XPHY_148 VGND VGND VPWR VPWR sky130_fd_sc_hd__decap_3
XPHY_137 VGND VGND VPWR VPWR sky130_fd_sc_hd__decap_3
XFILLER_0_66_348 VGND VGND VPWR VPWR sky130_fd_sc_hd__decap_6
XPHY_126 VGND VGND VPWR VPWR sky130_fd_sc_hd__decap_3
XFILLER_0_19_220 VGND VGND VPWR VPWR sky130_fd_sc_hd__decap_4
XPHY_159 VGND VGND VPWR VPWR sky130_fd_sc_hd__decap_3
X_7729_ clknet_leaf_74_clk _0635_ net13 VGND VGND VPWR VPWR u_pe_array.g_pe_row\[0\].g_pe_col\[2\].u_pe.psum_out\[7\]
+ sky130_fd_sc_hd__dfrtp_4
XFILLER_0_47_573 VGND VGND VPWR VPWR sky130_fd_sc_hd__fill_2
XFILLER_0_105_601 VGND VGND VPWR VPWR sky130_fd_sc_hd__fill_1
XFILLER_0_47_595 VGND VGND VPWR VPWR sky130_fd_sc_hd__decap_6
XFILLER_0_22_407 VPWR VGND VPWR VGND sky130_ef_sc_hd__decap_12
XFILLER_0_62_587 VGND VGND VPWR VPWR sky130_fd_sc_hd__fill_1
XFILLER_0_104_188 VGND VGND VPWR VPWR sky130_fd_sc_hd__decap_8
XFILLER_0_97_462 VGND VGND VPWR VPWR sky130_fd_sc_hd__fill_1
XFILLER_0_69_131 VGND VGND VPWR VPWR sky130_fd_sc_hd__decap_8
Xmax_cap62 _1118_ VGND VGND VPWR VPWR net62 sky130_fd_sc_hd__clkbuf_8
XFILLER_0_97_484 VGND VGND VPWR VPWR sky130_fd_sc_hd__fill_1
XPHY_6 VGND VGND VPWR VPWR sky130_fd_sc_hd__decap_3
XFILLER_0_84_134 VGND VGND VPWR VPWR sky130_fd_sc_hd__decap_6
XFILLER_0_69_197 VGND VGND VPWR VPWR sky130_fd_sc_hd__decap_8
XFILLER_0_57_337 VGND VGND VPWR VPWR sky130_fd_sc_hd__fill_2
XFILLER_0_72_307 VGND VGND VPWR VPWR sky130_fd_sc_hd__fill_1
Xclkbuf_leaf_104_clk clknet_3_0__leaf_clk VGND VGND VPWR VPWR clknet_leaf_104_clk
+ sky130_fd_sc_hd__clkbuf_16
XFILLER_0_25_201 VPWR VGND VPWR VGND sky130_ef_sc_hd__decap_12
XFILLER_0_108_483 VPWR VGND VPWR VGND sky130_ef_sc_hd__decap_12
XFILLER_0_80_362 VGND VGND VPWR VPWR sky130_fd_sc_hd__fill_2
XFILLER_0_4_139 VGND VGND VPWR VPWR sky130_fd_sc_hd__fill_1
XFILLER_0_53_554 VGND VGND VPWR VPWR sky130_fd_sc_hd__decap_6
XFILLER_0_7_27 VPWR VGND VPWR VGND sky130_ef_sc_hd__decap_12
Xhold308 _0131_ VGND VGND VPWR VPWR net382 sky130_fd_sc_hd__dlygate4sd3_1
XFILLER_0_53_587 VGND VGND VPWR VPWR sky130_fd_sc_hd__fill_1
X_4390_ _1497_ _1498_ VGND VGND VPWR VPWR _1499_ sky130_fd_sc_hd__xnor2_1
XFILLER_0_21_440 VGND VGND VPWR VPWR sky130_fd_sc_hd__decap_8
Xhold319 _0217_ VGND VGND VPWR VPWR net393 sky130_fd_sc_hd__dlygate4sd3_1
XFILLER_0_0_345 VGND VGND VPWR VPWR sky130_fd_sc_hd__fill_1
XFILLER_0_0_334 VGND VGND VPWR VPWR sky130_fd_sc_hd__fill_2
XFILLER_0_0_389 VGND VGND VPWR VPWR sky130_fd_sc_hd__decap_3
XTAP_602 VGND VPWR sky130_fd_sc_hd__tapvpwrvgnd_1
XTAP_613 VGND VPWR sky130_fd_sc_hd__tapvpwrvgnd_1
XTAP_624 VGND VPWR sky130_fd_sc_hd__tapvpwrvgnd_1
X_6060_ u_pe_array.g_pe_row\[1\].g_pe_col\[0\].u_pe.psum_out\[8\] _1865_ VGND VGND
+ VPWR VPWR _2809_ sky130_fd_sc_hd__nand2_1
XTAP_635 VGND VPWR sky130_fd_sc_hd__tapvpwrvgnd_1
XTAP_646 VGND VPWR sky130_fd_sc_hd__tapvpwrvgnd_1
XTAP_657 VGND VPWR sky130_fd_sc_hd__tapvpwrvgnd_1
XTAP_668 VGND VPWR sky130_fd_sc_hd__tapvpwrvgnd_1
X_5011_ u_pe_array.g_pe_row\[2\].g_pe_col\[1\].u_pe.psum_out\[11\] _1105_ VGND VGND
+ VPWR VPWR _1988_ sky130_fd_sc_hd__and2b_1
XTAP_679 VGND VPWR sky130_fd_sc_hd__tapvpwrvgnd_1
XFILLER_0_108_41 VPWR VGND VPWR VGND sky130_ef_sc_hd__decap_12
XFILLER_0_84_78 VGND VGND VPWR VPWR sky130_fd_sc_hd__decap_6
XFILLER_0_108_85 VPWR VGND VPWR VGND sky130_ef_sc_hd__decap_12
XFILLER_0_88_440 VGND VGND VPWR VPWR sky130_fd_sc_hd__decap_6
X_6962_ u_pe_array.u_fifo1.rd_ptr\[2\] _3466_ VGND VGND VPWR VPWR _3468_ sky130_fd_sc_hd__and2_1
X_5913_ u_pe_array.u_fifo1.rd_ptr\[1\] u_pe_array.u_fifo1.rd_ptr\[0\] _2682_ VGND
+ VGND VPWR VPWR _2683_ sky130_fd_sc_hd__and3b_2
X_6893_ _3427_ VGND VGND VPWR VPWR _0768_ sky130_fd_sc_hd__clkbuf_1
XFILLER_0_118_203 VGND VGND VPWR VPWR sky130_fd_sc_hd__decap_3
X_5844_ _2637_ VGND VGND VPWR VPWR _0509_ sky130_fd_sc_hd__clkbuf_1
XFILLER_0_48_359 VGND VGND VPWR VPWR sky130_fd_sc_hd__decap_4
XFILLER_0_118_225 VPWR VGND VPWR VGND sky130_ef_sc_hd__decap_12
XFILLER_0_29_573 VGND VGND VPWR VPWR sky130_fd_sc_hd__decap_8
XFILLER_0_33_93 VPWR VGND VPWR VGND sky130_ef_sc_hd__decap_12
X_5775_ _2570_ _2575_ _2578_ VGND VGND VPWR VPWR _2579_ sky130_fd_sc_hd__o21bai_1
XFILLER_0_99_3 VPWR VGND VPWR VGND sky130_ef_sc_hd__decap_12
X_7514_ clknet_leaf_68_clk _0420_ net72 VGND VGND VPWR VPWR u_pe_array.act_from_right\[5\]\[8\]
+ sky130_fd_sc_hd__dfrtp_1
X_4726_ u_pe_array.g_pe_row\[2\].g_pe_col\[2\].u_pe.act_val\[1\] u_pe_array.g_pe_row\[2\].g_pe_col\[2\].u_pe.w_out\[0\]
+ VGND VGND VPWR VPWR _1754_ sky130_fd_sc_hd__nand2_1
XFILLER_0_16_245 VGND VGND VPWR VPWR sky130_fd_sc_hd__fill_1
X_7445_ clknet_leaf_36_clk net329 net951 VGND VGND VPWR VPWR u_pe_array.g_pe_row\[2\].g_pe_col\[0\].u_pe.move_reg\[8\]
+ sky130_fd_sc_hd__dfrtp_1
XFILLER_0_44_587 VGND VGND VPWR VPWR sky130_fd_sc_hd__fill_1
X_4657_ u_pe_array.g_pe_row\[2\].g_pe_col\[3\].u_pe.psum_out\[10\] _1702_ _1709_ _1713_
+ VGND VGND VPWR VPWR _1716_ sky130_fd_sc_hd__a2bb2o_1
XFILLER_0_114_475 VGND VGND VPWR VPWR sky130_fd_sc_hd__fill_1
XFILLER_0_3_161 VGND VGND VPWR VPWR sky130_fd_sc_hd__decap_6
X_7376_ clknet_leaf_104_clk _0282_ net944 VGND VGND VPWR VPWR u_pe_array.g_pe_row\[2\].g_pe_col\[2\].u_pe.psum_out\[8\]
+ sky130_fd_sc_hd__dfrtp_2
X_3608_ u_fsm.state\[1\] _0853_ VGND VGND VPWR VPWR _0905_ sky130_fd_sc_hd__nor2_1
Xhold820 u_pe_array.g_pe_row\[1\].g_pe_col\[2\].u_pe.act_val\[1\] VGND VGND VPWR VPWR
+ net894 sky130_fd_sc_hd__dlygate4sd3_1
Xhold831 u_pe_array.g_pe_row\[2\].g_pe_col\[1\].u_pe.psum_out\[12\] VGND VGND VPWR
+ VPWR net905 sky130_fd_sc_hd__dlygate4sd3_1
Xhold842 u_pe_array.g_pe_row\[3\].g_pe_col\[2\].u_pe.psum_out\[2\] VGND VGND VPWR
+ VPWR net916 sky130_fd_sc_hd__dlygate4sd3_1
X_4588_ _1652_ _1653_ VGND VGND VPWR VPWR _1654_ sky130_fd_sc_hd__and2_1
X_6327_ u_pe_array.g_pe_row\[0\].g_pe_col\[2\].u_pe.act_val\[0\] VGND VGND VPWR VPWR
+ _3000_ sky130_fd_sc_hd__inv_2
Xhold864 u_pe_array.act_from_right\[13\]\[12\] VGND VGND VPWR VPWR net938 sky130_fd_sc_hd__dlygate4sd3_1
Xhold853 u_pe_array.g_pe_row\[1\].g_pe_col\[0\].u_pe.psum_out\[7\] VGND VGND VPWR
+ VPWR net927 sky130_fd_sc_hd__dlygate4sd3_1
XFILLER_0_101_169 VGND VGND VPWR VPWR sky130_fd_sc_hd__decap_6
XFILLER_0_12_484 VGND VGND VPWR VPWR sky130_fd_sc_hd__decap_8
XFILLER_0_110_681 VPWR VGND VPWR VGND sky130_ef_sc_hd__decap_12
X_6258_ _1999_ u_pe_array.g_pe_row\[0\].g_pe_col\[3\].u_pe.psum_out\[11\] VGND VGND
+ VPWR VPWR _2963_ sky130_fd_sc_hd__and2b_1
X_6189_ _2892_ _2900_ VGND VGND VPWR VPWR _2901_ sky130_fd_sc_hd__nor2_1
X_5209_ net425 _1882_ _2132_ _2137_ VGND VGND VPWR VPWR _0374_ sky130_fd_sc_hd__a22o_1
XFILLER_0_98_204 VGND VGND VPWR VPWR sky130_fd_sc_hd__decap_8
XFILLER_0_67_602 VPWR VGND VPWR VGND sky130_ef_sc_hd__decap_12
XFILLER_0_66_134 VGND VGND VPWR VPWR sky130_fd_sc_hd__fill_1
XFILLER_0_39_337 VPWR VGND VPWR VGND sky130_ef_sc_hd__decap_12
XFILLER_0_109_225 VGND VGND VPWR VPWR sky130_fd_sc_hd__decap_6
XFILLER_0_81_159 VGND VGND VPWR VPWR sky130_fd_sc_hd__fill_1
XFILLER_0_105_453 VGND VGND VPWR VPWR sky130_fd_sc_hd__fill_1
XFILLER_0_22_215 VPWR VGND VPWR VGND sky130_ef_sc_hd__decap_12
XFILLER_0_38_27 VGND VGND VPWR VPWR sky130_fd_sc_hd__fill_1
XFILLER_0_97_281 VPWR VGND VPWR VGND sky130_ef_sc_hd__decap_12
XFILLER_0_85_443 VGND VGND VPWR VPWR sky130_fd_sc_hd__decap_4
XFILLER_0_58_668 VGND VGND VPWR VPWR sky130_fd_sc_hd__decap_4
XFILLER_0_70_58 VPWR VGND VPWR VGND sky130_ef_sc_hd__decap_12
X_3890_ u_pe_array.g_pe_row\[3\].g_pe_col\[2\].u_pe.psum_out\[4\] _1108_ _1110_ _1130_
+ VGND VGND VPWR VPWR _1131_ sky130_fd_sc_hd__o211a_2
XFILLER_0_73_638 VGND VGND VPWR VPWR sky130_fd_sc_hd__decap_8
XFILLER_0_115_217 VGND VGND VPWR VPWR sky130_fd_sc_hd__decap_6
X_5560_ _2233_ _2407_ _2408_ _2173_ net557 VGND VGND VPWR VPWR _0454_ sky130_fd_sc_hd__a32o_1
XFILLER_0_81_671 VGND VGND VPWR VPWR sky130_fd_sc_hd__fill_1
X_5491_ u_pe_array.u_fifo2.buffer\[3\]\[2\] _2331_ _2332_ u_pe_array.u_fifo2.buffer\[2\]\[2\]
+ _2353_ VGND VGND VPWR VPWR _2354_ sky130_fd_sc_hd__a221o_1
X_4511_ net257 _1301_ _1305_ _1603_ VGND VGND VPWR VPWR _0210_ sky130_fd_sc_hd__a22o_1
XFILLER_0_111_412 VGND VGND VPWR VPWR sky130_fd_sc_hd__decap_6
XFILLER_0_110_53 VPWR VGND VPWR VGND sky130_ef_sc_hd__decap_12
XFILLER_0_80_192 VGND VGND VPWR VPWR sky130_fd_sc_hd__fill_1
X_7230_ clknet_leaf_13_clk net180 net942 VGND VGND VPWR VPWR u_pe_array.g_pe_row\[3\].g_pe_col\[1\].u_pe.move_reg\[11\]
+ sky130_fd_sc_hd__dfrtp_1
X_4442_ _1541_ _1546_ VGND VGND VPWR VPWR _1547_ sky130_fd_sc_hd__or2_1
Xhold105 u_pe_array.act_from_right\[13\]\[11\] VGND VGND VPWR VPWR net179 sky130_fd_sc_hd__dlygate4sd3_1
Xhold116 u_pe_array.act_from_up\[6\]\[6\] VGND VGND VPWR VPWR net190 sky130_fd_sc_hd__dlymetal6s2s_1
Xhold149 _0709_ VGND VGND VPWR VPWR net223 sky130_fd_sc_hd__dlygate4sd3_1
Xhold138 u_pe_array.act_from_up\[12\]\[7\] VGND VGND VPWR VPWR net212 sky130_fd_sc_hd__dlygate4sd3_1
Xhold127 _0447_ VGND VGND VPWR VPWR net201 sky130_fd_sc_hd__dlygate4sd3_1
XFILLER_0_110_97 VGND VGND VPWR VPWR sky130_fd_sc_hd__decap_6
X_4373_ u_pe_array.g_pe_row\[3\].g_pe_col\[0\].u_pe.act_val\[0\] u_pe_array.g_pe_row\[3\].g_pe_col\[0\].u_pe.w_out\[0\]
+ u_pe_array.g_pe_row\[3\].g_pe_col\[0\].u_pe.psum_out\[0\] VGND VGND VPWR VPWR _1484_
+ sky130_fd_sc_hd__a21o_1
XFILLER_0_0_153 VPWR VGND VPWR VGND sky130_ef_sc_hd__decap_12
XFILLER_0_1_665 VGND VGND VPWR VPWR sky130_fd_sc_hd__decap_6
XFILLER_0_21_281 VGND VGND VPWR VPWR sky130_fd_sc_hd__decap_6
X_7161_ clknet_leaf_96_clk _0067_ net945 VGND VGND VPWR VPWR u_pe_array.act_from_right\[13\]\[9\]
+ sky130_fd_sc_hd__dfrtp_1
XFILLER_0_95_55 VGND VGND VPWR VPWR sky130_fd_sc_hd__fill_1
X_6112_ u_pe_array.g_pe_row\[0\].g_pe_col\[3\].u_pe.psum_out\[4\] u_pe_array.g_pe_row\[0\].g_pe_col\[3\].u_pe.act_val\[4\]
+ _2844_ VGND VGND VPWR VPWR _2850_ sky130_fd_sc_hd__mux2_1
XTAP_410 VGND VPWR sky130_fd_sc_hd__tapvpwrvgnd_1
XFILLER_0_0_197 VPWR VGND VPWR VGND sky130_ef_sc_hd__decap_12
XFILLER_0_0_175 VPWR VGND VPWR VGND sky130_ef_sc_hd__decap_12
XTAP_432 VGND VPWR sky130_fd_sc_hd__tapvpwrvgnd_1
XTAP_421 VGND VPWR sky130_fd_sc_hd__tapvpwrvgnd_1
X_7092_ clknet_leaf_88_clk u_fsm.next_state\[1\] net948 VGND VGND VPWR VPWR u_fsm.state\[1\]
+ sky130_fd_sc_hd__dfrtp_4
XTAP_443 VGND VPWR sky130_fd_sc_hd__tapvpwrvgnd_1
XTAP_454 VGND VPWR sky130_fd_sc_hd__tapvpwrvgnd_1
XTAP_465 VGND VPWR sky130_fd_sc_hd__tapvpwrvgnd_1
XTAP_476 VGND VPWR sky130_fd_sc_hd__tapvpwrvgnd_1
X_6043_ _2787_ _2792_ VGND VGND VPWR VPWR _2794_ sky130_fd_sc_hd__nand2_1
XTAP_487 VGND VPWR sky130_fd_sc_hd__tapvpwrvgnd_1
XTAP_498 VGND VPWR sky130_fd_sc_hd__tapvpwrvgnd_1
XFILLER_0_28_60 VGND VGND VPWR VPWR sky130_fd_sc_hd__fill_1
XFILLER_0_14_3 VPWR VGND VPWR VGND sky130_ef_sc_hd__decap_12
XTAP_1609 VGND VPWR sky130_fd_sc_hd__tapvpwrvgnd_1
X_6945_ _3351_ _3455_ _3456_ VGND VGND VPWR VPWR _3457_ sky130_fd_sc_hd__and3_1
XFILLER_0_91_413 VPWR VGND VPWR VGND sky130_ef_sc_hd__decap_12
XFILLER_0_63_104 VGND VGND VPWR VPWR sky130_fd_sc_hd__decap_8
XFILLER_0_8_220 VPWR VGND VPWR VGND sky130_ef_sc_hd__decap_12
X_6876_ net683 _0922_ _3415_ VGND VGND VPWR VPWR _3418_ sky130_fd_sc_hd__mux2_1
X_5827_ net697 _2586_ _2625_ _0978_ VGND VGND VPWR VPWR _0504_ sky130_fd_sc_hd__a22o_1
XFILLER_0_17_532 VGND VGND VPWR VPWR sky130_fd_sc_hd__fill_2
XFILLER_0_29_381 VGND VGND VPWR VPWR sky130_fd_sc_hd__decap_8
X_5758_ _2233_ _2562_ _2563_ _2173_ net713 VGND VGND VPWR VPWR _0497_ sky130_fd_sc_hd__a32o_1
XFILLER_0_106_217 VGND VGND VPWR VPWR sky130_fd_sc_hd__decap_6
XFILLER_0_17_543 VGND VGND VPWR VPWR sky130_fd_sc_hd__fill_1
X_4709_ u_pe_array.g_pe_row\[2\].g_pe_col\[2\].u_pe.act_val\[2\] _1605_ _1611_ net173
+ VGND VGND VPWR VPWR _0263_ sky130_fd_sc_hd__a22o_1
X_7428_ clknet_leaf_99_clk _0334_ net951 VGND VGND VPWR VPWR u_pe_array.act_from_up\[12\]\[4\]
+ sky130_fd_sc_hd__dfrtp_1
X_5689_ u_pe_array.act_from_right\[5\]\[4\] u_pe_array.act_from_left\[5\]\[4\] _0963_
+ VGND VGND VPWR VPWR _2509_ sky130_fd_sc_hd__mux2_2
Xhold650 u_pe_array.g_pe_row\[0\].g_pe_col\[0\].u_pe.psum_out\[11\] VGND VGND VPWR
+ VPWR net724 sky130_fd_sc_hd__dlygate4sd3_1
Xhold672 u_pe_array.u_fifo2.wr_ptr\[0\] VGND VGND VPWR VPWR net746 sky130_fd_sc_hd__dlygate4sd3_1
X_7359_ clknet_leaf_1_clk _0265_ net944 VGND VGND VPWR VPWR u_pe_array.g_pe_row\[2\].g_pe_col\[2\].u_pe.act_val\[4\]
+ sky130_fd_sc_hd__dfrtp_2
Xhold661 u_pe_array.g_pe_row\[1\].g_pe_col\[2\].u_pe.psum_out\[1\] VGND VGND VPWR
+ VPWR net735 sky130_fd_sc_hd__dlygate4sd3_1
Xhold694 u_pe_array.g_pe_row\[2\].g_pe_col\[0\].u_pe.psum_out\[5\] VGND VGND VPWR
+ VPWR net768 sky130_fd_sc_hd__dlygate4sd3_1
Xhold683 u_pe_array.act_from_left\[15\]\[1\] VGND VGND VPWR VPWR net757 sky130_fd_sc_hd__dlygate4sd3_1
XFILLER_0_99_513 VPWR VGND VPWR VGND sky130_ef_sc_hd__decap_12
XFILLER_0_99_502 VGND VGND VPWR VPWR sky130_fd_sc_hd__fill_2
XFILLER_0_55_605 VGND VGND VPWR VPWR sky130_fd_sc_hd__fill_1
XFILLER_0_39_167 VGND VGND VPWR VPWR sky130_fd_sc_hd__fill_1
XFILLER_0_94_284 VGND VGND VPWR VPWR sky130_fd_sc_hd__decap_3
XFILLER_0_54_104 VGND VGND VPWR VPWR sky130_fd_sc_hd__fill_1
XFILLER_0_48_690 VGND VGND VPWR VPWR sky130_fd_sc_hd__fill_2
Xload_slew6 net69 VGND VGND VPWR VPWR net945 sky130_fd_sc_hd__buf_12
XFILLER_0_23_502 VGND VGND VPWR VPWR sky130_fd_sc_hd__fill_2
XFILLER_0_35_384 VGND VGND VPWR VPWR sky130_fd_sc_hd__decap_8
XFILLER_0_112_209 VPWR VGND VPWR VGND sky130_ef_sc_hd__decap_12
XFILLER_0_2_418 VGND VGND VPWR VPWR sky130_fd_sc_hd__fill_2
X_4991_ _1962_ _1964_ _1969_ VGND VGND VPWR VPWR _1971_ sky130_fd_sc_hd__o21a_1
XFILLER_0_105_31 VPWR VGND VPWR VGND sky130_ef_sc_hd__decap_12
X_6730_ _3299_ _3309_ u_pe_array.g_pe_row\[0\].g_pe_col\[0\].u_pe.psum_out\[7\] _3310_
+ VGND VGND VPWR VPWR _3315_ sky130_fd_sc_hd__o2bb2a_1
XFILLER_0_81_57 VPWR VGND VPWR VGND sky130_ef_sc_hd__decap_12
X_3942_ _0983_ _1141_ _1166_ net112 VGND VGND VPWR VPWR _0078_ sky130_fd_sc_hd__a22o_1
X_6661_ _3244_ _3250_ VGND VGND VPWR VPWR _3253_ sky130_fd_sc_hd__nand2_1
X_3873_ _1117_ VGND VGND VPWR VPWR _0058_ sky130_fd_sc_hd__clkbuf_1
X_6592_ _3210_ _3215_ VGND VGND VPWR VPWR _3216_ sky130_fd_sc_hd__and2_1
X_5612_ u_pe_array.g_pe_row\[1\].g_pe_col\[2\].u_pe.psum_out\[8\] _1597_ VGND VGND
+ VPWR VPWR _2456_ sky130_fd_sc_hd__or2_1
XFILLER_0_5_223 VGND VGND VPWR VPWR sky130_fd_sc_hd__fill_1
X_5543_ _2384_ _2385_ VGND VGND VPWR VPWR _2393_ sky130_fd_sc_hd__and2_1
XFILLER_0_26_384 VGND VGND VPWR VPWR sky130_fd_sc_hd__decap_3
X_5474_ u_pe_array.u_fifo2.buffer\[8\]\[0\] _2322_ _2325_ _2338_ _0857_ VGND VGND
+ VPWR VPWR _2339_ sky130_fd_sc_hd__a221o_1
X_7213_ clknet_leaf_15_clk _0119_ net942 VGND VGND VPWR VPWR u_pe_array.act_from_down\[9\]\[7\]
+ sky130_fd_sc_hd__dfrtp_1
X_4425_ u_pe_array.g_pe_row\[3\].g_pe_col\[0\].u_pe.act_val\[4\] u_pe_array.g_pe_row\[3\].g_pe_col\[0\].u_pe.w_out\[0\]
+ _1517_ VGND VGND VPWR VPWR _1531_ sky130_fd_sc_hd__and3_1
X_7144_ clknet_leaf_20_clk _0050_ net70 VGND VGND VPWR VPWR u_pe_array.g_pe_row\[3\].g_pe_col\[3\].u_pe.psum_out\[7\]
+ sky130_fd_sc_hd__dfrtp_4
X_4356_ net602 _1301_ _1305_ _1478_ VGND VGND VPWR VPWR _0180_ sky130_fd_sc_hd__a22o_1
XFILLER_0_1_473 VPWR VGND VPWR VGND sky130_ef_sc_hd__decap_12
XTAP_240 VGND VPWR sky130_fd_sc_hd__tapvpwrvgnd_1
XTAP_251 VGND VPWR sky130_fd_sc_hd__tapvpwrvgnd_1
X_4287_ u_pe_array.g_pe_row\[3\].g_pe_col\[0\].u_pe.act_val\[2\] VGND VGND VPWR VPWR
+ _1435_ sky130_fd_sc_hd__inv_2
XTAP_273 VGND VPWR sky130_fd_sc_hd__tapvpwrvgnd_1
XTAP_262 VGND VPWR sky130_fd_sc_hd__tapvpwrvgnd_1
XTAP_284 VGND VPWR sky130_fd_sc_hd__tapvpwrvgnd_1
X_7075_ _3534_ VGND VGND VPWR VPWR _0843_ sky130_fd_sc_hd__clkbuf_1
XTAP_295 VGND VPWR sky130_fd_sc_hd__tapvpwrvgnd_1
X_6026_ u_pe_array.g_pe_row\[1\].g_pe_col\[0\].u_pe.psum_out\[4\] _2765_ _2777_ VGND
+ VGND VPWR VPWR _2778_ sky130_fd_sc_hd__a21oi_2
XTAP_1406 VGND VPWR sky130_fd_sc_hd__tapvpwrvgnd_1
Xclkbuf_leaf_93_clk clknet_3_4__leaf_clk VGND VGND VPWR VPWR clknet_leaf_93_clk sky130_fd_sc_hd__clkbuf_16
XTAP_1439 VGND VPWR sky130_fd_sc_hd__tapvpwrvgnd_1
XTAP_1428 VGND VPWR sky130_fd_sc_hd__tapvpwrvgnd_1
XTAP_1417 VGND VPWR sky130_fd_sc_hd__tapvpwrvgnd_1
XFILLER_0_49_443 VGND VGND VPWR VPWR sky130_fd_sc_hd__decap_4
X_6928_ _3447_ VGND VGND VPWR VPWR _0783_ sky130_fd_sc_hd__clkbuf_1
X_6859_ net593 _0911_ _3408_ VGND VGND VPWR VPWR _3409_ sky130_fd_sc_hd__mux2_1
XFILLER_0_36_137 VGND VGND VPWR VPWR sky130_fd_sc_hd__decap_3
XFILLER_0_32_321 VGND VGND VPWR VPWR sky130_fd_sc_hd__decap_3
XFILLER_0_102_253 VPWR VGND VPWR VGND sky130_ef_sc_hd__decap_12
Xhold480 u_pe_array.g_pe_row\[3\].g_pe_col\[0\].u_pe.psum_out\[0\] VGND VGND VPWR
+ VPWR net554 sky130_fd_sc_hd__dlygate4sd3_1
XFILLER_0_3_3 VPWR VGND VPWR VGND sky130_ef_sc_hd__decap_12
Xhold491 u_pe_array.g_pe_row\[0\].g_pe_col\[0\].u_pe.psum_out\[4\] VGND VGND VPWR
+ VPWR net565 sky130_fd_sc_hd__dlygate4sd3_1
XFILLER_0_99_321 VGND VGND VPWR VPWR sky130_fd_sc_hd__fill_1
Xclkbuf_leaf_84_clk clknet_3_4__leaf_clk VGND VGND VPWR VPWR clknet_leaf_84_clk sky130_fd_sc_hd__clkbuf_16
XFILLER_0_55_468 VGND VGND VPWR VPWR sky130_fd_sc_hd__fill_1
XFILLER_0_55_446 VGND VGND VPWR VPWR sky130_fd_sc_hd__fill_2
XFILLER_0_82_287 VGND VGND VPWR VPWR sky130_fd_sc_hd__fill_1
XFILLER_0_113_518 VGND VGND VPWR VPWR sky130_fd_sc_hd__fill_1
XFILLER_0_42_129 VGND VGND VPWR VPWR sky130_fd_sc_hd__decap_4
XFILLER_0_23_365 VGND VGND VPWR VPWR sky130_fd_sc_hd__decap_8
X_4210_ _1367_ _1106_ u_pe_array.g_pe_row\[3\].g_pe_col\[1\].u_pe.psum_out\[6\] VGND
+ VGND VPWR VPWR _1369_ sky130_fd_sc_hd__a21o_1
X_5190_ _2111_ _2115_ _2122_ _2124_ _2121_ VGND VGND VPWR VPWR _2125_ sky130_fd_sc_hd__a32o_1
X_4141_ net255 u_fsm.psum_shift_en _1175_ u_pe_array.g_pe_row\[3\].g_pe_col\[1\].u_pe.move_reg\[9\]
+ VGND VGND VPWR VPWR _0134_ sky130_fd_sc_hd__a22o_1
X_4072_ u_pe_array.g_pe_row\[3\].g_pe_col\[2\].u_pe.psum_out\[10\] _0934_ VGND VGND
+ VPWR VPWR _1268_ sky130_fd_sc_hd__or2_1
X_7900_ clknet_leaf_81_clk _0805_ VGND VGND VPWR VPWR u_pe_array.u_fifo1.buffer\[0\]\[2\]
+ sky130_fd_sc_hd__dfxtp_1
XFILLER_0_116_41 VPWR VGND VPWR VGND sky130_ef_sc_hd__decap_12
Xclkbuf_leaf_75_clk clknet_3_5__leaf_clk VGND VGND VPWR VPWR clknet_leaf_75_clk sky130_fd_sc_hd__clkbuf_16
XFILLER_0_116_85 VPWR VGND VPWR VGND sky130_ef_sc_hd__decap_12
X_7831_ clknet_leaf_85_clk _0736_ net948 VGND VGND VPWR VPWR u_pe_array.u_fifo2.rd_ptr\[3\]
+ sky130_fd_sc_hd__dfrtp_4
X_4974_ u_pe_array.g_pe_row\[2\].g_pe_col\[1\].u_pe.psum_out\[7\] _1105_ VGND VGND
+ VPWR VPWR _1955_ sky130_fd_sc_hd__or2_1
XFILLER_0_93_519 VGND VGND VPWR VPWR sky130_fd_sc_hd__fill_2
X_7762_ clknet_leaf_42_clk net282 net946 VGND VGND VPWR VPWR u_pe_array.g_pe_row\[0\].g_pe_col\[1\].u_pe.move_reg\[12\]
+ sky130_fd_sc_hd__dfrtp_1
XFILLER_0_86_560 VGND VGND VPWR VPWR sky130_fd_sc_hd__decap_4
X_6713_ _3297_ _3298_ _3296_ _3287_ VGND VGND VPWR VPWR _3300_ sky130_fd_sc_hd__o211a_1
X_7693_ clknet_leaf_63_clk _0599_ net74 VGND VGND VPWR VPWR u_pe_array.g_pe_row\[0\].g_pe_col\[3\].u_pe.psum_out\[12\]
+ sky130_fd_sc_hd__dfrtp_1
X_3925_ _1157_ VGND VGND VPWR VPWR _0070_ sky130_fd_sc_hd__clkbuf_1
X_6644_ u_pe_array.act_from_right\[0\]\[7\] _0866_ _0940_ net287 VGND VGND VPWR VPWR
+ _0704_ sky130_fd_sc_hd__a22o_1
XFILLER_0_18_148 VGND VGND VPWR VPWR sky130_fd_sc_hd__fill_1
X_3856_ net679 _1007_ _1103_ _1021_ VGND VGND VPWR VPWR _0055_ sky130_fd_sc_hd__a22o_1
XFILLER_0_41_93 VPWR VGND VPWR VGND sky130_ef_sc_hd__decap_12
XFILLER_0_116_356 VGND VGND VPWR VPWR sky130_fd_sc_hd__decap_8
X_6575_ _3192_ _3194_ _3199_ VGND VGND VPWR VPWR _3201_ sky130_fd_sc_hd__o21a_1
XFILLER_0_81_3 VPWR VGND VPWR VGND sky130_ef_sc_hd__decap_12
X_3787_ _1028_ _1031_ _1040_ VGND VGND VPWR VPWR _1042_ sky130_fd_sc_hd__o21ai_1
XFILLER_0_61_449 VGND VGND VPWR VPWR sky130_fd_sc_hd__fill_2
XFILLER_0_6_587 VGND VGND VPWR VPWR sky130_fd_sc_hd__fill_1
XFILLER_0_42_630 VPWR VGND VPWR VGND sky130_ef_sc_hd__decap_12
X_5526_ net206 _2016_ _1883_ u_pe_array.g_pe_row\[1\].g_pe_col\[2\].u_pe.move_reg\[12\]
+ VGND VGND VPWR VPWR _0450_ sky130_fd_sc_hd__a22o_1
XFILLER_0_14_365 VGND VGND VPWR VPWR sky130_fd_sc_hd__fill_2
XFILLER_0_41_140 VGND VGND VPWR VPWR sky130_fd_sc_hd__decap_4
XFILLER_0_42_674 VGND VGND VPWR VPWR sky130_fd_sc_hd__decap_8
X_5457_ u_pe_array.u_fifo2.rd_ptr\[2\] _2321_ u_pe_array.u_fifo2.rd_ptr\[3\] VGND
+ VGND VPWR VPWR _2322_ sky130_fd_sc_hd__nor3b_4
X_4408_ net830 _1273_ _1515_ _1021_ VGND VGND VPWR VPWR _0195_ sky130_fd_sc_hd__a22o_1
X_5388_ _2277_ VGND VGND VPWR VPWR _0413_ sky130_fd_sc_hd__clkbuf_1
X_7127_ clknet_leaf_18_clk _0033_ net943 VGND VGND VPWR VPWR u_pe_array.g_pe_row\[3\].g_pe_col\[3\].u_pe.act_val\[3\]
+ sky130_fd_sc_hd__dfrtp_1
X_4339_ _1440_ net878 _1158_ VGND VGND VPWR VPWR _1473_ sky130_fd_sc_hd__mux2_1
XFILLER_0_5_93 VPWR VGND VPWR VGND sky130_ef_sc_hd__decap_12
X_7058_ net587 _3358_ _3521_ VGND VGND VPWR VPWR _3525_ sky130_fd_sc_hd__mux2_1
X_6009_ _2751_ _2759_ _2758_ VGND VGND VPWR VPWR _2762_ sky130_fd_sc_hd__a21oi_1
Xclkbuf_leaf_66_clk clknet_3_6__leaf_clk VGND VGND VPWR VPWR clknet_leaf_66_clk sky130_fd_sc_hd__clkbuf_16
XFILLER_0_96_324 VPWR VGND VPWR VGND sky130_ef_sc_hd__decap_12
XTAP_1214 VGND VPWR sky130_fd_sc_hd__tapvpwrvgnd_1
XTAP_1203 VGND VPWR sky130_fd_sc_hd__tapvpwrvgnd_1
XTAP_1247 VGND VPWR sky130_fd_sc_hd__tapvpwrvgnd_1
XTAP_1236 VGND VPWR sky130_fd_sc_hd__tapvpwrvgnd_1
XTAP_1225 VGND VPWR sky130_fd_sc_hd__tapvpwrvgnd_1
XFILLER_0_49_240 VGND VGND VPWR VPWR sky130_fd_sc_hd__decap_8
XTAP_1269 VGND VPWR sky130_fd_sc_hd__tapvpwrvgnd_1
XTAP_1258 VGND VPWR sky130_fd_sc_hd__tapvpwrvgnd_1
XFILLER_0_64_210 VGND VGND VPWR VPWR sky130_fd_sc_hd__fill_2
XFILLER_0_107_345 VGND VGND VPWR VPWR sky130_fd_sc_hd__decap_3
XFILLER_0_107_356 VPWR VGND VPWR VGND sky130_ef_sc_hd__decap_12
XFILLER_0_60_471 VGND VGND VPWR VPWR sky130_fd_sc_hd__decap_4
XFILLER_0_20_302 VGND VGND VPWR VPWR sky130_fd_sc_hd__decap_6
XFILLER_0_33_685 VPWR VGND VPWR VGND sky130_ef_sc_hd__decap_12
XFILLER_0_32_195 VGND VGND VPWR VPWR sky130_fd_sc_hd__fill_1
XFILLER_0_46_27 VGND VGND VPWR VPWR sky130_fd_sc_hd__fill_1
Xclkbuf_leaf_57_clk clknet_3_7__leaf_clk VGND VGND VPWR VPWR clknet_leaf_57_clk sky130_fd_sc_hd__clkbuf_16
XFILLER_0_99_184 VGND VGND VPWR VPWR sky130_fd_sc_hd__decap_6
X_3710_ _0973_ VGND VGND VPWR VPWR _0039_ sky130_fd_sc_hd__clkbuf_1
X_4690_ net578 _1732_ _1735_ _1740_ VGND VGND VPWR VPWR _0252_ sky130_fd_sc_hd__a22o_1
XFILLER_0_113_304 VGND VGND VPWR VPWR sky130_fd_sc_hd__fill_2
X_3641_ _0929_ VGND VGND VPWR VPWR _0014_ sky130_fd_sc_hd__clkbuf_1
XFILLER_0_102_65 VPWR VGND VPWR VGND sky130_ef_sc_hd__decap_12
XFILLER_0_24_641 VGND VGND VPWR VPWR sky130_fd_sc_hd__decap_3
X_3572_ _0853_ _0874_ VGND VGND VPWR VPWR _0879_ sky130_fd_sc_hd__nand2_4
X_6360_ _3029_ _3030_ VGND VGND VPWR VPWR _3031_ sky130_fd_sc_hd__or2_1
XFILLER_0_113_359 VGND VGND VPWR VPWR sky130_fd_sc_hd__fill_1
X_5311_ _2194_ _2201_ _2211_ VGND VGND VPWR VPWR _2212_ sky130_fd_sc_hd__o21ba_1
XFILLER_0_23_162 VGND VGND VPWR VPWR sky130_fd_sc_hd__decap_6
XFILLER_0_24_696 VGND VGND VPWR VPWR sky130_fd_sc_hd__decap_4
XFILLER_0_87_45 VGND VGND VPWR VPWR sky130_fd_sc_hd__decap_3
X_6291_ u_pe_array.g_pe_row\[0\].g_pe_col\[2\].u_pe.psum_out\[9\] u_pe_array.g_pe_row\[0\].g_pe_col\[2\].u_pe.move_reg\[9\]
+ _2844_ VGND VGND VPWR VPWR _2983_ sky130_fd_sc_hd__mux2_1
X_5242_ _2154_ VGND VGND VPWR VPWR _0390_ sky130_fd_sc_hd__clkbuf_1
X_5173_ u_pe_array.g_pe_row\[2\].g_pe_col\[0\].u_pe.psum_out\[7\] u_pe_array.g_pe_row\[2\].g_pe_col\[0\].u_pe.psum_out\[8\]
+ _1286_ VGND VGND VPWR VPWR _2110_ sky130_fd_sc_hd__o21a_1
X_4124_ net498 _1301_ _1169_ _1302_ VGND VGND VPWR VPWR _0124_ sky130_fd_sc_hd__a22o_1
Xinput1 h_in0[0] VGND VGND VPWR VPWR net1 sky130_fd_sc_hd__clkbuf_2
Xclkbuf_leaf_48_clk clknet_3_6__leaf_clk VGND VGND VPWR VPWR clknet_leaf_48_clk sky130_fd_sc_hd__clkbuf_16
X_4055_ u_pe_array.g_pe_row\[3\].g_pe_col\[2\].u_pe.psum_out\[8\] _0934_ VGND VGND
+ VPWR VPWR _1253_ sky130_fd_sc_hd__or2_1
XFILLER_0_36_60 VGND VGND VPWR VPWR sky130_fd_sc_hd__decap_4
X_7814_ clknet_leaf_55_clk _0719_ net74 VGND VGND VPWR VPWR u_pe_array.g_pe_row\[0\].g_pe_col\[0\].u_pe.psum_out\[9\]
+ sky130_fd_sc_hd__dfrtp_2
X_4957_ _1938_ u_pe_array.g_pe_row\[2\].g_pe_col\[1\].u_pe.psum_out\[6\] _1105_ VGND
+ VGND VPWR VPWR _1939_ sky130_fd_sc_hd__and3_1
XFILLER_0_108_109 VPWR VGND VPWR VGND sky130_ef_sc_hd__decap_12
X_7745_ clknet_leaf_50_clk _0651_ net946 VGND VGND VPWR VPWR u_pe_array.act_from_right\[0\]\[8\]
+ sky130_fd_sc_hd__dfrtp_1
XFILLER_0_74_530 VGND VGND VPWR VPWR sky130_fd_sc_hd__fill_2
XFILLER_0_19_446 VGND VGND VPWR VPWR sky130_fd_sc_hd__fill_2
X_4888_ u_pe_array.act_from_down\[9\]\[6\] _1750_ _1483_ net226 VGND VGND VPWR VPWR
+ _0308_ sky130_fd_sc_hd__a22o_1
X_7676_ clknet_leaf_64_clk net152 net946 VGND VGND VPWR VPWR u_pe_array.g_pe_row\[0\].g_pe_col\[3\].u_pe.move_reg\[8\]
+ sky130_fd_sc_hd__dfrtp_1
XFILLER_0_34_416 VGND VGND VPWR VPWR sky130_fd_sc_hd__decap_4
X_3908_ net347 _1144_ _1116_ VGND VGND VPWR VPWR _1145_ sky130_fd_sc_hd__mux2_1
XFILLER_0_46_276 VGND VGND VPWR VPWR sky130_fd_sc_hd__fill_1
XFILLER_0_116_153 VGND VGND VPWR VPWR sky130_fd_sc_hd__decap_4
X_6627_ u_pe_array.g_pe_row\[0\].g_pe_col\[0\].u_pe.psum_out\[8\] u_pe_array.g_pe_row\[0\].g_pe_col\[0\].u_pe.move_reg\[8\]
+ _3102_ VGND VGND VPWR VPWR _3238_ sky130_fd_sc_hd__mux2_1
X_3839_ u_pe_array.g_pe_row\[3\].g_pe_col\[3\].u_pe.psum_out\[10\] _1078_ VGND VGND
+ VPWR VPWR _1089_ sky130_fd_sc_hd__nor2_1
XFILLER_0_116_197 VGND VGND VPWR VPWR sky130_fd_sc_hd__decap_4
X_6558_ u_pe_array.g_pe_row\[0\].g_pe_col\[1\].u_pe.psum_out\[7\] _2268_ VGND VGND
+ VPWR VPWR _3185_ sky130_fd_sc_hd__or2_1
XFILLER_0_15_685 VPWR VGND VPWR VGND sky130_ef_sc_hd__decap_12
XFILLER_0_42_460 VGND VGND VPWR VPWR sky130_fd_sc_hd__fill_1
X_6489_ _3118_ _3121_ VGND VGND VPWR VPWR _3122_ sky130_fd_sc_hd__xnor2_1
XFILLER_0_14_195 VGND VGND VPWR VPWR sky130_fd_sc_hd__fill_1
X_5509_ u_pe_array.u_fifo2.buffer\[8\]\[4\] _2322_ _2365_ _2369_ _0857_ VGND VGND
+ VPWR VPWR _2370_ sky130_fd_sc_hd__a221o_1
XFILLER_0_30_699 VGND VGND VPWR VPWR sky130_fd_sc_hd__fill_1
Xclkbuf_leaf_39_clk clknet_3_6__leaf_clk VGND VGND VPWR VPWR clknet_leaf_39_clk sky130_fd_sc_hd__clkbuf_16
XFILLER_0_69_368 VGND VGND VPWR VPWR sky130_fd_sc_hd__decap_3
XTAP_1022 VGND VPWR sky130_fd_sc_hd__tapvpwrvgnd_1
XTAP_1011 VGND VPWR sky130_fd_sc_hd__tapvpwrvgnd_1
XTAP_1000 VGND VPWR sky130_fd_sc_hd__tapvpwrvgnd_1
XFILLER_0_84_305 VGND VGND VPWR VPWR sky130_fd_sc_hd__decap_3
XTAP_1055 VGND VPWR sky130_fd_sc_hd__tapvpwrvgnd_1
XTAP_1044 VGND VPWR sky130_fd_sc_hd__tapvpwrvgnd_1
XTAP_1033 VGND VPWR sky130_fd_sc_hd__tapvpwrvgnd_1
XFILLER_0_32_29 VGND VGND VPWR VPWR sky130_fd_sc_hd__fill_1
XTAP_1099 VGND VPWR sky130_fd_sc_hd__tapvpwrvgnd_1
XTAP_1077 VGND VPWR sky130_fd_sc_hd__tapvpwrvgnd_1
XTAP_1088 VGND VPWR sky130_fd_sc_hd__tapvpwrvgnd_1
XTAP_1066 VGND VPWR sky130_fd_sc_hd__tapvpwrvgnd_1
XFILLER_0_25_449 VGND VGND VPWR VPWR sky130_fd_sc_hd__decap_4
XFILLER_0_0_505 VPWR VGND VPWR VGND sky130_ef_sc_hd__decap_12
XFILLER_0_21_655 VGND VGND VPWR VPWR sky130_fd_sc_hd__fill_1
XTAP_806 VGND VPWR sky130_fd_sc_hd__tapvpwrvgnd_1
XTAP_817 VGND VPWR sky130_fd_sc_hd__tapvpwrvgnd_1
XTAP_839 VGND VPWR sky130_fd_sc_hd__tapvpwrvgnd_1
XTAP_828 VGND VPWR sky130_fd_sc_hd__tapvpwrvgnd_1
X_5860_ net45 _2649_ _2273_ VGND VGND VPWR VPWR _2650_ sky130_fd_sc_hd__mux2_1
XFILLER_0_88_699 VGND VGND VPWR VPWR sky130_fd_sc_hd__fill_1
X_4811_ u_pe_array.g_pe_row\[2\].g_pe_col\[2\].u_pe.psum_out\[8\] _0933_ VGND VGND
+ VPWR VPWR _1832_ sky130_fd_sc_hd__or2_1
X_5791_ _2592_ _2593_ VGND VGND VPWR VPWR _2594_ sky130_fd_sc_hd__nand2_1
X_7530_ clknet_leaf_70_clk _0436_ net72 VGND VGND VPWR VPWR u_pe_array.act_from_left\[7\]\[11\]
+ sky130_fd_sc_hd__dfrtp_1
XFILLER_0_56_585 VGND VGND VPWR VPWR sky130_fd_sc_hd__decap_3
XFILLER_0_7_137 VPWR VGND VPWR VGND sky130_ef_sc_hd__decap_12
X_4742_ _1761_ _1767_ _1003_ VGND VGND VPWR VPWR _1769_ sky130_fd_sc_hd__a21o_1
XFILLER_0_28_265 VGND VGND VPWR VPWR sky130_fd_sc_hd__decap_6
X_7461_ clknet_leaf_31_clk _0367_ net71 VGND VGND VPWR VPWR u_pe_array.g_pe_row\[2\].g_pe_col\[0\].u_pe.psum_out\[11\]
+ sky130_fd_sc_hd__dfrtp_2
X_4673_ _1728_ _1105_ _0931_ VGND VGND VPWR VPWR _1729_ sky130_fd_sc_hd__mux2_1
XFILLER_0_83_393 VGND VGND VPWR VPWR sky130_fd_sc_hd__decap_6
XFILLER_0_56_596 VGND VGND VPWR VPWR sky130_fd_sc_hd__fill_2
X_3624_ _0912_ _0917_ VGND VGND VPWR VPWR _0918_ sky130_fd_sc_hd__or2_2
X_6412_ _3068_ _3075_ _3076_ _3077_ VGND VGND VPWR VPWR _3078_ sky130_fd_sc_hd__a31o_1
XFILLER_0_114_657 VPWR VGND VPWR VGND sky130_ef_sc_hd__decap_12
XFILLER_0_98_77 VGND VGND VPWR VPWR sky130_fd_sc_hd__decap_6
X_7392_ clknet_leaf_35_clk _0298_ net942 VGND VGND VPWR VPWR u_pe_array.act_from_right\[8\]\[9\]
+ sky130_fd_sc_hd__dfrtp_1
XFILLER_0_113_167 VGND VGND VPWR VPWR sky130_fd_sc_hd__fill_1
X_3555_ u_fsm.cnt\[0\] u_fsm.cnt\[1\] u_fsm.cnt\[2\] VGND VGND VPWR VPWR _0863_ sky130_fd_sc_hd__nand3_1
X_6343_ _3014_ VGND VGND VPWR VPWR _3015_ sky130_fd_sc_hd__inv_2
XFILLER_0_51_290 VGND VGND VPWR VPWR sky130_fd_sc_hd__decap_8
XFILLER_0_12_699 VGND VGND VPWR VPWR sky130_fd_sc_hd__fill_1
XFILLER_0_11_165 VGND VGND VPWR VPWR sky130_fd_sc_hd__decap_3
X_6274_ net271 _2006_ _2009_ _2974_ VGND VGND VPWR VPWR _0602_ sky130_fd_sc_hd__a22o_1
X_5225_ u_pe_array.g_pe_row\[1\].g_pe_col\[3\].u_pe.psum_out\[11\] net509 _2133_ VGND
+ VGND VPWR VPWR _2146_ sky130_fd_sc_hd__mux2_1
XFILLER_0_11_198 VGND VGND VPWR VPWR sky130_fd_sc_hd__decap_6
X_5156_ _2077_ _2087_ u_pe_array.g_pe_row\[2\].g_pe_col\[0\].u_pe.psum_out\[7\] _2073_
+ VGND VGND VPWR VPWR _2095_ sky130_fd_sc_hd__o2bb2a_1
X_4107_ net85 _1167_ _1169_ _1293_ VGND VGND VPWR VPWR _0116_ sky130_fd_sc_hd__a22o_1
X_5087_ _2022_ _2023_ VGND VGND VPWR VPWR _2032_ sky130_fd_sc_hd__and2_1
XFILLER_0_79_600 VGND VGND VPWR VPWR sky130_fd_sc_hd__decap_3
XFILLER_0_79_611 VGND VGND VPWR VPWR sky130_fd_sc_hd__decap_4
X_4038_ net865 _1007_ _1237_ _1021_ VGND VGND VPWR VPWR _0103_ sky130_fd_sc_hd__a22o_1
XFILLER_0_2_83 VGND VGND VPWR VPWR sky130_fd_sc_hd__fill_1
XPHY_116 VGND VGND VPWR VPWR sky130_fd_sc_hd__decap_3
XPHY_105 VGND VGND VPWR VPWR sky130_fd_sc_hd__decap_3
XPHY_149 VGND VGND VPWR VPWR sky130_fd_sc_hd__decap_3
XPHY_138 VGND VGND VPWR VPWR sky130_fd_sc_hd__decap_3
XPHY_127 VGND VGND VPWR VPWR sky130_fd_sc_hd__decap_3
X_5989_ u_pe_array.g_pe_row\[1\].g_pe_col\[0\].u_pe.act_val\[2\] u_pe_array.g_pe_row\[1\].g_pe_col\[0\].u_pe.w_out\[0\]
+ VGND VGND VPWR VPWR _2744_ sky130_fd_sc_hd__nand2_1
XFILLER_0_93_157 VGND VGND VPWR VPWR sky130_fd_sc_hd__decap_4
X_7728_ clknet_leaf_74_clk _0634_ net13 VGND VGND VPWR VPWR u_pe_array.g_pe_row\[0\].g_pe_col\[2\].u_pe.psum_out\[6\]
+ sky130_fd_sc_hd__dfrtp_2
XFILLER_0_19_265 VGND VGND VPWR VPWR sky130_fd_sc_hd__decap_8
XFILLER_0_62_533 VGND VGND VPWR VPWR sky130_fd_sc_hd__decap_3
XFILLER_0_117_495 VGND VGND VPWR VPWR sky130_fd_sc_hd__fill_1
X_7659_ clknet_leaf_60_clk _0565_ net74 VGND VGND VPWR VPWR u_pe_array.act_from_right\[2\]\[4\]
+ sky130_fd_sc_hd__dfrtp_1
XFILLER_0_62_544 VGND VGND VPWR VPWR sky130_fd_sc_hd__fill_2
XFILLER_0_34_268 VGND VGND VPWR VPWR sky130_fd_sc_hd__fill_1
XFILLER_0_22_419 VGND VGND VPWR VPWR sky130_fd_sc_hd__fill_1
XPHY_7 VGND VGND VPWR VPWR sky130_fd_sc_hd__decap_3
XFILLER_0_84_146 VGND VGND VPWR VPWR sky130_fd_sc_hd__decap_8
XFILLER_0_38_530 VGND VGND VPWR VPWR sky130_fd_sc_hd__fill_2
XFILLER_0_38_541 VGND VGND VPWR VPWR sky130_fd_sc_hd__decap_3
XFILLER_0_25_213 VGND VGND VPWR VPWR sky130_fd_sc_hd__decap_8
XFILLER_0_80_341 VGND VGND VPWR VPWR sky130_fd_sc_hd__fill_2
Xhold309 u_pe_array.act_from_right\[8\]\[5\] VGND VGND VPWR VPWR net383 sky130_fd_sc_hd__dlygate4sd3_1
XFILLER_0_7_39 VPWR VGND VPWR VGND sky130_ef_sc_hd__decap_12
XFILLER_0_0_302 VGND VGND VPWR VPWR sky130_fd_sc_hd__decap_6
XFILLER_0_21_496 VGND VGND VPWR VPWR sky130_fd_sc_hd__decap_8
XTAP_603 VGND VPWR sky130_fd_sc_hd__tapvpwrvgnd_1
XTAP_614 VGND VPWR sky130_fd_sc_hd__tapvpwrvgnd_1
XTAP_625 VGND VPWR sky130_fd_sc_hd__tapvpwrvgnd_1
X_5010_ _1986_ _1987_ u_pe_array.g_pe_row\[2\].g_pe_col\[1\].u_pe.psum_out\[10\] _1006_
+ VGND VGND VPWR VPWR _0325_ sky130_fd_sc_hd__a2bb2o_1
XTAP_636 VGND VPWR sky130_fd_sc_hd__tapvpwrvgnd_1
XTAP_647 VGND VPWR sky130_fd_sc_hd__tapvpwrvgnd_1
XTAP_658 VGND VPWR sky130_fd_sc_hd__tapvpwrvgnd_1
XTAP_669 VGND VPWR sky130_fd_sc_hd__tapvpwrvgnd_1
XFILLER_0_108_53 VPWR VGND VPWR VGND sky130_ef_sc_hd__decap_12
XFILLER_0_84_57 VGND VGND VPWR VPWR sky130_fd_sc_hd__decap_6
XFILLER_0_17_51 VGND VGND VPWR VPWR sky130_fd_sc_hd__decap_4
XFILLER_0_108_97 VPWR VGND VPWR VGND sky130_ef_sc_hd__decap_12
X_6961_ _3466_ net824 VGND VGND VPWR VPWR _0796_ sky130_fd_sc_hd__nor2_1
XFILLER_0_88_463 VGND VGND VPWR VPWR sky130_fd_sc_hd__decap_4
X_5912_ u_pe_array.u_fifo1.rd_ptr\[3\] u_pe_array.u_fifo1.rd_ptr\[2\] VGND VGND VPWR
+ VPWR _2682_ sky130_fd_sc_hd__nor2_1
X_6892_ _0924_ net677 _3423_ VGND VGND VPWR VPWR _3427_ sky130_fd_sc_hd__mux2_1
X_5843_ net798 _2636_ _2273_ VGND VGND VPWR VPWR _2637_ sky130_fd_sc_hd__mux2_1
XFILLER_0_118_237 VGND VGND VPWR VPWR sky130_fd_sc_hd__decap_8
XFILLER_0_91_617 VPWR VGND VPWR VGND sky130_ef_sc_hd__decap_12
X_5774_ _2567_ _2569_ VGND VGND VPWR VPWR _2578_ sky130_fd_sc_hd__nor2_1
X_7513_ clknet_leaf_67_clk _0419_ net947 VGND VGND VPWR VPWR u_pe_array.act_from_right\[5\]\[7\]
+ sky130_fd_sc_hd__dfrtp_1
X_4725_ _1487_ _1751_ _1753_ _1356_ net540 VGND VGND VPWR VPWR _0274_ sky130_fd_sc_hd__a32o_1
X_7444_ clknet_leaf_34_clk net221 net951 VGND VGND VPWR VPWR u_pe_array.g_pe_row\[2\].g_pe_col\[0\].u_pe.move_reg\[7\]
+ sky130_fd_sc_hd__dfrtp_1
X_4656_ _1487_ _1714_ _1715_ _1356_ net888 VGND VGND VPWR VPWR _0243_ sky130_fd_sc_hd__a32o_1
XFILLER_0_102_605 VGND VGND VPWR VPWR sky130_fd_sc_hd__fill_1
X_3607_ _0857_ _0898_ VGND VGND VPWR VPWR _0904_ sky130_fd_sc_hd__nor2_1
XFILLER_0_24_290 VGND VGND VPWR VPWR sky130_fd_sc_hd__fill_2
X_7375_ clknet_leaf_0_clk _0281_ net944 VGND VGND VPWR VPWR u_pe_array.g_pe_row\[2\].g_pe_col\[2\].u_pe.psum_out\[7\]
+ sky130_fd_sc_hd__dfrtp_2
Xhold821 _0439_ VGND VGND VPWR VPWR net895 sky130_fd_sc_hd__dlygate4sd3_1
Xhold810 u_pe_array.act_from_left\[5\]\[4\] VGND VGND VPWR VPWR net884 sky130_fd_sc_hd__dlygate4sd3_1
X_4587_ u_pe_array.g_pe_row\[2\].g_pe_col\[3\].u_pe.act_val\[3\] _1424_ _1638_ _1637_
+ VGND VGND VPWR VPWR _1653_ sky130_fd_sc_hd__a31o_1
Xhold832 u_pe_array.act_from_left\[15\]\[5\] VGND VGND VPWR VPWR net906 sky130_fd_sc_hd__dlygate4sd3_1
Xhold854 u_pe_array.g_pe_row\[3\].g_pe_col\[0\].u_pe.psum_out\[7\] VGND VGND VPWR
+ VPWR net928 sky130_fd_sc_hd__dlygate4sd3_1
X_6326_ _2996_ _2998_ VGND VGND VPWR VPWR _2999_ sky130_fd_sc_hd__xnor2_1
Xhold843 u_pe_array.act_from_left\[13\]\[0\] VGND VGND VPWR VPWR net917 sky130_fd_sc_hd__dlygate4sd3_1
Xhold865 u_pe_array.act_from_right\[13\]\[11\] VGND VGND VPWR VPWR net939 sky130_fd_sc_hd__dlygate4sd3_1
XFILLER_0_110_693 VGND VGND VPWR VPWR sky130_fd_sc_hd__decap_6
X_6257_ u_pe_array.g_pe_row\[0\].g_pe_col\[3\].u_pe.psum_out\[11\] _1999_ VGND VGND
+ VPWR VPWR _2962_ sky130_fd_sc_hd__and2b_1
X_6188_ _2898_ _2899_ VGND VGND VPWR VPWR _2900_ sky130_fd_sc_hd__or2_1
X_5208_ u_pe_array.g_pe_row\[1\].g_pe_col\[3\].u_pe.psum_out\[3\] u_pe_array.g_pe_row\[1\].g_pe_col\[3\].u_pe.act_val\[3\]
+ _2133_ VGND VGND VPWR VPWR _2137_ sky130_fd_sc_hd__mux2_1
X_5139_ _2067_ VGND VGND VPWR VPWR _2080_ sky130_fd_sc_hd__inv_2
XFILLER_0_67_614 VGND VGND VPWR VPWR sky130_fd_sc_hd__fill_2
XFILLER_0_39_305 VPWR VGND VPWR VGND sky130_ef_sc_hd__decap_12
XFILLER_0_67_658 VPWR VGND VPWR VGND sky130_ef_sc_hd__decap_12
XFILLER_0_39_349 VGND VGND VPWR VPWR sky130_fd_sc_hd__decap_4
XFILLER_0_35_511 VGND VGND VPWR VPWR sky130_fd_sc_hd__decap_3
XFILLER_0_47_382 VGND VGND VPWR VPWR sky130_fd_sc_hd__decap_8
XFILLER_0_90_661 VPWR VGND VPWR VGND sky130_ef_sc_hd__decap_12
XFILLER_0_74_190 VGND VGND VPWR VPWR sky130_fd_sc_hd__decap_6
XFILLER_0_117_281 VGND VGND VPWR VPWR sky130_fd_sc_hd__fill_2
XFILLER_0_105_487 VGND VGND VPWR VPWR sky130_fd_sc_hd__decap_8
XFILLER_0_22_227 VGND VGND VPWR VPWR sky130_fd_sc_hd__decap_6
XFILLER_0_101_671 VGND VGND VPWR VPWR sky130_fd_sc_hd__fill_1
XFILLER_0_38_39 VGND VGND VPWR VPWR sky130_fd_sc_hd__fill_2
XFILLER_0_54_27 VGND VGND VPWR VPWR sky130_fd_sc_hd__fill_1
XFILLER_0_97_271 VGND VGND VPWR VPWR sky130_fd_sc_hd__fill_1
XFILLER_0_58_603 VPWR VGND VPWR VGND sky130_ef_sc_hd__decap_12
XFILLER_0_97_293 VGND VGND VPWR VPWR sky130_fd_sc_hd__decap_8
XFILLER_0_57_113 VGND VGND VPWR VPWR sky130_fd_sc_hd__fill_1
XFILLER_0_85_488 VGND VGND VPWR VPWR sky130_fd_sc_hd__fill_1
XFILLER_0_57_179 VPWR VGND VPWR VGND sky130_ef_sc_hd__decap_12
XFILLER_0_38_371 VGND VGND VPWR VPWR sky130_fd_sc_hd__fill_1
XFILLER_0_108_270 VGND VGND VPWR VPWR sky130_fd_sc_hd__decap_3
XFILLER_0_72_149 VGND VGND VPWR VPWR sky130_fd_sc_hd__decap_3
XFILLER_0_26_566 VGND VGND VPWR VPWR sky130_fd_sc_hd__fill_1
XFILLER_0_13_216 VGND VGND VPWR VPWR sky130_fd_sc_hd__decap_8
X_5490_ u_pe_array.u_fifo2.buffer\[5\]\[2\] _2333_ _2334_ u_pe_array.u_fifo2.buffer\[6\]\[2\]
+ _2335_ VGND VGND VPWR VPWR _2353_ sky130_fd_sc_hd__a221o_1
X_4510_ u_pe_array.g_pe_row\[2\].g_pe_col\[3\].u_pe.psum_out\[3\] u_pe_array.g_pe_row\[2\].g_pe_col\[3\].u_pe.act_val\[3\]
+ _1599_ VGND VGND VPWR VPWR _1603_ sky130_fd_sc_hd__mux2_1
XFILLER_0_41_503 VGND VGND VPWR VPWR sky130_fd_sc_hd__fill_1
XFILLER_0_102_3 VPWR VGND VPWR VGND sky130_ef_sc_hd__decap_12
XFILLER_0_79_46 VGND VGND VPWR VPWR sky130_fd_sc_hd__decap_6
Xhold106 _0136_ VGND VGND VPWR VPWR net180 sky130_fd_sc_hd__dlygate4sd3_1
Xhold117 _0444_ VGND VGND VPWR VPWR net191 sky130_fd_sc_hd__dlygate4sd3_1
X_4441_ _1542_ _1543_ _1545_ VGND VGND VPWR VPWR _1546_ sky130_fd_sc_hd__a21oi_1
XFILLER_0_111_446 VGND VGND VPWR VPWR sky130_fd_sc_hd__fill_2
XFILLER_0_110_65 VPWR VGND VPWR VGND sky130_ef_sc_hd__decap_12
Xhold128 u_pe_array.g_pe_row\[0\].g_pe_col\[1\].u_pe.move_reg\[6\] VGND VGND VPWR
+ VPWR net202 sky130_fd_sc_hd__dlygate4sd3_1
Xhold139 _0186_ VGND VGND VPWR VPWR net213 sky130_fd_sc_hd__dlygate4sd3_1
X_7160_ clknet_leaf_8_clk _0066_ net945 VGND VGND VPWR VPWR u_pe_array.act_from_right\[13\]\[8\]
+ sky130_fd_sc_hd__dfrtp_1
XFILLER_0_95_23 VPWR VGND VPWR VGND sky130_ef_sc_hd__decap_12
X_4372_ net357 _1310_ _1483_ u_pe_array.g_pe_row\[3\].g_pe_col\[0\].u_pe.move_reg\[12\]
+ VGND VGND VPWR VPWR _0191_ sky130_fd_sc_hd__a22o_1
X_6111_ net344 _2499_ _2847_ _2849_ VGND VGND VPWR VPWR _0564_ sky130_fd_sc_hd__a22o_1
XTAP_400 VGND VPWR sky130_fd_sc_hd__tapvpwrvgnd_1
XTAP_411 VGND VPWR sky130_fd_sc_hd__tapvpwrvgnd_1
XFILLER_0_0_187 VGND VGND VPWR VPWR sky130_fd_sc_hd__decap_8
XFILLER_0_0_165 VGND VGND VPWR VPWR sky130_fd_sc_hd__decap_3
XTAP_433 VGND VPWR sky130_fd_sc_hd__tapvpwrvgnd_1
XTAP_422 VGND VPWR sky130_fd_sc_hd__tapvpwrvgnd_1
X_7091_ clknet_leaf_89_clk u_fsm.next_state\[0\] net948 VGND VGND VPWR VPWR u_fsm.state\[0\]
+ sky130_fd_sc_hd__dfrtp_4
XTAP_444 VGND VPWR sky130_fd_sc_hd__tapvpwrvgnd_1
XTAP_455 VGND VPWR sky130_fd_sc_hd__tapvpwrvgnd_1
XTAP_466 VGND VPWR sky130_fd_sc_hd__tapvpwrvgnd_1
X_6042_ _2787_ _2792_ VGND VGND VPWR VPWR _2793_ sky130_fd_sc_hd__or2_1
XTAP_477 VGND VPWR sky130_fd_sc_hd__tapvpwrvgnd_1
XTAP_488 VGND VPWR sky130_fd_sc_hd__tapvpwrvgnd_1
XTAP_499 VGND VPWR sky130_fd_sc_hd__tapvpwrvgnd_1
X_6944_ u_pe_array.u_fifo1.wr_ptr\[0\] _3349_ VGND VGND VPWR VPWR _3456_ sky130_fd_sc_hd__nand2_1
XFILLER_0_48_102 VGND VGND VPWR VPWR sky130_fd_sc_hd__fill_1
XFILLER_0_49_625 VGND VGND VPWR VPWR sky130_fd_sc_hd__fill_2
XFILLER_0_76_477 VGND VGND VPWR VPWR sky130_fd_sc_hd__decap_4
X_6875_ _3417_ VGND VGND VPWR VPWR _0760_ sky130_fd_sc_hd__clkbuf_1
XFILLER_0_91_425 VGND VGND VPWR VPWR sky130_fd_sc_hd__decap_6
X_5826_ _2623_ _2624_ VGND VGND VPWR VPWR _2625_ sky130_fd_sc_hd__xnor2_1
XFILLER_0_8_232 VGND VGND VPWR VPWR sky130_fd_sc_hd__decap_4
X_5757_ _2550_ _2553_ _2561_ VGND VGND VPWR VPWR _2563_ sky130_fd_sc_hd__o21ai_1
X_4708_ u_pe_array.g_pe_row\[2\].g_pe_col\[2\].u_pe.act_val\[1\] _1605_ _1611_ net177
+ VGND VGND VPWR VPWR _0262_ sky130_fd_sc_hd__a22o_1
X_5688_ net924 _2499_ _2491_ _2508_ VGND VGND VPWR VPWR _0482_ sky130_fd_sc_hd__a22o_1
X_7427_ clknet_leaf_11_clk _0333_ net951 VGND VGND VPWR VPWR u_pe_array.act_from_up\[12\]\[3\]
+ sky130_fd_sc_hd__dfrtp_1
X_4639_ _1691_ _1694_ _1699_ _1003_ VGND VGND VPWR VPWR _1701_ sky130_fd_sc_hd__a31o_1
Xhold640 u_pe_array.g_pe_row\[0\].g_pe_col\[0\].u_pe.psum_out\[8\] VGND VGND VPWR
+ VPWR net714 sky130_fd_sc_hd__dlygate4sd3_1
Xhold662 u_pe_array.u_fifo1.rd_ptr\[3\] VGND VGND VPWR VPWR net736 sky130_fd_sc_hd__dlygate4sd3_1
X_7358_ clknet_leaf_106_clk net258 net944 VGND VGND VPWR VPWR u_pe_array.g_pe_row\[2\].g_pe_col\[2\].u_pe.act_val\[3\]
+ sky130_fd_sc_hd__dfrtp_2
Xhold651 u_pe_array.g_pe_row\[3\].g_pe_col\[2\].u_pe.psum_out\[1\] VGND VGND VPWR
+ VPWR net725 sky130_fd_sc_hd__dlygate4sd3_1
X_6309_ u_pe_array.act_from_right\[2\]\[9\] _2730_ _0940_ net308 VGND VGND VPWR VPWR
+ _0624_ sky130_fd_sc_hd__a22o_1
Xhold673 u_pe_array.act_from_left\[13\]\[5\] VGND VGND VPWR VPWR net747 sky130_fd_sc_hd__dlygate4sd3_1
Xhold695 u_pe_array.g_pe_row\[0\].g_pe_col\[2\].u_pe.psum_out\[6\] VGND VGND VPWR
+ VPWR net769 sky130_fd_sc_hd__dlygate4sd3_1
Xhold684 u_pe_array.act_from_right\[5\]\[0\] VGND VGND VPWR VPWR net758 sky130_fd_sc_hd__dlygate4sd3_1
X_7289_ clknet_leaf_9_clk _0195_ net950 VGND VGND VPWR VPWR u_pe_array.g_pe_row\[3\].g_pe_col\[0\].u_pe.psum_out\[3\]
+ sky130_fd_sc_hd__dfrtp_2
XFILLER_0_99_525 VGND VGND VPWR VPWR sky130_fd_sc_hd__decap_8
XFILLER_0_39_113 VGND VGND VPWR VPWR sky130_fd_sc_hd__decap_8
XFILLER_0_55_617 VPWR VGND VPWR VGND sky130_ef_sc_hd__decap_12
XFILLER_0_35_363 VGND VGND VPWR VPWR sky130_fd_sc_hd__decap_6
XFILLER_0_23_558 VGND VGND VPWR VPWR sky130_fd_sc_hd__fill_2
XFILLER_0_50_322 VPWR VGND VPWR VGND sky130_ef_sc_hd__decap_12
XFILLER_0_65_15 VGND VGND VPWR VPWR sky130_fd_sc_hd__fill_1
XFILLER_0_4_29 VPWR VGND VPWR VGND sky130_ef_sc_hd__decap_12
XFILLER_0_4_18 VGND VGND VPWR VPWR sky130_fd_sc_hd__decap_8
XFILLER_0_65_48 VGND VGND VPWR VPWR sky130_fd_sc_hd__decap_8
X_4990_ _1962_ _1964_ _1969_ VGND VGND VPWR VPWR _1970_ sky130_fd_sc_hd__or3_1
XFILLER_0_81_69 VGND VGND VPWR VPWR sky130_fd_sc_hd__decap_4
XFILLER_0_105_43 VPWR VGND VPWR VGND sky130_ef_sc_hd__decap_12
XFILLER_0_14_41 VGND VGND VPWR VPWR sky130_fd_sc_hd__decap_8
X_3941_ _0983_ _1138_ _1166_ net113 VGND VGND VPWR VPWR _0077_ sky130_fd_sc_hd__a22o_1
X_6660_ _3244_ _3250_ VGND VGND VPWR VPWR _3252_ sky130_fd_sc_hd__or2_1
XFILLER_0_14_85 VPWR VGND VPWR VGND sky130_ef_sc_hd__decap_12
X_3872_ net826 _1114_ _1116_ VGND VGND VPWR VPWR _1117_ sky130_fd_sc_hd__mux2_1
XFILLER_0_45_105 VGND VGND VPWR VPWR sky130_fd_sc_hd__decap_6
X_6591_ _3203_ _3213_ _3214_ VGND VGND VPWR VPWR _3215_ sky130_fd_sc_hd__a21oi_1
XFILLER_0_73_447 VGND VGND VPWR VPWR sky130_fd_sc_hd__fill_1
X_5611_ u_pe_array.g_pe_row\[1\].g_pe_col\[2\].u_pe.psum_out\[8\] _1597_ VGND VGND
+ VPWR VPWR _2455_ sky130_fd_sc_hd__nand2_1
XFILLER_0_26_352 VGND VGND VPWR VPWR sky130_fd_sc_hd__fill_1
XFILLER_0_30_40 VPWR VGND VPWR VGND sky130_ef_sc_hd__decap_12
X_5542_ _2390_ _2391_ VGND VGND VPWR VPWR _2392_ sky130_fd_sc_hd__xnor2_1
XFILLER_0_14_569 VGND VGND VPWR VPWR sky130_fd_sc_hd__fill_2
X_5473_ u_pe_array.u_fifo2.buffer\[4\]\[0\] net68 _2330_ _2337_ VGND VGND VPWR VPWR
+ _2338_ sky130_fd_sc_hd__a211o_1
X_7212_ clknet_leaf_15_clk _0118_ net942 VGND VGND VPWR VPWR u_pe_array.act_from_down\[9\]\[6\]
+ sky130_fd_sc_hd__dfrtp_1
X_4424_ u_pe_array.g_pe_row\[3\].g_pe_col\[0\].u_pe.psum_out\[5\] _1529_ VGND VGND
+ VPWR VPWR _1530_ sky130_fd_sc_hd__xnor2_2
XFILLER_0_1_441 VGND VGND VPWR VPWR sky130_fd_sc_hd__decap_6
XFILLER_0_22_580 VGND VGND VPWR VPWR sky130_fd_sc_hd__decap_8
X_7143_ clknet_leaf_20_clk _0049_ net70 VGND VGND VPWR VPWR u_pe_array.g_pe_row\[3\].g_pe_col\[3\].u_pe.psum_out\[6\]
+ sky130_fd_sc_hd__dfrtp_1
X_4355_ net16 u_pe_array.act_from_up\[12\]\[1\] _0857_ VGND VGND VPWR VPWR _1478_
+ sky130_fd_sc_hd__mux2_1
XFILLER_0_1_485 VPWR VGND VPWR VGND sky130_ef_sc_hd__decap_12
XTAP_241 VGND VPWR sky130_fd_sc_hd__tapvpwrvgnd_1
X_7074_ net716 _3360_ _3529_ VGND VGND VPWR VPWR _3534_ sky130_fd_sc_hd__mux2_1
X_4286_ _1434_ VGND VGND VPWR VPWR _0154_ sky130_fd_sc_hd__clkbuf_1
XTAP_263 VGND VPWR sky130_fd_sc_hd__tapvpwrvgnd_1
XTAP_252 VGND VPWR sky130_fd_sc_hd__tapvpwrvgnd_1
XTAP_274 VGND VPWR sky130_fd_sc_hd__tapvpwrvgnd_1
XTAP_296 VGND VPWR sky130_fd_sc_hd__tapvpwrvgnd_1
XTAP_285 VGND VPWR sky130_fd_sc_hd__tapvpwrvgnd_1
X_6025_ u_pe_array.g_pe_row\[1\].g_pe_col\[0\].u_pe.act_val\[4\] u_pe_array.g_pe_row\[1\].g_pe_col\[0\].u_pe.w_out\[0\]
+ _2763_ VGND VGND VPWR VPWR _2777_ sky130_fd_sc_hd__and3_1
XTAP_1429 VGND VPWR sky130_fd_sc_hd__tapvpwrvgnd_1
XTAP_1407 VGND VPWR sky130_fd_sc_hd__tapvpwrvgnd_1
XTAP_1418 VGND VPWR sky130_fd_sc_hd__tapvpwrvgnd_1
XFILLER_0_49_433 VGND VGND VPWR VPWR sky130_fd_sc_hd__fill_2
XFILLER_0_92_701 VGND VGND VPWR VPWR sky130_fd_sc_hd__decap_4
X_6927_ _0911_ net670 _3446_ VGND VGND VPWR VPWR _3447_ sky130_fd_sc_hd__mux2_1
XFILLER_0_37_617 VGND VGND VPWR VPWR sky130_fd_sc_hd__decap_8
XFILLER_0_64_414 VGND VGND VPWR VPWR sky130_fd_sc_hd__decap_3
X_6858_ _3407_ VGND VGND VPWR VPWR _3408_ sky130_fd_sc_hd__buf_2
XFILLER_0_9_541 VGND VGND VPWR VPWR sky130_fd_sc_hd__fill_1
XFILLER_0_9_530 VGND VGND VPWR VPWR sky130_fd_sc_hd__decap_3
XFILLER_0_36_127 VGND VGND VPWR VPWR sky130_fd_sc_hd__fill_2
XFILLER_0_107_505 VGND VGND VPWR VPWR sky130_fd_sc_hd__decap_4
X_5809_ _2608_ _2609_ VGND VGND VPWR VPWR _2610_ sky130_fd_sc_hd__nand2_1
XFILLER_0_91_233 VGND VGND VPWR VPWR sky130_fd_sc_hd__decap_6
XFILLER_0_9_574 VGND VGND VPWR VPWR sky130_fd_sc_hd__decap_8
XFILLER_0_91_277 VGND VGND VPWR VPWR sky130_fd_sc_hd__decap_3
X_6789_ _3363_ VGND VGND VPWR VPWR _0728_ sky130_fd_sc_hd__clkbuf_1
XFILLER_0_45_661 VGND VGND VPWR VPWR sky130_fd_sc_hd__decap_8
XFILLER_0_17_385 VGND VGND VPWR VPWR sky130_fd_sc_hd__fill_2
XFILLER_0_102_265 VPWR VGND VPWR VGND sky130_ef_sc_hd__decap_12
Xhold481 u_pe_array.g_pe_row\[3\].g_pe_col\[0\].u_pe.psum_out\[6\] VGND VGND VPWR
+ VPWR net555 sky130_fd_sc_hd__dlygate4sd3_1
Xhold470 u_pe_array.g_pe_row\[0\].g_pe_col\[2\].u_pe.psum_out\[12\] VGND VGND VPWR
+ VPWR net544 sky130_fd_sc_hd__dlygate4sd3_1
XFILLER_0_102_298 VGND VGND VPWR VPWR sky130_fd_sc_hd__decap_8
Xhold492 u_pe_array.g_pe_row\[3\].g_pe_col\[3\].u_pe.psum_out\[4\] VGND VGND VPWR
+ VPWR net566 sky130_fd_sc_hd__dlygate4sd3_1
XFILLER_0_99_333 VGND VGND VPWR VPWR sky130_fd_sc_hd__decap_3
XFILLER_0_95_572 VGND VGND VPWR VPWR sky130_fd_sc_hd__fill_1
XFILLER_0_82_266 VGND VGND VPWR VPWR sky130_fd_sc_hd__fill_1
XFILLER_0_51_686 VGND VGND VPWR VPWR sky130_fd_sc_hd__decap_4
X_4140_ net347 u_fsm.psum_shift_en _1175_ u_pe_array.g_pe_row\[3\].g_pe_col\[1\].u_pe.move_reg\[8\]
+ VGND VGND VPWR VPWR _0133_ sky130_fd_sc_hd__a22o_1
X_4071_ u_pe_array.g_pe_row\[3\].g_pe_col\[2\].u_pe.psum_out\[10\] _0934_ VGND VGND
+ VPWR VPWR _1267_ sky130_fd_sc_hd__nand2_1
XFILLER_0_116_20 VGND VGND VPWR VPWR sky130_fd_sc_hd__decap_8
X_7830_ clknet_leaf_86_clk _0735_ net948 VGND VGND VPWR VPWR u_pe_array.u_fifo2.rd_ptr\[2\]
+ sky130_fd_sc_hd__dfrtp_4
XFILLER_0_116_53 VPWR VGND VPWR VGND sky130_ef_sc_hd__decap_12
XFILLER_0_25_51 VGND VGND VPWR VPWR sky130_fd_sc_hd__decap_4
XFILLER_0_116_97 VPWR VGND VPWR VGND sky130_ef_sc_hd__decap_12
X_4973_ u_pe_array.g_pe_row\[2\].g_pe_col\[1\].u_pe.psum_out\[7\] _1105_ VGND VGND
+ VPWR VPWR _1954_ sky130_fd_sc_hd__nand2_1
X_7761_ clknet_leaf_43_clk net266 net946 VGND VGND VPWR VPWR u_pe_array.g_pe_row\[0\].g_pe_col\[1\].u_pe.move_reg\[11\]
+ sky130_fd_sc_hd__dfrtp_1
X_6712_ _3296_ _3287_ _3297_ _3298_ VGND VGND VPWR VPWR _3299_ sky130_fd_sc_hd__a211oi_1
X_7692_ clknet_leaf_64_clk _0598_ net74 VGND VGND VPWR VPWR u_pe_array.g_pe_row\[0\].g_pe_col\[3\].u_pe.psum_out\[11\]
+ sky130_fd_sc_hd__dfrtp_1
X_3924_ net938 _1156_ _1116_ VGND VGND VPWR VPWR _1157_ sky130_fd_sc_hd__mux2_1
X_6643_ u_pe_array.act_from_right\[0\]\[6\] _0866_ _0940_ net210 VGND VGND VPWR VPWR
+ _0703_ sky130_fd_sc_hd__a22o_1
X_3855_ _1101_ _1102_ VGND VGND VPWR VPWR _1103_ sky130_fd_sc_hd__xnor2_1
XFILLER_0_116_379 VGND VGND VPWR VPWR sky130_fd_sc_hd__decap_3
X_6574_ _3192_ _3194_ _3199_ VGND VGND VPWR VPWR _3200_ sky130_fd_sc_hd__or3_1
X_3786_ _1028_ _1031_ _1040_ VGND VGND VPWR VPWR _1041_ sky130_fd_sc_hd__or3_1
XFILLER_0_61_439 VGND VGND VPWR VPWR sky130_fd_sc_hd__decap_8
X_5525_ net108 _2016_ _1883_ u_pe_array.g_pe_row\[1\].g_pe_col\[2\].u_pe.move_reg\[11\]
+ VGND VGND VPWR VPWR _0449_ sky130_fd_sc_hd__a22o_1
XFILLER_0_42_642 VGND VGND VPWR VPWR sky130_fd_sc_hd__fill_2
XFILLER_0_42_653 VGND VGND VPWR VPWR sky130_fd_sc_hd__fill_2
XFILLER_0_74_3 VGND VGND VPWR VPWR sky130_fd_sc_hd__decap_8
X_5456_ u_pe_array.u_fifo2.rd_ptr\[1\] u_pe_array.u_fifo2.rd_ptr\[0\] VGND VGND VPWR
+ VPWR _2321_ sky130_fd_sc_hd__or2_2
X_4407_ _1505_ _1514_ VGND VGND VPWR VPWR _1515_ sky130_fd_sc_hd__xnor2_1
XFILLER_0_10_550 VGND VGND VPWR VPWR sky130_fd_sc_hd__fill_1
X_5387_ net864 _2276_ _2273_ VGND VGND VPWR VPWR _2277_ sky130_fd_sc_hd__mux2_1
X_4338_ _1472_ VGND VGND VPWR VPWR _0168_ sky130_fd_sc_hd__clkbuf_1
X_7126_ clknet_leaf_5_clk _0032_ net945 VGND VGND VPWR VPWR u_pe_array.g_pe_row\[3\].g_pe_col\[3\].u_pe.act_val\[2\]
+ sky130_fd_sc_hd__dfrtp_2
X_4269_ _1420_ _1421_ VGND VGND VPWR VPWR _1422_ sky130_fd_sc_hd__xnor2_1
X_7057_ _3524_ VGND VGND VPWR VPWR _0835_ sky130_fd_sc_hd__clkbuf_1
X_6008_ net873 _2586_ _2761_ _0978_ VGND VGND VPWR VPWR _0549_ sky130_fd_sc_hd__a22o_1
XFILLER_0_96_336 VGND VGND VPWR VPWR sky130_fd_sc_hd__decap_4
XTAP_1204 VGND VPWR sky130_fd_sc_hd__tapvpwrvgnd_1
XTAP_1248 VGND VPWR sky130_fd_sc_hd__tapvpwrvgnd_1
XTAP_1237 VGND VPWR sky130_fd_sc_hd__tapvpwrvgnd_1
XTAP_1226 VGND VPWR sky130_fd_sc_hd__tapvpwrvgnd_1
XTAP_1215 VGND VPWR sky130_fd_sc_hd__tapvpwrvgnd_1
XTAP_1259 VGND VPWR sky130_fd_sc_hd__tapvpwrvgnd_1
XFILLER_0_92_531 VGND VGND VPWR VPWR sky130_fd_sc_hd__fill_1
XFILLER_0_64_244 VGND VGND VPWR VPWR sky130_fd_sc_hd__decap_8
XFILLER_0_92_586 VGND VGND VPWR VPWR sky130_fd_sc_hd__fill_2
XFILLER_0_9_393 VPWR VGND VPWR VGND sky130_ef_sc_hd__decap_12
XFILLER_0_52_406 VPWR VGND VPWR VGND sky130_ef_sc_hd__decap_12
XFILLER_0_107_368 VPWR VGND VPWR VGND sky130_ef_sc_hd__decap_12
XFILLER_0_115_390 VGND VGND VPWR VPWR sky130_fd_sc_hd__fill_2
XFILLER_0_33_697 VGND VGND VPWR VPWR sky130_fd_sc_hd__decap_8
XFILLER_0_56_701 VGND VGND VPWR VPWR sky130_fd_sc_hd__decap_4
XFILLER_0_28_414 VGND VGND VPWR VPWR sky130_fd_sc_hd__fill_1
XFILLER_0_83_542 VGND VGND VPWR VPWR sky130_fd_sc_hd__fill_2
XFILLER_0_71_704 VGND VGND VPWR VPWR sky130_fd_sc_hd__fill_1
XFILLER_0_15_108 VGND VGND VPWR VPWR sky130_fd_sc_hd__decap_4
XFILLER_0_3_503 VGND VGND VPWR VPWR sky130_fd_sc_hd__fill_1
X_3640_ _0928_ net661 _0918_ VGND VGND VPWR VPWR _0929_ sky130_fd_sc_hd__mux2_1
XFILLER_0_113_327 VGND VGND VPWR VPWR sky130_fd_sc_hd__decap_4
XFILLER_0_102_77 VGND VGND VPWR VPWR sky130_fd_sc_hd__decap_6
X_3571_ _0878_ VGND VGND VPWR VPWR u_fsm.next_state\[0\] sky130_fd_sc_hd__buf_1
X_5310_ _2199_ _2200_ VGND VGND VPWR VPWR _2211_ sky130_fd_sc_hd__nor2_1
X_6290_ net114 _2006_ _2009_ _2982_ VGND VGND VPWR VPWR _0610_ sky130_fd_sc_hd__a22o_1
XFILLER_0_11_97 VGND VGND VPWR VPWR sky130_fd_sc_hd__decap_3
X_5241_ net785 _0939_ VGND VGND VPWR VPWR _2154_ sky130_fd_sc_hd__and2_1
X_5172_ _1884_ _2108_ _2109_ _1803_ net733 VGND VGND VPWR VPWR _0365_ sky130_fd_sc_hd__a32o_1
X_4123_ u_pe_array.g_pe_row\[3\].g_pe_col\[1\].u_pe.psum_out\[12\] u_pe_array.g_pe_row\[3\].g_pe_col\[1\].u_pe.move_reg\[12\]
+ _0947_ VGND VGND VPWR VPWR _1302_ sky130_fd_sc_hd__mux2_1
Xinput2 h_in0[1] VGND VGND VPWR VPWR net2 sky130_fd_sc_hd__clkbuf_2
X_4054_ u_pe_array.g_pe_row\[3\].g_pe_col\[2\].u_pe.psum_out\[8\] _0934_ VGND VGND
+ VPWR VPWR _1252_ sky130_fd_sc_hd__nand2_1
X_7813_ clknet_leaf_51_clk _0718_ net74 VGND VGND VPWR VPWR u_pe_array.g_pe_row\[0\].g_pe_col\[0\].u_pe.psum_out\[8\]
+ sky130_fd_sc_hd__dfrtp_2
X_7744_ clknet_leaf_50_clk _0650_ net947 VGND VGND VPWR VPWR u_pe_array.act_from_right\[0\]\[7\]
+ sky130_fd_sc_hd__dfrtp_1
X_4956_ u_pe_array.g_pe_row\[2\].g_pe_col\[1\].u_pe.act_val\[5\] VGND VGND VPWR VPWR
+ _1938_ sky130_fd_sc_hd__inv_2
XFILLER_0_52_93 VGND VGND VPWR VPWR sky130_fd_sc_hd__decap_8
X_4887_ u_pe_array.g_pe_row\[2\].g_pe_col\[1\].u_pe.act_val\[5\] _1882_ _1873_ net91
+ VGND VGND VPWR VPWR _0307_ sky130_fd_sc_hd__a22o_1
X_7675_ clknet_leaf_63_clk net313 net74 VGND VGND VPWR VPWR u_pe_array.g_pe_row\[0\].g_pe_col\[3\].u_pe.move_reg\[7\]
+ sky130_fd_sc_hd__dfrtp_1
X_3907_ u_pe_array.g_pe_row\[3\].g_pe_col\[2\].u_pe.psum_out\[8\] _1112_ _1109_ _1143_
+ VGND VGND VPWR VPWR _1144_ sky130_fd_sc_hd__o211a_1
X_3838_ _1086_ _1087_ VGND VGND VPWR VPWR _1088_ sky130_fd_sc_hd__nand2_1
X_6626_ net168 _1731_ _1734_ _3237_ VGND VGND VPWR VPWR _0691_ sky130_fd_sc_hd__a22o_1
XFILLER_0_61_225 VGND VGND VPWR VPWR sky130_fd_sc_hd__fill_2
X_6557_ u_pe_array.g_pe_row\[0\].g_pe_col\[1\].u_pe.psum_out\[7\] _2268_ VGND VGND
+ VPWR VPWR _3184_ sky130_fd_sc_hd__nand2_1
XFILLER_0_14_141 VPWR VGND VPWR VGND sky130_ef_sc_hd__decap_12
XFILLER_0_6_374 VGND VGND VPWR VPWR sky130_fd_sc_hd__fill_2
XFILLER_0_42_450 VGND VGND VPWR VPWR sky130_fd_sc_hd__fill_1
X_3769_ _1023_ _1024_ VGND VGND VPWR VPWR _1025_ sky130_fd_sc_hd__xnor2_2
XFILLER_0_15_697 VGND VGND VPWR VPWR sky130_fd_sc_hd__decap_4
X_5508_ u_pe_array.u_fifo2.buffer\[4\]\[4\] net68 _2366_ _2368_ VGND VGND VPWR VPWR
+ _2369_ sky130_fd_sc_hd__a211o_1
X_6488_ _3119_ _3120_ VGND VGND VPWR VPWR _3121_ sky130_fd_sc_hd__xor2_1
XFILLER_0_30_645 VPWR VGND VPWR VGND sky130_ef_sc_hd__decap_12
XFILLER_0_100_522 VGND VGND VPWR VPWR sky130_fd_sc_hd__fill_2
X_5439_ _2315_ VGND VGND VPWR VPWR _0426_ sky130_fd_sc_hd__clkbuf_1
XFILLER_0_100_577 VGND VGND VPWR VPWR sky130_fd_sc_hd__fill_1
X_7109_ clknet_leaf_104_clk _0015_ net944 VGND VGND VPWR VPWR u_pe_array.g_pe_row\[3\].g_pe_col\[2\].u_pe.w_out\[0\]
+ sky130_fd_sc_hd__dfrtp_4
XTAP_1012 VGND VPWR sky130_fd_sc_hd__tapvpwrvgnd_1
XTAP_1001 VGND VPWR sky130_fd_sc_hd__tapvpwrvgnd_1
XFILLER_0_96_188 VGND VGND VPWR VPWR sky130_fd_sc_hd__fill_1
XTAP_1056 VGND VPWR sky130_fd_sc_hd__tapvpwrvgnd_1
XTAP_1045 VGND VPWR sky130_fd_sc_hd__tapvpwrvgnd_1
XTAP_1034 VGND VPWR sky130_fd_sc_hd__tapvpwrvgnd_1
XTAP_1023 VGND VPWR sky130_fd_sc_hd__tapvpwrvgnd_1
XFILLER_0_38_701 VGND VGND VPWR VPWR sky130_fd_sc_hd__decap_4
XTAP_1078 VGND VPWR sky130_fd_sc_hd__tapvpwrvgnd_1
XTAP_1089 VGND VPWR sky130_fd_sc_hd__tapvpwrvgnd_1
XTAP_1067 VGND VPWR sky130_fd_sc_hd__tapvpwrvgnd_1
XFILLER_0_107_154 VGND VGND VPWR VPWR sky130_fd_sc_hd__decap_8
XFILLER_0_107_121 VGND VGND VPWR VPWR sky130_fd_sc_hd__fill_1
XFILLER_0_108_699 VGND VGND VPWR VPWR sky130_fd_sc_hd__fill_1
XFILLER_0_40_409 VGND VGND VPWR VPWR sky130_fd_sc_hd__decap_8
XFILLER_0_0_517 VPWR VGND VPWR VGND sky130_ef_sc_hd__decap_12
XFILLER_0_21_689 VPWR VGND VPWR VGND sky130_ef_sc_hd__decap_12
XTAP_807 VGND VPWR sky130_fd_sc_hd__tapvpwrvgnd_1
XTAP_818 VGND VPWR sky130_fd_sc_hd__tapvpwrvgnd_1
XTAP_829 VGND VPWR sky130_fd_sc_hd__tapvpwrvgnd_1
XFILLER_0_88_601 VGND VGND VPWR VPWR sky130_fd_sc_hd__fill_1
XFILLER_0_88_645 VPWR VGND VPWR VGND sky130_ef_sc_hd__decap_12
XFILLER_0_88_634 VGND VGND VPWR VPWR sky130_fd_sc_hd__decap_8
XFILLER_0_88_623 VGND VGND VPWR VPWR sky130_fd_sc_hd__decap_3
XFILLER_0_73_48 VGND VGND VPWR VPWR sky130_fd_sc_hd__decap_8
XFILLER_0_75_328 VGND VGND VPWR VPWR sky130_fd_sc_hd__decap_8
X_4810_ u_pe_array.g_pe_row\[2\].g_pe_col\[2\].u_pe.psum_out\[8\] _0933_ VGND VGND
+ VPWR VPWR _1831_ sky130_fd_sc_hd__nand2_1
XFILLER_0_118_408 VPWR VGND VPWR VGND sky130_ef_sc_hd__decap_12
X_5790_ u_pe_array.g_pe_row\[1\].g_pe_col\[1\].u_pe.psum_out\[8\] _1728_ VGND VGND
+ VPWR VPWR _2593_ sky130_fd_sc_hd__or2_1
XFILLER_0_7_105 VGND VGND VPWR VPWR sky130_fd_sc_hd__decap_6
XTAP_1590 VGND VPWR sky130_fd_sc_hd__tapvpwrvgnd_1
XFILLER_0_90_309 VGND VGND VPWR VPWR sky130_fd_sc_hd__decap_8
X_4741_ _1761_ _1767_ VGND VGND VPWR VPWR _1768_ sky130_fd_sc_hd__nor2_1
X_7460_ clknet_leaf_30_clk _0366_ net71 VGND VGND VPWR VPWR u_pe_array.g_pe_row\[2\].g_pe_col\[0\].u_pe.psum_out\[10\]
+ sky130_fd_sc_hd__dfrtp_2
X_4672_ u_pe_array.g_pe_row\[1\].g_pe_col\[1\].u_pe.w_out\[1\] VGND VGND VPWR VPWR
+ _1728_ sky130_fd_sc_hd__clkbuf_8
XFILLER_0_7_149 VGND VGND VPWR VPWR sky130_fd_sc_hd__decap_8
XFILLER_0_16_417 VGND VGND VPWR VPWR sky130_fd_sc_hd__decap_3
XFILLER_0_22_63 VGND VGND VPWR VPWR sky130_fd_sc_hd__fill_1
XFILLER_0_22_85 VGND VGND VPWR VPWR sky130_fd_sc_hd__decap_6
XFILLER_0_113_113 VPWR VGND VPWR VGND sky130_ef_sc_hd__decap_12
X_3623_ u_pe_array.u_fifo2.wr_ptr\[2\] _0915_ _0916_ u_pe_array.u_fifo2.wr_ptr\[3\]
+ VGND VGND VPWR VPWR _0917_ sky130_fd_sc_hd__or4b_1
X_6411_ u_pe_array.g_pe_row\[0\].g_pe_col\[2\].u_pe.psum_out\[8\] u_pe_array.g_pe_row\[0\].g_pe_col\[2\].u_pe.psum_out\[9\]
+ _2130_ VGND VGND VPWR VPWR _3077_ sky130_fd_sc_hd__and3_1
XFILLER_0_114_669 VPWR VGND VPWR VGND sky130_ef_sc_hd__decap_12
X_7391_ clknet_leaf_35_clk _0297_ net942 VGND VGND VPWR VPWR u_pe_array.act_from_right\[8\]\[8\]
+ sky130_fd_sc_hd__dfrtp_1
XFILLER_0_12_645 VPWR VGND VPWR VGND sky130_ef_sc_hd__decap_12
XFILLER_0_11_111 VGND VGND VPWR VPWR sky130_fd_sc_hd__fill_1
X_3554_ _0861_ VGND VGND VPWR VPWR _0862_ sky130_fd_sc_hd__clkbuf_4
X_6342_ _3005_ _3006_ _3012_ VGND VGND VPWR VPWR _3014_ sky130_fd_sc_hd__o21ai_1
XFILLER_0_11_133 VGND VGND VPWR VPWR sky130_fd_sc_hd__decap_6
X_6273_ u_pe_array.g_pe_row\[0\].g_pe_col\[2\].u_pe.psum_out\[0\] u_pe_array.g_pe_row\[0\].g_pe_col\[2\].u_pe.act_val\[0\]
+ _2844_ VGND VGND VPWR VPWR _2974_ sky130_fd_sc_hd__mux2_1
X_5224_ net132 _2143_ _2132_ _2145_ VGND VGND VPWR VPWR _0381_ sky130_fd_sc_hd__a22o_1
X_5155_ _2056_ _2067_ _2068_ VGND VGND VPWR VPWR _2094_ sky130_fd_sc_hd__o21bai_1
X_5086_ _2028_ _2030_ VGND VGND VPWR VPWR _2031_ sky130_fd_sc_hd__xnor2_1
X_4106_ u_pe_array.g_pe_row\[3\].g_pe_col\[1\].u_pe.psum_out\[4\] u_pe_array.g_pe_row\[3\].g_pe_col\[1\].u_pe.act_val\[4\]
+ _0947_ VGND VGND VPWR VPWR _1293_ sky130_fd_sc_hd__mux2_1
X_4037_ _1234_ _1236_ VGND VGND VPWR VPWR _1237_ sky130_fd_sc_hd__xnor2_1
XPHY_106 VGND VGND VPWR VPWR sky130_fd_sc_hd__decap_3
XPHY_139 VGND VGND VPWR VPWR sky130_fd_sc_hd__decap_3
XPHY_128 VGND VGND VPWR VPWR sky130_fd_sc_hd__decap_3
XPHY_117 VGND VGND VPWR VPWR sky130_fd_sc_hd__decap_3
X_5988_ u_pe_array.g_pe_row\[1\].g_pe_col\[0\].u_pe.act_val\[1\] _1865_ VGND VGND
+ VPWR VPWR _2743_ sky130_fd_sc_hd__and2b_1
XFILLER_0_47_520 VPWR VGND VPWR VGND sky130_ef_sc_hd__decap_12
X_4939_ u_pe_array.g_pe_row\[2\].g_pe_col\[1\].u_pe.psum_out\[3\] _1908_ _1909_ VGND
+ VGND VPWR VPWR _1923_ sky130_fd_sc_hd__a21boi_2
XFILLER_0_35_704 VGND VGND VPWR VPWR sky130_fd_sc_hd__fill_1
X_7727_ clknet_leaf_74_clk _0633_ net13 VGND VGND VPWR VPWR u_pe_array.g_pe_row\[0\].g_pe_col\[2\].u_pe.psum_out\[5\]
+ sky130_fd_sc_hd__dfrtp_1
X_7658_ clknet_leaf_60_clk _0564_ net74 VGND VGND VPWR VPWR u_pe_array.act_from_right\[2\]\[3\]
+ sky130_fd_sc_hd__dfrtp_1
XFILLER_0_34_225 VGND VGND VPWR VPWR sky130_fd_sc_hd__fill_1
X_6609_ u_fsm.ch_cnt\[0\] u_fsm.ch_cnt\[1\] VGND VGND VPWR VPWR _3229_ sky130_fd_sc_hd__or2_1
X_7589_ clknet_leaf_32_clk _0495_ net71 VGND VGND VPWR VPWR u_pe_array.g_pe_row\[1\].g_pe_col\[1\].u_pe.psum_out\[3\]
+ sky130_fd_sc_hd__dfrtp_2
XFILLER_0_104_135 VGND VGND VPWR VPWR sky130_fd_sc_hd__decap_4
XFILLER_0_62_589 VGND VGND VPWR VPWR sky130_fd_sc_hd__fill_2
XFILLER_0_30_442 VGND VGND VPWR VPWR sky130_fd_sc_hd__decap_4
XFILLER_0_69_111 VGND VGND VPWR VPWR sky130_fd_sc_hd__fill_1
Xmax_cap64 _3278_ VGND VGND VPWR VPWR net64 sky130_fd_sc_hd__clkbuf_1
XPHY_8 VGND VGND VPWR VPWR sky130_fd_sc_hd__decap_3
XFILLER_0_72_309 VGND VGND VPWR VPWR sky130_fd_sc_hd__fill_1
XFILLER_0_108_430 VGND VGND VPWR VPWR sky130_fd_sc_hd__fill_2
XFILLER_0_93_670 VGND VGND VPWR VPWR sky130_fd_sc_hd__fill_2
XFILLER_0_38_586 VGND VGND VPWR VPWR sky130_fd_sc_hd__fill_2
XFILLER_0_38_597 VGND VGND VPWR VPWR sky130_fd_sc_hd__decap_8
XFILLER_0_13_409 VGND VGND VPWR VPWR sky130_fd_sc_hd__decap_8
XFILLER_0_68_26 VGND VGND VPWR VPWR sky130_fd_sc_hd__fill_2
XFILLER_0_68_15 VGND VGND VPWR VPWR sky130_fd_sc_hd__fill_2
XFILLER_0_21_420 VPWR VGND VPWR VGND sky130_ef_sc_hd__decap_12
XFILLER_0_110_138 VGND VGND VPWR VPWR sky130_fd_sc_hd__fill_2
XFILLER_0_0_358 VGND VGND VPWR VPWR sky130_fd_sc_hd__fill_2
XTAP_604 VGND VPWR sky130_fd_sc_hd__tapvpwrvgnd_1
XTAP_615 VGND VPWR sky130_fd_sc_hd__tapvpwrvgnd_1
XTAP_626 VGND VPWR sky130_fd_sc_hd__tapvpwrvgnd_1
XTAP_637 VGND VPWR sky130_fd_sc_hd__tapvpwrvgnd_1
XTAP_648 VGND VPWR sky130_fd_sc_hd__tapvpwrvgnd_1
XTAP_659 VGND VPWR sky130_fd_sc_hd__tapvpwrvgnd_1
XFILLER_0_108_65 VPWR VGND VPWR VGND sky130_ef_sc_hd__decap_12
X_6960_ u_pe_array.u_fifo1.rd_ptr\[0\] _3463_ net823 VGND VGND VPWR VPWR _3467_ sky130_fd_sc_hd__a21oi_1
X_5911_ u_pe_array.u_fifo1.rd_ptr\[3\] u_pe_array.u_fifo1.rd_ptr\[2\] u_pe_array.u_fifo1.rd_ptr\[1\]
+ u_pe_array.u_fifo1.rd_ptr\[0\] VGND VGND VPWR VPWR _2681_ sky130_fd_sc_hd__and4b_2
X_6891_ _3426_ VGND VGND VPWR VPWR _0767_ sky130_fd_sc_hd__clkbuf_1
X_5842_ u_pe_array.g_pe_row\[1\].g_pe_col\[0\].u_pe.psum_out\[2\] _1108_ _1110_ _2635_
+ VGND VGND VPWR VPWR _2636_ sky130_fd_sc_hd__o211a_2
X_5773_ _2233_ _2576_ _2577_ _2173_ net582 VGND VGND VPWR VPWR _0498_ sky130_fd_sc_hd__a32o_1
XFILLER_0_91_629 VGND VGND VPWR VPWR sky130_fd_sc_hd__decap_8
XFILLER_0_75_169 VGND VGND VPWR VPWR sky130_fd_sc_hd__decap_8
XFILLER_0_75_147 VGND VGND VPWR VPWR sky130_fd_sc_hd__decap_3
XFILLER_0_29_553 VGND VGND VPWR VPWR sky130_fd_sc_hd__fill_2
XFILLER_0_90_117 VGND VGND VPWR VPWR sky130_fd_sc_hd__decap_3
X_7512_ clknet_leaf_68_clk _0418_ net947 VGND VGND VPWR VPWR u_pe_array.act_from_right\[5\]\[6\]
+ sky130_fd_sc_hd__dfrtp_1
XFILLER_0_16_214 VGND VGND VPWR VPWR sky130_fd_sc_hd__fill_1
X_4724_ _1752_ VGND VGND VPWR VPWR _1753_ sky130_fd_sc_hd__inv_2
XFILLER_0_16_225 VPWR VGND VPWR VGND sky130_ef_sc_hd__decap_12
X_7443_ clknet_leaf_35_clk net278 net951 VGND VGND VPWR VPWR u_pe_array.g_pe_row\[2\].g_pe_col\[0\].u_pe.move_reg\[6\]
+ sky130_fd_sc_hd__dfrtp_1
XFILLER_0_31_217 VGND VGND VPWR VPWR sky130_fd_sc_hd__decap_6
X_4655_ _1709_ _1713_ VGND VGND VPWR VPWR _1715_ sky130_fd_sc_hd__or2_1
XFILLER_0_114_477 VGND VGND VPWR VPWR sky130_fd_sc_hd__decap_4
XFILLER_0_102_628 VGND VGND VPWR VPWR sky130_fd_sc_hd__decap_4
Xhold800 u_pe_array.act_from_left\[5\]\[2\] VGND VGND VPWR VPWR net874 sky130_fd_sc_hd__dlygate4sd3_1
X_3606_ _0902_ _0901_ _0903_ VGND VGND VPWR VPWR _0005_ sky130_fd_sc_hd__a21oi_1
X_7374_ clknet_leaf_108_clk _0280_ net944 VGND VGND VPWR VPWR u_pe_array.g_pe_row\[2\].g_pe_col\[2\].u_pe.psum_out\[6\]
+ sky130_fd_sc_hd__dfrtp_1
Xhold811 u_pe_array.g_pe_row\[2\].g_pe_col\[2\].u_pe.psum_out\[9\] VGND VGND VPWR
+ VPWR net885 sky130_fd_sc_hd__dlygate4sd3_1
X_4586_ _1647_ _1651_ VGND VGND VPWR VPWR _1652_ sky130_fd_sc_hd__xnor2_1
Xhold833 u_pe_array.g_pe_row\[0\].g_pe_col\[0\].u_pe.psum_out\[9\] VGND VGND VPWR
+ VPWR net907 sky130_fd_sc_hd__dlygate4sd3_1
Xhold855 u_pe_array.g_pe_row\[0\].g_pe_col\[3\].u_pe.psum_out\[10\] VGND VGND VPWR
+ VPWR net929 sky130_fd_sc_hd__dlygate4sd3_1
Xhold844 u_pe_array.g_pe_row\[3\].g_pe_col\[3\].u_pe.act_val\[5\] VGND VGND VPWR VPWR
+ net918 sky130_fd_sc_hd__dlygate4sd3_1
Xhold822 u_pe_array.act_from_left\[7\]\[0\] VGND VGND VPWR VPWR net896 sky130_fd_sc_hd__dlygate4sd3_1
XFILLER_0_4_697 VGND VGND VPWR VPWR sky130_fd_sc_hd__decap_3
X_6325_ u_pe_array.g_pe_row\[0\].g_pe_col\[2\].u_pe.psum_out\[2\] _2997_ VGND VGND
+ VPWR VPWR _2998_ sky130_fd_sc_hd__xnor2_1
X_6256_ _2960_ _2961_ net929 _1007_ VGND VGND VPWR VPWR _0597_ sky130_fd_sc_hd__a2bb2o_1
XFILLER_0_58_81 VGND VGND VPWR VPWR sky130_fd_sc_hd__decap_3
X_6187_ _2896_ _2897_ VGND VGND VPWR VPWR _2899_ sky130_fd_sc_hd__and2_1
X_5207_ net419 _1882_ _2132_ _2136_ VGND VGND VPWR VPWR _0373_ sky130_fd_sc_hd__a22o_1
X_5138_ _2077_ _2078_ VGND VGND VPWR VPWR _2079_ sky130_fd_sc_hd__or2b_1
X_5069_ u_pe_array.act_from_right\[8\]\[12\] _2016_ _1883_ net263 VGND VGND VPWR VPWR
+ _0355_ sky130_fd_sc_hd__a22o_1
XFILLER_0_39_317 VPWR VGND VPWR VGND sky130_ef_sc_hd__decap_12
XFILLER_0_66_147 VGND VGND VPWR VPWR sky130_fd_sc_hd__fill_1
XFILLER_0_82_629 VGND VGND VPWR VPWR sky130_fd_sc_hd__fill_1
XFILLER_0_90_673 VPWR VGND VPWR VGND sky130_ef_sc_hd__decap_12
XFILLER_0_35_567 VGND VGND VPWR VPWR sky130_fd_sc_hd__fill_1
XFILLER_0_38_29 VGND VGND VPWR VPWR sky130_fd_sc_hd__fill_2
XFILLER_0_97_261 VGND VGND VPWR VPWR sky130_fd_sc_hd__decap_3
XFILLER_0_58_615 VGND VGND VPWR VPWR sky130_fd_sc_hd__fill_2
XFILLER_0_57_169 VGND VGND VPWR VPWR sky130_fd_sc_hd__fill_1
XFILLER_0_53_331 VGND VGND VPWR VPWR sky130_fd_sc_hd__decap_4
XFILLER_0_108_293 VGND VGND VPWR VPWR sky130_fd_sc_hd__decap_4
XFILLER_0_81_673 VPWR VGND VPWR VGND sky130_ef_sc_hd__decap_12
XFILLER_0_80_161 VPWR VGND VPWR VGND sky130_ef_sc_hd__decap_12
Xhold107 u_pe_array.act_from_right\[8\]\[2\] VGND VGND VPWR VPWR net181 sky130_fd_sc_hd__dlygate4sd3_1
X_4440_ _1530_ _1532_ _1544_ VGND VGND VPWR VPWR _1545_ sky130_fd_sc_hd__a21oi_1
XFILLER_0_13_239 VGND VGND VPWR VPWR sky130_fd_sc_hd__decap_3
XFILLER_0_110_77 VGND VGND VPWR VPWR sky130_fd_sc_hd__decap_6
Xhold129 _0662_ VGND VGND VPWR VPWR net203 sky130_fd_sc_hd__dlygate4sd3_1
Xhold118 u_pe_array.act_from_right\[2\]\[0\] VGND VGND VPWR VPWR net192 sky130_fd_sc_hd__dlygate4sd3_1
X_4371_ _0939_ VGND VGND VPWR VPWR _1483_ sky130_fd_sc_hd__buf_6
X_6110_ u_pe_array.g_pe_row\[0\].g_pe_col\[3\].u_pe.psum_out\[3\] u_pe_array.g_pe_row\[0\].g_pe_col\[3\].u_pe.act_val\[3\]
+ _2844_ VGND VGND VPWR VPWR _2849_ sky130_fd_sc_hd__mux2_1
XFILLER_0_0_133 VGND VGND VPWR VPWR sky130_fd_sc_hd__decap_6
XFILLER_0_95_57 VPWR VGND VPWR VGND sky130_ef_sc_hd__decap_12
XFILLER_0_95_35 VPWR VGND VPWR VGND sky130_ef_sc_hd__decap_12
XTAP_412 VGND VPWR sky130_fd_sc_hd__tapvpwrvgnd_1
XTAP_401 VGND VPWR sky130_fd_sc_hd__tapvpwrvgnd_1
XTAP_423 VGND VPWR sky130_fd_sc_hd__tapvpwrvgnd_1
X_7090_ _3542_ VGND VGND VPWR VPWR _0850_ sky130_fd_sc_hd__clkbuf_1
XTAP_434 VGND VPWR sky130_fd_sc_hd__tapvpwrvgnd_1
XTAP_445 VGND VPWR sky130_fd_sc_hd__tapvpwrvgnd_1
XTAP_456 VGND VPWR sky130_fd_sc_hd__tapvpwrvgnd_1
XTAP_467 VGND VPWR sky130_fd_sc_hd__tapvpwrvgnd_1
X_6041_ _2788_ _2789_ _2791_ VGND VGND VPWR VPWR _2792_ sky130_fd_sc_hd__a21oi_1
XTAP_478 VGND VPWR sky130_fd_sc_hd__tapvpwrvgnd_1
XTAP_489 VGND VPWR sky130_fd_sc_hd__tapvpwrvgnd_1
XFILLER_0_21_6 VGND VGND VPWR VPWR sky130_fd_sc_hd__fill_2
X_6943_ u_pe_array.u_fifo1.wr_ptr\[0\] _3349_ VGND VGND VPWR VPWR _3455_ sky130_fd_sc_hd__or2_1
XFILLER_0_44_61 VGND VGND VPWR VPWR sky130_fd_sc_hd__fill_1
XFILLER_0_88_283 VGND VGND VPWR VPWR sky130_fd_sc_hd__fill_1
XFILLER_0_76_434 VPWR VGND VPWR VGND sky130_ef_sc_hd__decap_12
X_6874_ net599 _0920_ _3415_ VGND VGND VPWR VPWR _3417_ sky130_fd_sc_hd__mux2_1
XFILLER_0_44_83 VGND VGND VPWR VPWR sky130_fd_sc_hd__fill_1
XFILLER_0_49_648 VPWR VGND VPWR VGND sky130_ef_sc_hd__decap_12
X_5825_ u_pe_array.g_pe_row\[1\].g_pe_col\[1\].u_pe.psum_out\[12\] _2615_ VGND VGND
+ VPWR VPWR _2624_ sky130_fd_sc_hd__xnor2_1
XFILLER_0_36_309 VGND VGND VPWR VPWR sky130_fd_sc_hd__decap_4
X_5756_ _2550_ _2553_ _2561_ VGND VGND VPWR VPWR _2562_ sky130_fd_sc_hd__or3_1
XFILLER_0_56_180 VPWR VGND VPWR VGND sky130_ef_sc_hd__decap_12
X_5687_ u_pe_array.act_from_right\[5\]\[3\] u_pe_array.act_from_left\[5\]\[3\] _0963_
+ VGND VGND VPWR VPWR _2508_ sky130_fd_sc_hd__mux2_1
XFILLER_0_60_93 VGND VGND VPWR VPWR sky130_fd_sc_hd__fill_2
X_4707_ u_pe_array.g_pe_row\[2\].g_pe_col\[2\].u_pe.act_val\[0\] _1605_ _1611_ net333
+ VGND VGND VPWR VPWR _0261_ sky130_fd_sc_hd__a22o_1
XFILLER_0_44_375 VPWR VGND VPWR VGND sky130_ef_sc_hd__decap_12
X_7426_ clknet_leaf_100_clk _0332_ net950 VGND VGND VPWR VPWR u_pe_array.act_from_up\[12\]\[2\]
+ sky130_fd_sc_hd__dfrtp_1
XFILLER_0_32_537 VGND VGND VPWR VPWR sky130_fd_sc_hd__fill_1
X_4638_ _1691_ _1694_ _1699_ VGND VGND VPWR VPWR _1700_ sky130_fd_sc_hd__a21oi_2
XFILLER_0_102_436 VGND VGND VPWR VPWR sky130_fd_sc_hd__fill_2
Xhold630 u_pe_array.g_pe_row\[3\].g_pe_col\[1\].u_pe.psum_out\[11\] VGND VGND VPWR
+ VPWR net704 sky130_fd_sc_hd__dlygate4sd3_1
XFILLER_0_8_83 VGND VGND VPWR VPWR sky130_fd_sc_hd__fill_1
Xhold652 u_pe_array.g_pe_row\[3\].g_pe_col\[2\].u_pe.act_val\[4\] VGND VGND VPWR VPWR
+ net726 sky130_fd_sc_hd__dlygate4sd3_1
Xhold663 u_pe_array.u_fifo2.buffer\[4\]\[0\] VGND VGND VPWR VPWR net737 sky130_fd_sc_hd__dlygate4sd3_1
X_7357_ clknet_leaf_108_clk net174 net944 VGND VGND VPWR VPWR u_pe_array.g_pe_row\[2\].g_pe_col\[2\].u_pe.act_val\[2\]
+ sky130_fd_sc_hd__dfrtp_2
Xhold641 u_pe_array.u_fifo1.buffer\[4\]\[1\] VGND VGND VPWR VPWR net715 sky130_fd_sc_hd__dlygate4sd3_1
X_4569_ _1635_ _1427_ u_pe_array.g_pe_row\[2\].g_pe_col\[3\].u_pe.psum_out\[3\] VGND
+ VGND VPWR VPWR _1636_ sky130_fd_sc_hd__a21oi_1
Xhold685 u_pe_array.g_pe_row\[2\].g_pe_col\[0\].u_pe.psum_out\[12\] VGND VGND VPWR
+ VPWR net759 sky130_fd_sc_hd__dlygate4sd3_1
X_6308_ net403 _2730_ _2511_ net444 VGND VGND VPWR VPWR _0623_ sky130_fd_sc_hd__a22o_1
Xhold674 _1309_ VGND VGND VPWR VPWR net748 sky130_fd_sc_hd__dlygate4sd3_1
X_7288_ clknet_leaf_6_clk _0194_ net950 VGND VGND VPWR VPWR u_pe_array.g_pe_row\[3\].g_pe_col\[0\].u_pe.psum_out\[2\]
+ sky130_fd_sc_hd__dfrtp_1
XFILLER_0_12_283 VPWR VGND VPWR VGND sky130_ef_sc_hd__decap_12
Xhold696 u_pe_array.g_pe_row\[0\].g_pe_col\[2\].u_pe.psum_out\[2\] VGND VGND VPWR
+ VPWR net770 sky130_fd_sc_hd__dlygate4sd3_1
X_6239_ net780 _2586_ _2944_ _2946_ VGND VGND VPWR VPWR _0595_ sky130_fd_sc_hd__a22o_1
XTAP_990 VGND VPWR sky130_fd_sc_hd__tapvpwrvgnd_1
XFILLER_0_99_548 VPWR VGND VPWR VGND sky130_ef_sc_hd__decap_12
XFILLER_0_79_250 VGND VGND VPWR VPWR sky130_fd_sc_hd__fill_1
XFILLER_0_67_423 VPWR VGND VPWR VGND sky130_ef_sc_hd__decap_12
XFILLER_0_67_445 VGND VGND VPWR VPWR sky130_fd_sc_hd__decap_3
XFILLER_0_55_629 VPWR VGND VPWR VGND sky130_ef_sc_hd__decap_12
XFILLER_0_39_169 VPWR VGND VPWR VGND sky130_ef_sc_hd__decap_12
XFILLER_0_54_139 VGND VGND VPWR VPWR sky130_fd_sc_hd__fill_1
Xload_slew8 net73 VGND VGND VPWR VPWR net947 sky130_fd_sc_hd__buf_12
XFILLER_0_35_342 VGND VGND VPWR VPWR sky130_fd_sc_hd__fill_1
XFILLER_0_50_334 VGND VGND VPWR VPWR sky130_fd_sc_hd__fill_2
XFILLER_0_105_274 VGND VGND VPWR VPWR sky130_fd_sc_hd__decap_6
XFILLER_0_81_15 VGND VGND VPWR VPWR sky130_fd_sc_hd__decap_8
X_3940_ _1159_ VGND VGND VPWR VPWR _1166_ sky130_fd_sc_hd__buf_6
XFILLER_0_105_55 VGND VGND VPWR VPWR sky130_fd_sc_hd__fill_1
XFILLER_0_85_275 VGND VGND VPWR VPWR sky130_fd_sc_hd__decap_4
XFILLER_0_18_309 VGND VGND VPWR VPWR sky130_fd_sc_hd__fill_1
X_3871_ _1115_ VGND VGND VPWR VPWR _1116_ sky130_fd_sc_hd__buf_12
X_6590_ u_pe_array.g_pe_row\[0\].g_pe_col\[1\].u_pe.psum_out\[10\] _3203_ VGND VGND
+ VPWR VPWR _3214_ sky130_fd_sc_hd__nor2_1
XFILLER_0_14_97 VGND VGND VPWR VPWR sky130_fd_sc_hd__decap_4
X_5610_ _2437_ _2447_ _2452_ _2453_ VGND VGND VPWR VPWR _2454_ sky130_fd_sc_hd__o31a_1
X_5541_ _2270_ u_pe_array.g_pe_row\[1\].g_pe_col\[2\].u_pe.psum_out\[1\] _1597_ VGND
+ VGND VPWR VPWR _2391_ sky130_fd_sc_hd__o21a_1
XFILLER_0_112_701 VGND VGND VPWR VPWR sky130_fd_sc_hd__decap_4
XFILLER_0_26_397 VGND VGND VPWR VPWR sky130_fd_sc_hd__fill_1
XFILLER_0_30_52 VGND VGND VPWR VPWR sky130_fd_sc_hd__decap_8
X_7211_ clknet_leaf_22_clk _0117_ net942 VGND VGND VPWR VPWR u_pe_array.act_from_down\[9\]\[5\]
+ sky130_fd_sc_hd__dfrtp_1
X_5472_ u_pe_array.u_fifo2.buffer\[3\]\[0\] _2331_ _2332_ u_pe_array.u_fifo2.buffer\[2\]\[0\]
+ _2336_ VGND VGND VPWR VPWR _2337_ sky130_fd_sc_hd__a221o_1
XFILLER_0_111_222 VGND VGND VPWR VPWR sky130_fd_sc_hd__fill_2
X_4423_ _1527_ _1528_ VGND VGND VPWR VPWR _1529_ sky130_fd_sc_hd__xnor2_2
X_7142_ clknet_leaf_20_clk _0048_ net70 VGND VGND VPWR VPWR u_pe_array.g_pe_row\[3\].g_pe_col\[3\].u_pe.psum_out\[5\]
+ sky130_fd_sc_hd__dfrtp_2
X_4354_ net934 _1301_ _1305_ _1477_ VGND VGND VPWR VPWR _0179_ sky130_fd_sc_hd__a22o_1
XTAP_242 VGND VPWR sky130_fd_sc_hd__tapvpwrvgnd_1
XFILLER_0_1_497 VGND VGND VPWR VPWR sky130_fd_sc_hd__decap_6
X_7073_ _3533_ VGND VGND VPWR VPWR _0842_ sky130_fd_sc_hd__clkbuf_1
X_4285_ net779 _1433_ _1116_ VGND VGND VPWR VPWR _1434_ sky130_fd_sc_hd__mux2_1
XTAP_264 VGND VPWR sky130_fd_sc_hd__tapvpwrvgnd_1
XTAP_253 VGND VPWR sky130_fd_sc_hd__tapvpwrvgnd_1
XTAP_275 VGND VPWR sky130_fd_sc_hd__tapvpwrvgnd_1
X_6024_ u_pe_array.g_pe_row\[1\].g_pe_col\[0\].u_pe.psum_out\[5\] _2775_ VGND VGND
+ VPWR VPWR _2776_ sky130_fd_sc_hd__xnor2_2
XTAP_297 VGND VPWR sky130_fd_sc_hd__tapvpwrvgnd_1
XTAP_286 VGND VPWR sky130_fd_sc_hd__tapvpwrvgnd_1
XFILLER_0_96_529 VGND VGND VPWR VPWR sky130_fd_sc_hd__decap_3
XTAP_1408 VGND VPWR sky130_fd_sc_hd__tapvpwrvgnd_1
XTAP_1419 VGND VPWR sky130_fd_sc_hd__tapvpwrvgnd_1
XFILLER_0_89_570 VGND VGND VPWR VPWR sky130_fd_sc_hd__decap_4
X_6926_ _3365_ _3422_ VGND VGND VPWR VPWR _3446_ sky130_fd_sc_hd__or2_2
X_6857_ u_pe_array.u_fifo2.wr_ptr\[0\] u_pe_array.u_fifo2.wr_ptr\[1\] _3391_ VGND
+ VGND VPWR VPWR _3407_ sky130_fd_sc_hd__and3b_1
X_5808_ u_pe_array.g_pe_row\[1\].g_pe_col\[1\].u_pe.psum_out\[10\] _1728_ VGND VGND
+ VPWR VPWR _2609_ sky130_fd_sc_hd__or2_1
XFILLER_0_91_223 VGND VGND VPWR VPWR sky130_fd_sc_hd__fill_1
XFILLER_0_64_459 VGND VGND VPWR VPWR sky130_fd_sc_hd__fill_2
X_6788_ _3362_ net738 _3352_ VGND VGND VPWR VPWR _3363_ sky130_fd_sc_hd__mux2_1
X_5739_ u_pe_array.g_pe_row\[1\].g_pe_col\[1\].u_pe.act_val\[4\] u_pe_array.g_pe_row\[1\].g_pe_col\[1\].u_pe.w_out\[0\]
+ VGND VGND VPWR VPWR _2546_ sky130_fd_sc_hd__nand2_1
XFILLER_0_45_673 VGND VGND VPWR VPWR sky130_fd_sc_hd__decap_8
XFILLER_0_115_594 VGND VGND VPWR VPWR sky130_fd_sc_hd__decap_8
XFILLER_0_44_194 VGND VGND VPWR VPWR sky130_fd_sc_hd__fill_2
X_7409_ clknet_leaf_23_clk _0315_ net943 VGND VGND VPWR VPWR u_pe_array.g_pe_row\[2\].g_pe_col\[1\].u_pe.psum_out\[0\]
+ sky130_fd_sc_hd__dfrtp_1
Xhold471 u_pe_array.g_pe_row\[1\].g_pe_col\[1\].u_pe.psum_out\[1\] VGND VGND VPWR
+ VPWR net545 sky130_fd_sc_hd__dlygate4sd3_1
XFILLER_0_102_277 VGND VGND VPWR VPWR sky130_fd_sc_hd__fill_1
Xhold460 u_pe_array.g_pe_row\[2\].g_pe_col\[0\].u_pe.psum_out\[0\] VGND VGND VPWR
+ VPWR net534 sky130_fd_sc_hd__dlygate4sd3_1
XFILLER_0_13_581 VPWR VGND VPWR VGND sky130_ef_sc_hd__decap_12
Xhold493 u_pe_array.u_fifo1.buffer\[7\]\[2\] VGND VGND VPWR VPWR net567 sky130_fd_sc_hd__dlygate4sd3_1
Xhold482 u_pe_array.u_fifo2.buffer\[0\]\[5\] VGND VGND VPWR VPWR net556 sky130_fd_sc_hd__dlygate4sd3_1
XFILLER_0_35_19 VGND VGND VPWR VPWR sky130_fd_sc_hd__fill_1
XFILLER_0_95_595 VGND VGND VPWR VPWR sky130_fd_sc_hd__decap_6
XFILLER_0_51_654 VGND VGND VPWR VPWR sky130_fd_sc_hd__decap_3
XFILLER_0_76_37 VGND VGND VPWR VPWR sky130_fd_sc_hd__decap_4
XFILLER_0_76_26 VGND VGND VPWR VPWR sky130_fd_sc_hd__fill_2
X_4070_ _1259_ _1260_ _1265_ _1262_ _1257_ VGND VGND VPWR VPWR _1266_ sky130_fd_sc_hd__a32o_1
XFILLER_0_116_65 VPWR VGND VPWR VGND sky130_ef_sc_hd__decap_12
X_4972_ _1944_ _1949_ _1952_ VGND VGND VPWR VPWR _1953_ sky130_fd_sc_hd__o21bai_1
X_7760_ clknet_leaf_43_clk net245 net946 VGND VGND VPWR VPWR u_pe_array.g_pe_row\[0\].g_pe_col\[1\].u_pe.move_reg\[10\]
+ sky130_fd_sc_hd__dfrtp_1
X_6711_ u_pe_array.g_pe_row\[0\].g_pe_col\[0\].u_pe.act_val\[5\] _3246_ u_pe_array.g_pe_row\[0\].g_pe_col\[0\].u_pe.psum_out\[6\]
+ VGND VGND VPWR VPWR _3298_ sky130_fd_sc_hd__o21ba_1
X_7691_ clknet_leaf_56_clk _0597_ net74 VGND VGND VPWR VPWR u_pe_array.g_pe_row\[0\].g_pe_col\[3\].u_pe.psum_out\[10\]
+ sky130_fd_sc_hd__dfrtp_2
XFILLER_0_58_253 VGND VGND VPWR VPWR sky130_fd_sc_hd__fill_2
X_3923_ u_pe_array.g_pe_row\[3\].g_pe_col\[2\].u_pe.psum_out\[12\] _1112_ _1109_ _1155_
+ VGND VGND VPWR VPWR _1156_ sky130_fd_sc_hd__o211a_1
X_6642_ u_pe_array.g_pe_row\[0\].g_pe_col\[0\].u_pe.act_val\[5\] _2343_ _2320_ net246
+ VGND VGND VPWR VPWR _0702_ sky130_fd_sc_hd__a22o_1
X_3854_ u_pe_array.g_pe_row\[3\].g_pe_col\[3\].u_pe.psum_out\[12\] _1094_ VGND VGND
+ VPWR VPWR _1102_ sky130_fd_sc_hd__xnor2_1
XFILLER_0_73_234 VGND VGND VPWR VPWR sky130_fd_sc_hd__decap_6
XFILLER_0_6_523 VGND VGND VPWR VPWR sky130_fd_sc_hd__fill_1
X_6573_ _3184_ _3197_ _3198_ VGND VGND VPWR VPWR _3199_ sky130_fd_sc_hd__a21oi_1
X_3785_ _1037_ _1039_ VGND VGND VPWR VPWR _1040_ sky130_fd_sc_hd__xor2_1
XFILLER_0_27_684 VPWR VGND VPWR VGND sky130_ef_sc_hd__decap_12
X_5524_ net104 _2016_ _1883_ u_pe_array.g_pe_row\[1\].g_pe_col\[2\].u_pe.move_reg\[10\]
+ VGND VGND VPWR VPWR _0448_ sky130_fd_sc_hd__a22o_1
XFILLER_0_6_589 VGND VGND VPWR VPWR sky130_fd_sc_hd__decap_8
XFILLER_0_112_531 VGND VGND VPWR VPWR sky130_fd_sc_hd__fill_1
XFILLER_0_14_389 VGND VGND VPWR VPWR sky130_fd_sc_hd__decap_4
XFILLER_0_41_164 VGND VGND VPWR VPWR sky130_fd_sc_hd__decap_4
X_5455_ _0943_ VGND VGND VPWR VPWR _2320_ sky130_fd_sc_hd__buf_8
XFILLER_0_67_3 VGND VGND VPWR VPWR sky130_fd_sc_hd__decap_8
X_4406_ _1512_ _1513_ VGND VGND VPWR VPWR _1514_ sky130_fd_sc_hd__or2b_1
XFILLER_0_112_597 VGND VGND VPWR VPWR sky130_fd_sc_hd__fill_1
X_5386_ u_pe_array.g_pe_row\[1\].g_pe_col\[2\].u_pe.psum_out\[1\] _1108_ _1110_ _2275_
+ VGND VGND VPWR VPWR _2276_ sky130_fd_sc_hd__o211a_1
X_7125_ clknet_leaf_3_clk _0031_ net945 VGND VGND VPWR VPWR u_pe_array.g_pe_row\[3\].g_pe_col\[3\].u_pe.act_val\[1\]
+ sky130_fd_sc_hd__dfrtp_1
X_4337_ _1437_ net627 _1158_ VGND VGND VPWR VPWR _1472_ sky130_fd_sc_hd__mux2_1
XFILLER_0_5_51 VGND VGND VPWR VPWR sky130_fd_sc_hd__decap_4
X_4268_ u_pe_array.g_pe_row\[3\].g_pe_col\[1\].u_pe.psum_out\[12\] _1414_ VGND VGND
+ VPWR VPWR _1421_ sky130_fd_sc_hd__xnor2_1
X_7056_ net574 _3356_ _3521_ VGND VGND VPWR VPWR _3524_ sky130_fd_sc_hd__mux2_1
X_6007_ _2751_ _2760_ VGND VGND VPWR VPWR _2761_ sky130_fd_sc_hd__xnor2_1
XFILLER_0_96_304 VGND VGND VPWR VPWR sky130_fd_sc_hd__decap_4
X_4199_ u_pe_array.g_pe_row\[3\].g_pe_col\[1\].u_pe.act_val\[4\] _1106_ VGND VGND
+ VPWR VPWR _1359_ sky130_fd_sc_hd__and2b_1
XTAP_1205 VGND VPWR sky130_fd_sc_hd__tapvpwrvgnd_1
XTAP_1238 VGND VPWR sky130_fd_sc_hd__tapvpwrvgnd_1
XTAP_1227 VGND VPWR sky130_fd_sc_hd__tapvpwrvgnd_1
XTAP_1216 VGND VPWR sky130_fd_sc_hd__tapvpwrvgnd_1
XFILLER_0_49_231 VGND VGND VPWR VPWR sky130_fd_sc_hd__fill_1
XTAP_1249 VGND VPWR sky130_fd_sc_hd__tapvpwrvgnd_1
X_7889_ clknet_leaf_83_clk net482 net13 VGND VGND VPWR VPWR u_pe_array.u_fifo1.wr_ptr\[3\]
+ sky130_fd_sc_hd__dfrtp_1
X_6909_ _3436_ VGND VGND VPWR VPWR _0775_ sky130_fd_sc_hd__clkbuf_1
XFILLER_0_9_350 VGND VGND VPWR VPWR sky130_fd_sc_hd__decap_8
XFILLER_0_52_418 VGND VGND VPWR VPWR sky130_fd_sc_hd__fill_2
XFILLER_0_17_172 VPWR VGND VPWR VGND sky130_ef_sc_hd__decap_12
Xhold290 u_pe_array.g_pe_row\[1\].g_pe_col\[1\].u_pe.act_val\[5\] VGND VGND VPWR VPWR
+ net364 sky130_fd_sc_hd__dlygate4sd3_1
XFILLER_0_46_29 VGND VGND VPWR VPWR sky130_fd_sc_hd__decap_4
XFILLER_0_99_164 VGND VGND VPWR VPWR sky130_fd_sc_hd__decap_4
XFILLER_0_87_337 VGND VGND VPWR VPWR sky130_fd_sc_hd__fill_2
XFILLER_0_68_551 VPWR VGND VPWR VGND sky130_ef_sc_hd__decap_12
XFILLER_0_68_584 VGND VGND VPWR VPWR sky130_fd_sc_hd__decap_4
XFILLER_0_68_573 VGND VGND VPWR VPWR sky130_fd_sc_hd__decap_3
XFILLER_0_83_521 VGND VGND VPWR VPWR sky130_fd_sc_hd__fill_2
XFILLER_0_55_223 VGND VGND VPWR VPWR sky130_fd_sc_hd__fill_1
XFILLER_0_70_248 VGND VGND VPWR VPWR sky130_fd_sc_hd__decap_4
X_3570_ _0859_ _0868_ _0876_ _0877_ VGND VGND VPWR VPWR _0878_ sky130_fd_sc_hd__o31a_1
XFILLER_0_11_87 VGND VGND VPWR VPWR sky130_fd_sc_hd__fill_1
XFILLER_0_3_559 VGND VGND VPWR VPWR sky130_fd_sc_hd__fill_1
X_5240_ net925 _2143_ _2132_ _2153_ VGND VGND VPWR VPWR _0389_ sky130_fd_sc_hd__a22o_1
X_5171_ _2100_ _2102_ _2107_ VGND VGND VPWR VPWR _2109_ sky130_fd_sc_hd__or3_1
XFILLER_0_53_9 VGND VGND VPWR VPWR sky130_fd_sc_hd__fill_2
X_4122_ _0938_ VGND VGND VPWR VPWR _1301_ sky130_fd_sc_hd__buf_6
X_4053_ _1234_ _1244_ _1249_ _1250_ VGND VGND VPWR VPWR _1251_ sky130_fd_sc_hd__o31a_1
Xinput3 h_in0[2] VGND VGND VPWR VPWR net3 sky130_fd_sc_hd__clkbuf_2
XFILLER_0_78_304 VGND VGND VPWR VPWR sky130_fd_sc_hd__decap_4
X_7812_ clknet_leaf_51_clk _0717_ net74 VGND VGND VPWR VPWR u_pe_array.g_pe_row\[0\].g_pe_col\[0\].u_pe.psum_out\[7\]
+ sky130_fd_sc_hd__dfrtp_2
XFILLER_0_78_348 VGND VGND VPWR VPWR sky130_fd_sc_hd__fill_1
X_4955_ _1884_ _1936_ _1937_ _1803_ net435 VGND VGND VPWR VPWR _0320_ sky130_fd_sc_hd__a32o_1
X_7743_ clknet_leaf_50_clk net369 net947 VGND VGND VPWR VPWR u_pe_array.act_from_right\[0\]\[6\]
+ sky130_fd_sc_hd__dfrtp_1
XFILLER_0_74_521 VGND VGND VPWR VPWR sky130_fd_sc_hd__fill_2
X_3906_ u_pe_array.g_pe_row\[3\].g_pe_col\[2\].u_pe.move_reg\[8\] _1118_ VGND VGND
+ VPWR VPWR _1143_ sky130_fd_sc_hd__or2_1
X_4886_ u_pe_array.g_pe_row\[2\].g_pe_col\[1\].u_pe.act_val\[4\] _1882_ _1873_ net85
+ VGND VGND VPWR VPWR _0306_ sky130_fd_sc_hd__a22o_1
X_7674_ clknet_leaf_63_clk net268 net74 VGND VGND VPWR VPWR u_pe_array.g_pe_row\[0\].g_pe_col\[3\].u_pe.move_reg\[6\]
+ sky130_fd_sc_hd__dfrtp_1
X_6625_ u_pe_array.g_pe_row\[0\].g_pe_col\[0\].u_pe.psum_out\[7\] net508 _3102_ VGND
+ VGND VPWR VPWR _3237_ sky130_fd_sc_hd__mux2_1
X_3837_ u_pe_array.g_pe_row\[3\].g_pe_col\[3\].u_pe.psum_out\[10\] _0988_ VGND VGND
+ VPWR VPWR _1087_ sky130_fd_sc_hd__or2_1
XFILLER_0_6_353 VGND VGND VPWR VPWR sky130_fd_sc_hd__decap_8
XFILLER_0_46_289 VGND VGND VPWR VPWR sky130_fd_sc_hd__fill_1
X_6556_ _3174_ _3179_ _3182_ VGND VGND VPWR VPWR _3183_ sky130_fd_sc_hd__o21bai_1
XFILLER_0_104_317 VGND VGND VPWR VPWR sky130_fd_sc_hd__decap_8
X_3768_ u_pe_array.g_pe_row\[3\].g_pe_col\[3\].u_pe.act_val\[4\] u_pe_array.g_pe_row\[3\].g_pe_col\[3\].u_pe.w_out\[0\]
+ VGND VGND VPWR VPWR _1024_ sky130_fd_sc_hd__nand2_1
XFILLER_0_14_153 VGND VGND VPWR VPWR sky130_fd_sc_hd__fill_2
X_5507_ u_pe_array.u_fifo2.buffer\[3\]\[4\] _2331_ _2332_ u_pe_array.u_fifo2.buffer\[2\]\[4\]
+ _2367_ VGND VGND VPWR VPWR _2368_ sky130_fd_sc_hd__a221o_1
X_6487_ u_pe_array.g_pe_row\[0\].g_pe_col\[1\].u_pe.act_val\[0\] _2268_ VGND VGND
+ VPWR VPWR _3120_ sky130_fd_sc_hd__nand2_1
XFILLER_0_14_197 VGND VGND VPWR VPWR sky130_fd_sc_hd__fill_2
X_3699_ net11 u_pe_array.act_from_left\[15\]\[4\] _0963_ VGND VGND VPWR VPWR _0968_
+ sky130_fd_sc_hd__mux2_1
XFILLER_0_30_657 VPWR VGND VPWR VGND sky130_ef_sc_hd__decap_12
XFILLER_0_2_581 VGND VGND VPWR VPWR sky130_fd_sc_hd__decap_6
X_5438_ _2276_ net851 _1158_ VGND VGND VPWR VPWR _2315_ sky130_fd_sc_hd__mux2_1
X_5369_ u_pe_array.g_pe_row\[1\].g_pe_col\[3\].u_pe.psum_out\[9\] u_pe_array.g_pe_row\[1\].g_pe_col\[3\].u_pe.psum_out\[10\]
+ _1426_ VGND VGND VPWR VPWR _2263_ sky130_fd_sc_hd__o21a_1
X_7108_ clknet_leaf_87_clk _0014_ VGND VGND VPWR VPWR u_pe_array.u_fifo2.buffer\[8\]\[5\]
+ sky130_fd_sc_hd__dfxtp_1
X_7039_ net613 _3347_ _3514_ VGND VGND VPWR VPWR _3515_ sky130_fd_sc_hd__mux2_1
XFILLER_0_97_624 VGND VGND VPWR VPWR sky130_fd_sc_hd__decap_6
XFILLER_0_69_326 VGND VGND VPWR VPWR sky130_fd_sc_hd__decap_3
XTAP_1013 VGND VPWR sky130_fd_sc_hd__tapvpwrvgnd_1
XTAP_1002 VGND VPWR sky130_fd_sc_hd__tapvpwrvgnd_1
XFILLER_0_96_167 VGND VGND VPWR VPWR sky130_fd_sc_hd__fill_1
XTAP_1046 VGND VPWR sky130_fd_sc_hd__tapvpwrvgnd_1
XTAP_1035 VGND VPWR sky130_fd_sc_hd__tapvpwrvgnd_1
XTAP_1024 VGND VPWR sky130_fd_sc_hd__tapvpwrvgnd_1
XTAP_1079 VGND VPWR sky130_fd_sc_hd__tapvpwrvgnd_1
XTAP_1068 VGND VPWR sky130_fd_sc_hd__tapvpwrvgnd_1
XTAP_1057 VGND VPWR sky130_fd_sc_hd__tapvpwrvgnd_1
XFILLER_0_107_111 VGND VGND VPWR VPWR sky130_fd_sc_hd__fill_1
XFILLER_0_65_554 VGND VGND VPWR VPWR sky130_fd_sc_hd__decap_6
XFILLER_0_108_645 VPWR VGND VPWR VGND sky130_ef_sc_hd__decap_12
XFILLER_0_107_177 VGND VGND VPWR VPWR sky130_fd_sc_hd__fill_1
XFILLER_0_52_248 VGND VGND VPWR VPWR sky130_fd_sc_hd__decap_4
XFILLER_0_0_529 VGND VGND VPWR VPWR sky130_fd_sc_hd__decap_3
XFILLER_0_21_668 VGND VGND VPWR VPWR sky130_fd_sc_hd__decap_4
XTAP_808 VGND VPWR sky130_fd_sc_hd__tapvpwrvgnd_1
XTAP_819 VGND VPWR sky130_fd_sc_hd__tapvpwrvgnd_1
XFILLER_0_88_657 VPWR VGND VPWR VGND sky130_ef_sc_hd__decap_12
XFILLER_0_28_212 VPWR VGND VPWR VGND sky130_ef_sc_hd__decap_12
XFILLER_0_113_55 VGND VGND VPWR VPWR sky130_fd_sc_hd__fill_1
XTAP_1591 VGND VPWR sky130_fd_sc_hd__tapvpwrvgnd_1
XTAP_1580 VGND VPWR sky130_fd_sc_hd__tapvpwrvgnd_1
XFILLER_0_56_565 VGND VGND VPWR VPWR sky130_fd_sc_hd__decap_3
X_4740_ _1762_ _1766_ VGND VGND VPWR VPWR _1767_ sky130_fd_sc_hd__xor2_1
Xclkbuf_leaf_107_clk clknet_3_0__leaf_clk VGND VGND VPWR VPWR clknet_leaf_107_clk
+ sky130_fd_sc_hd__clkbuf_16
X_4671_ _1727_ VGND VGND VPWR VPWR _0246_ sky130_fd_sc_hd__clkbuf_1
XFILLER_0_71_535 VGND VGND VPWR VPWR sky130_fd_sc_hd__decap_4
X_7390_ clknet_leaf_35_clk _0296_ net942 VGND VGND VPWR VPWR u_pe_array.act_from_right\[8\]\[7\]
+ sky130_fd_sc_hd__dfrtp_1
X_3622_ u_pe_array.u_fifo2.wr_ptr\[0\] u_pe_array.u_fifo2.wr_ptr\[1\] VGND VGND VPWR
+ VPWR _0916_ sky130_fd_sc_hd__or2_1
X_6410_ u_pe_array.g_pe_row\[0\].g_pe_col\[2\].u_pe.psum_out\[9\] _2130_ VGND VGND
+ VPWR VPWR _3076_ sky130_fd_sc_hd__or2_1
XFILLER_0_113_125 VPWR VGND VPWR VGND sky130_ef_sc_hd__decap_12
XFILLER_0_24_451 VGND VGND VPWR VPWR sky130_fd_sc_hd__fill_1
X_6341_ _3005_ _3006_ _3012_ VGND VGND VPWR VPWR _3013_ sky130_fd_sc_hd__nor3_1
XFILLER_0_113_169 VGND VGND VPWR VPWR sky130_fd_sc_hd__decap_4
X_3553_ u_fsm.state\[1\] u_fsm.state\[0\] VGND VGND VPWR VPWR _0861_ sky130_fd_sc_hd__and2_1
XFILLER_0_51_281 VGND VGND VPWR VPWR sky130_fd_sc_hd__decap_6
X_6272_ _2973_ VGND VGND VPWR VPWR _0601_ sky130_fd_sc_hd__clkbuf_1
XFILLER_0_12_657 VPWR VGND VPWR VGND sky130_ef_sc_hd__decap_12
XFILLER_0_11_156 VGND VGND VPWR VPWR sky130_fd_sc_hd__fill_1
X_5223_ u_pe_array.g_pe_row\[1\].g_pe_col\[3\].u_pe.psum_out\[10\] net514 _2133_ VGND
+ VGND VPWR VPWR _2145_ sky130_fd_sc_hd__mux2_1
X_5154_ _2058_ _2059_ _2092_ VGND VGND VPWR VPWR _2093_ sky130_fd_sc_hd__or3_1
X_4105_ net214 _1167_ _1169_ _1292_ VGND VGND VPWR VPWR _0115_ sky130_fd_sc_hd__a22o_1
X_5085_ _2029_ u_pe_array.g_pe_row\[2\].g_pe_col\[0\].u_pe.psum_out\[1\] _1286_ VGND
+ VGND VPWR VPWR _2030_ sky130_fd_sc_hd__o21a_1
XFILLER_0_2_41 VPWR VGND VPWR VGND sky130_ef_sc_hd__decap_12
X_4036_ _1235_ _1226_ _1224_ VGND VGND VPWR VPWR _1236_ sky130_fd_sc_hd__a21oi_1
XFILLER_0_78_134 VGND VGND VPWR VPWR sky130_fd_sc_hd__decap_6
XFILLER_0_2_85 VPWR VGND VPWR VGND sky130_ef_sc_hd__decap_12
XPHY_107 VGND VGND VPWR VPWR sky130_fd_sc_hd__decap_3
XPHY_129 VGND VGND VPWR VPWR sky130_fd_sc_hd__decap_3
XPHY_118 VGND VGND VPWR VPWR sky130_fd_sc_hd__decap_3
X_5987_ u_pe_array.g_pe_row\[1\].g_pe_col\[0\].u_pe.act_val\[0\] _2734_ _1865_ VGND
+ VGND VPWR VPWR _2742_ sky130_fd_sc_hd__a21bo_1
XFILLER_0_47_532 VGND VGND VPWR VPWR sky130_fd_sc_hd__fill_2
X_4938_ u_pe_array.g_pe_row\[2\].g_pe_col\[1\].u_pe.psum_out\[4\] _1921_ VGND VGND
+ VPWR VPWR _1922_ sky130_fd_sc_hd__xnor2_1
XFILLER_0_19_234 VPWR VGND VPWR VGND sky130_ef_sc_hd__decap_12
X_7726_ clknet_leaf_75_clk _0632_ net13 VGND VGND VPWR VPWR u_pe_array.g_pe_row\[0\].g_pe_col\[2\].u_pe.psum_out\[4\]
+ sky130_fd_sc_hd__dfrtp_1
XFILLER_0_47_554 VGND VGND VPWR VPWR sky130_fd_sc_hd__decap_6
XFILLER_0_47_565 VGND VGND VPWR VPWR sky130_fd_sc_hd__fill_1
X_4869_ u_pe_array.g_pe_row\[2\].g_pe_col\[1\].u_pe.psum_out\[7\] u_pe_array.g_pe_row\[2\].g_pe_col\[1\].u_pe.move_reg\[7\]
+ _1867_ VGND VGND VPWR VPWR _1876_ sky130_fd_sc_hd__mux2_1
X_7657_ clknet_leaf_59_clk _0563_ net74 VGND VGND VPWR VPWR u_pe_array.act_from_right\[2\]\[2\]
+ sky130_fd_sc_hd__dfrtp_1
XFILLER_0_62_502 VPWR VGND VPWR VGND sky130_ef_sc_hd__decap_12
XFILLER_0_34_215 VGND VGND VPWR VPWR sky130_fd_sc_hd__fill_1
XFILLER_0_105_615 VGND VGND VPWR VPWR sky130_fd_sc_hd__fill_1
XFILLER_0_7_673 VPWR VGND VPWR VGND sky130_ef_sc_hd__decap_12
X_6608_ _3228_ VGND VGND VPWR VPWR _0682_ sky130_fd_sc_hd__clkbuf_1
X_7588_ clknet_leaf_32_clk _0494_ net71 VGND VGND VPWR VPWR u_pe_array.g_pe_row\[1\].g_pe_col\[1\].u_pe.psum_out\[2\]
+ sky130_fd_sc_hd__dfrtp_1
X_6539_ _2795_ _3166_ _3167_ _1005_ net490 VGND VGND VPWR VPWR _0674_ sky130_fd_sc_hd__a32o_1
XFILLER_0_42_281 VGND VGND VPWR VPWR sky130_fd_sc_hd__decap_6
XFILLER_0_97_410 VGND VGND VPWR VPWR sky130_fd_sc_hd__decap_8
Xmax_cap65 _3258_ VGND VGND VPWR VPWR net65 sky130_fd_sc_hd__buf_1
XPHY_9 VGND VGND VPWR VPWR sky130_fd_sc_hd__decap_3
XFILLER_0_84_159 VPWR VGND VPWR VGND sky130_ef_sc_hd__decap_12
XFILLER_0_38_576 VGND VGND VPWR VPWR sky130_fd_sc_hd__fill_2
XFILLER_0_4_109 VPWR VGND VPWR VGND sky130_ef_sc_hd__decap_12
XFILLER_0_80_365 VGND VGND VPWR VPWR sky130_fd_sc_hd__fill_2
XFILLER_0_80_354 VGND VGND VPWR VPWR sky130_fd_sc_hd__decap_8
XFILLER_0_104_681 VPWR VGND VPWR VGND sky130_ef_sc_hd__decap_12
XFILLER_0_21_432 VGND VGND VPWR VPWR sky130_fd_sc_hd__decap_4
XFILLER_0_33_292 VGND VGND VPWR VPWR sky130_fd_sc_hd__fill_1
XTAP_605 VGND VPWR sky130_fd_sc_hd__tapvpwrvgnd_1
XTAP_616 VGND VPWR sky130_fd_sc_hd__tapvpwrvgnd_1
XTAP_627 VGND VPWR sky130_fd_sc_hd__tapvpwrvgnd_1
XTAP_638 VGND VPWR sky130_fd_sc_hd__tapvpwrvgnd_1
XTAP_649 VGND VPWR sky130_fd_sc_hd__tapvpwrvgnd_1
XFILLER_0_84_26 VGND VGND VPWR VPWR sky130_fd_sc_hd__fill_2
XFILLER_0_84_15 VGND VGND VPWR VPWR sky130_fd_sc_hd__decap_8
XFILLER_0_108_77 VGND VGND VPWR VPWR sky130_fd_sc_hd__decap_6
X_5910_ _2675_ u_pe_array.u_fifo1.rd_ptr\[3\] u_pe_array.u_fifo1.rd_ptr\[2\] VGND
+ VGND VPWR VPWR _2680_ sky130_fd_sc_hd__nor3b_4
X_6890_ _0922_ net680 _3423_ VGND VGND VPWR VPWR _3426_ sky130_fd_sc_hd__mux2_1
XFILLER_0_48_307 VGND VGND VPWR VPWR sky130_fd_sc_hd__fill_1
XFILLER_0_29_532 VGND VGND VPWR VPWR sky130_fd_sc_hd__decap_4
X_5841_ _2634_ _1112_ VGND VGND VPWR VPWR _2635_ sky130_fd_sc_hd__nand2_1
X_5772_ _2570_ _2575_ VGND VGND VPWR VPWR _2577_ sky130_fd_sc_hd__nand2_1
X_4723_ u_pe_array.g_pe_row\[2\].g_pe_col\[2\].u_pe.psum_out\[0\] u_pe_array.g_pe_row\[2\].g_pe_col\[2\].u_pe.act_val\[0\]
+ u_pe_array.g_pe_row\[2\].g_pe_col\[2\].u_pe.w_out\[0\] VGND VGND VPWR VPWR _1752_
+ sky130_fd_sc_hd__and3_1
X_7511_ clknet_leaf_94_clk _0417_ net951 VGND VGND VPWR VPWR u_pe_array.act_from_right\[5\]\[5\]
+ sky130_fd_sc_hd__dfrtp_1
X_7442_ clknet_leaf_28_clk net384 net71 VGND VGND VPWR VPWR u_pe_array.g_pe_row\[2\].g_pe_col\[0\].u_pe.act_val\[5\]
+ sky130_fd_sc_hd__dfrtp_2
XFILLER_0_16_237 VGND VGND VPWR VPWR sky130_fd_sc_hd__decap_8
XFILLER_0_71_354 VGND VGND VPWR VPWR sky130_fd_sc_hd__fill_2
XFILLER_0_4_643 VGND VGND VPWR VPWR sky130_fd_sc_hd__fill_1
X_4654_ _1709_ _1713_ VGND VGND VPWR VPWR _1714_ sky130_fd_sc_hd__nand2_1
Xhold812 u_pe_array.g_pe_row\[2\].g_pe_col\[1\].u_pe.psum_out\[4\] VGND VGND VPWR
+ VPWR net886 sky130_fd_sc_hd__dlygate4sd3_1
XFILLER_0_12_421 VGND VGND VPWR VPWR sky130_fd_sc_hd__fill_2
X_3605_ net507 net609 _0899_ _0900_ VGND VGND VPWR VPWR _0903_ sky130_fd_sc_hd__a31o_1
X_7373_ clknet_leaf_106_clk _0279_ net944 VGND VGND VPWR VPWR u_pe_array.g_pe_row\[2\].g_pe_col\[2\].u_pe.psum_out\[5\]
+ sky130_fd_sc_hd__dfrtp_1
X_4585_ _1649_ _1650_ VGND VGND VPWR VPWR _1651_ sky130_fd_sc_hd__nor2_1
Xhold801 u_pe_array.g_pe_row\[0\].g_pe_col\[2\].u_pe.psum_out\[5\] VGND VGND VPWR
+ VPWR net875 sky130_fd_sc_hd__dlygate4sd3_1
XFILLER_0_114_489 VGND VGND VPWR VPWR sky130_fd_sc_hd__decap_4
XFILLER_0_101_106 VGND VGND VPWR VPWR sky130_fd_sc_hd__decap_6
Xhold823 u_pe_array.g_pe_row\[3\].g_pe_col\[1\].u_pe.psum_out\[10\] VGND VGND VPWR
+ VPWR net897 sky130_fd_sc_hd__dlygate4sd3_1
Xhold834 u_pe_array.g_pe_row\[3\].g_pe_col\[3\].u_pe.act_val\[3\] VGND VGND VPWR VPWR
+ net908 sky130_fd_sc_hd__dlygate4sd3_1
XFILLER_0_12_443 VPWR VGND VPWR VGND sky130_ef_sc_hd__decap_12
X_6324_ u_pe_array.g_pe_row\[0\].g_pe_col\[2\].u_pe.act_val\[1\] _2130_ VGND VGND
+ VPWR VPWR _2997_ sky130_fd_sc_hd__or2b_1
Xhold845 u_pe_array.act_from_right\[13\]\[2\] VGND VGND VPWR VPWR net919 sky130_fd_sc_hd__dlygate4sd3_1
XFILLER_0_101_139 VGND VGND VPWR VPWR sky130_fd_sc_hd__decap_6
X_6255_ _2954_ _2959_ _1092_ VGND VGND VPWR VPWR _2961_ sky130_fd_sc_hd__o21ai_1
Xhold856 u_pe_array.g_pe_row\[3\].g_pe_col\[0\].u_pe.act_val\[4\] VGND VGND VPWR VPWR
+ net930 sky130_fd_sc_hd__dlygate4sd3_1
X_5206_ u_pe_array.g_pe_row\[1\].g_pe_col\[3\].u_pe.psum_out\[2\] u_pe_array.g_pe_row\[1\].g_pe_col\[3\].u_pe.act_val\[2\]
+ _2133_ VGND VGND VPWR VPWR _2136_ sky130_fd_sc_hd__mux2_1
X_6186_ _2896_ _2897_ VGND VGND VPWR VPWR _2898_ sky130_fd_sc_hd__nor2_1
X_5137_ _2073_ _2074_ _2076_ VGND VGND VPWR VPWR _2078_ sky130_fd_sc_hd__a21o_1
X_5068_ u_pe_array.act_from_right\[8\]\[11\] _2016_ _1883_ net248 VGND VGND VPWR VPWR
+ _0354_ sky130_fd_sc_hd__a22o_1
X_4019_ u_pe_array.g_pe_row\[3\].g_pe_col\[2\].u_pe.act_val\[4\] _0934_ VGND VGND
+ VPWR VPWR _1220_ sky130_fd_sc_hd__and2b_1
XFILLER_0_79_454 VGND VGND VPWR VPWR sky130_fd_sc_hd__decap_6
XFILLER_0_79_487 VPWR VGND VPWR VGND sky130_ef_sc_hd__decap_12
XFILLER_0_67_649 VGND VGND VPWR VPWR sky130_fd_sc_hd__fill_1
XFILLER_0_39_329 VGND VGND VPWR VPWR sky130_fd_sc_hd__decap_6
XFILLER_0_90_80 VGND VGND VPWR VPWR sky130_fd_sc_hd__decap_4
XFILLER_0_75_660 VGND VGND VPWR VPWR sky130_fd_sc_hd__fill_1
X_7709_ clknet_leaf_60_clk _0615_ net74 VGND VGND VPWR VPWR u_pe_array.g_pe_row\[0\].g_pe_col\[2\].u_pe.act_val\[0\]
+ sky130_fd_sc_hd__dfrtp_4
XFILLER_0_35_502 VGND VGND VPWR VPWR sky130_fd_sc_hd__fill_2
XFILLER_0_47_373 VGND VGND VPWR VPWR sky130_fd_sc_hd__fill_1
XFILLER_0_117_261 VPWR VGND VPWR VGND sky130_ef_sc_hd__decap_12
XFILLER_0_35_535 VPWR VGND VPWR VGND sky130_ef_sc_hd__decap_12
XFILLER_0_90_685 VPWR VGND VPWR VGND sky130_ef_sc_hd__decap_12
XFILLER_0_62_365 VGND VGND VPWR VPWR sky130_fd_sc_hd__decap_4
XFILLER_0_7_481 VGND VGND VPWR VPWR sky130_fd_sc_hd__decap_6
XFILLER_0_43_590 VGND VGND VPWR VPWR sky130_fd_sc_hd__decap_6
XFILLER_0_101_673 VPWR VGND VPWR VGND sky130_ef_sc_hd__decap_12
XFILLER_0_100_150 VPWR VGND VPWR VGND sky130_ef_sc_hd__decap_12
XFILLER_0_100_194 VGND VGND VPWR VPWR sky130_fd_sc_hd__fill_2
XFILLER_0_54_29 VGND VGND VPWR VPWR sky130_fd_sc_hd__fill_1
XFILLER_0_85_435 VGND VGND VPWR VPWR sky130_fd_sc_hd__fill_1
Xhold108 _0345_ VGND VGND VPWR VPWR net182 sky130_fd_sc_hd__dlygate4sd3_1
XFILLER_0_80_173 VGND VGND VPWR VPWR sky130_fd_sc_hd__fill_2
Xhold119 u_pe_array.act_from_down\[3\]\[9\] VGND VGND VPWR VPWR net193 sky130_fd_sc_hd__dlygate4sd3_1
X_4370_ u_pe_array.act_from_up\[12\]\[11\] _1310_ _1175_ net251 VGND VGND VPWR VPWR
+ _0190_ sky130_fd_sc_hd__a22o_1
XFILLER_0_111_459 VGND VGND VPWR VPWR sky130_fd_sc_hd__fill_1
XFILLER_0_95_47 VGND VGND VPWR VPWR sky130_fd_sc_hd__decap_8
XTAP_413 VGND VPWR sky130_fd_sc_hd__tapvpwrvgnd_1
XTAP_402 VGND VPWR sky130_fd_sc_hd__tapvpwrvgnd_1
XTAP_424 VGND VPWR sky130_fd_sc_hd__tapvpwrvgnd_1
XFILLER_0_95_69 VPWR VGND VPWR VGND sky130_ef_sc_hd__decap_12
XTAP_435 VGND VPWR sky130_fd_sc_hd__tapvpwrvgnd_1
XTAP_446 VGND VPWR sky130_fd_sc_hd__tapvpwrvgnd_1
XTAP_457 VGND VPWR sky130_fd_sc_hd__tapvpwrvgnd_1
X_6040_ _2776_ _2778_ _2790_ VGND VGND VPWR VPWR _2791_ sky130_fd_sc_hd__a21oi_1
XTAP_468 VGND VPWR sky130_fd_sc_hd__tapvpwrvgnd_1
XTAP_479 VGND VPWR sky130_fd_sc_hd__tapvpwrvgnd_1
XFILLER_0_28_85 VPWR VGND VPWR VGND sky130_ef_sc_hd__decap_12
X_6942_ _3454_ VGND VGND VPWR VPWR _0790_ sky130_fd_sc_hd__clkbuf_1
X_6873_ _3416_ VGND VGND VPWR VPWR _0759_ sky130_fd_sc_hd__clkbuf_1
X_5824_ _2607_ _2612_ _2618_ _2622_ _2617_ VGND VGND VPWR VPWR _2623_ sky130_fd_sc_hd__a32o_1
XFILLER_0_76_446 VGND VGND VPWR VPWR sky130_fd_sc_hd__decap_6
XFILLER_0_8_245 VGND VGND VPWR VPWR sky130_fd_sc_hd__decap_6
X_5755_ _2558_ _2560_ VGND VGND VPWR VPWR _2561_ sky130_fd_sc_hd__xor2_1
XFILLER_0_91_449 VGND VGND VPWR VPWR sky130_fd_sc_hd__decap_4
XFILLER_0_56_192 VGND VGND VPWR VPWR sky130_fd_sc_hd__decap_4
XFILLER_0_97_3 VGND VGND VPWR VPWR sky130_fd_sc_hd__decap_8
X_5686_ net761 _2499_ _2491_ _2507_ VGND VGND VPWR VPWR _0481_ sky130_fd_sc_hd__a22o_1
X_4706_ net449 _1732_ _1735_ _1748_ VGND VGND VPWR VPWR _0260_ sky130_fd_sc_hd__a22o_1
XFILLER_0_44_365 VGND VGND VPWR VPWR sky130_fd_sc_hd__decap_3
XFILLER_0_114_253 VPWR VGND VPWR VGND sky130_ef_sc_hd__decap_12
X_7425_ clknet_leaf_12_clk _0331_ net951 VGND VGND VPWR VPWR u_pe_array.act_from_up\[12\]\[1\]
+ sky130_fd_sc_hd__dfrtp_1
X_4637_ _1683_ _1697_ _1698_ VGND VGND VPWR VPWR _1699_ sky130_fd_sc_hd__a21o_1
XFILLER_0_44_387 VGND VGND VPWR VPWR sky130_fd_sc_hd__decap_4
XFILLER_0_4_462 VPWR VGND VPWR VGND sky130_ef_sc_hd__decap_12
Xhold620 _0892_ VGND VGND VPWR VPWR net694 sky130_fd_sc_hd__dlygate4sd3_1
Xhold631 u_pe_array.g_pe_row\[2\].g_pe_col\[0\].u_pe.psum_out\[1\] VGND VGND VPWR
+ VPWR net705 sky130_fd_sc_hd__dlygate4sd3_1
Xhold653 u_pe_array.g_pe_row\[1\].g_pe_col\[2\].u_pe.psum_out\[12\] VGND VGND VPWR
+ VPWR net727 sky130_fd_sc_hd__dlygate4sd3_1
XFILLER_0_12_240 VGND VGND VPWR VPWR sky130_fd_sc_hd__fill_1
Xhold642 u_pe_array.u_fifo1.buffer\[6\]\[4\] VGND VGND VPWR VPWR net716 sky130_fd_sc_hd__dlygate4sd3_1
X_7356_ clknet_leaf_108_clk net178 net944 VGND VGND VPWR VPWR u_pe_array.g_pe_row\[2\].g_pe_col\[2\].u_pe.act_val\[1\]
+ sky130_fd_sc_hd__dfrtp_1
X_4568_ u_pe_array.g_pe_row\[2\].g_pe_col\[3\].u_pe.act_val\[2\] VGND VGND VPWR VPWR
+ _1635_ sky130_fd_sc_hd__inv_2
XFILLER_0_40_571 VPWR VGND VPWR VGND sky130_ef_sc_hd__decap_12
Xhold675 _0130_ VGND VGND VPWR VPWR net749 sky130_fd_sc_hd__dlygate4sd3_1
X_7287_ clknet_leaf_17_clk _0193_ net943 VGND VGND VPWR VPWR u_pe_array.g_pe_row\[3\].g_pe_col\[0\].u_pe.psum_out\[1\]
+ sky130_fd_sc_hd__dfrtp_1
X_6307_ u_pe_array.act_from_right\[2\]\[7\] _2730_ _2511_ net291 VGND VGND VPWR VPWR
+ _0622_ sky130_fd_sc_hd__a22o_1
XFILLER_0_12_295 VGND VGND VPWR VPWR sky130_fd_sc_hd__decap_6
Xhold686 u_pe_array.u_fifo2.buffer\[6\]\[0\] VGND VGND VPWR VPWR net760 sky130_fd_sc_hd__dlygate4sd3_1
X_4499_ _1596_ VGND VGND VPWR VPWR _0205_ sky130_fd_sc_hd__clkbuf_1
Xhold697 u_pe_array.u_fifo1.buffer\[8\]\[0\] VGND VGND VPWR VPWR net771 sky130_fd_sc_hd__dlygate4sd3_1
Xhold664 u_pe_array.u_fifo1.buffer\[8\]\[5\] VGND VGND VPWR VPWR net738 sky130_fd_sc_hd__dlygate4sd3_1
XFILLER_0_110_492 VPWR VGND VPWR VGND sky130_ef_sc_hd__decap_12
X_6238_ _1003_ _2945_ VGND VGND VPWR VPWR _2946_ sky130_fd_sc_hd__nor2_1
XFILLER_0_85_80 VPWR VGND VPWR VGND sky130_ef_sc_hd__decap_12
X_6169_ u_pe_array.g_pe_row\[0\].g_pe_col\[3\].u_pe.act_val\[3\] u_pe_array.g_pe_row\[0\].g_pe_col\[3\].u_pe.w_out\[0\]
+ _1999_ _2881_ VGND VGND VPWR VPWR _2882_ sky130_fd_sc_hd__a22o_1
XTAP_980 VGND VPWR sky130_fd_sc_hd__tapvpwrvgnd_1
XFILLER_0_99_505 VGND VGND VPWR VPWR sky130_fd_sc_hd__fill_1
XTAP_991 VGND VPWR sky130_fd_sc_hd__tapvpwrvgnd_1
Xclkbuf_leaf_96_clk clknet_3_1__leaf_clk VGND VGND VPWR VPWR clknet_leaf_96_clk sky130_fd_sc_hd__clkbuf_16
XFILLER_0_67_435 VGND VGND VPWR VPWR sky130_fd_sc_hd__decap_6
Xclkbuf_leaf_20_clk clknet_3_2__leaf_clk VGND VGND VPWR VPWR clknet_leaf_20_clk sky130_fd_sc_hd__clkbuf_16
XFILLER_0_23_505 VGND VGND VPWR VPWR sky130_fd_sc_hd__decap_4
Xload_slew9 net949 VGND VGND VPWR VPWR net948 sky130_fd_sc_hd__buf_12
XFILLER_0_63_696 VGND VGND VPWR VPWR sky130_fd_sc_hd__decap_8
XFILLER_0_62_195 VGND VGND VPWR VPWR sky130_fd_sc_hd__fill_1
Xclkbuf_leaf_87_clk clknet_3_4__leaf_clk VGND VGND VPWR VPWR clknet_leaf_87_clk sky130_fd_sc_hd__clkbuf_16
XFILLER_0_98_571 VGND VGND VPWR VPWR sky130_fd_sc_hd__fill_1
XFILLER_0_85_221 VGND VGND VPWR VPWR sky130_fd_sc_hd__decap_3
XFILLER_0_58_457 VGND VGND VPWR VPWR sky130_fd_sc_hd__decap_6
X_3870_ u_pe_array.g_pe_row\[0\].g_pe_col\[0\].u_pe.psum_shift_en_d _0963_ VGND VGND
+ VPWR VPWR _1115_ sky130_fd_sc_hd__nand2b_2
XFILLER_0_109_581 VPWR VGND VPWR VGND sky130_ef_sc_hd__decap_12
X_5540_ _2387_ _2389_ VGND VGND VPWR VPWR _2390_ sky130_fd_sc_hd__xnor2_1
Xclkbuf_leaf_11_clk clknet_3_1__leaf_clk VGND VGND VPWR VPWR clknet_leaf_11_clk sky130_fd_sc_hd__clkbuf_16
X_5471_ u_pe_array.u_fifo2.buffer\[5\]\[0\] _2333_ _2334_ u_pe_array.u_fifo2.buffer\[6\]\[0\]
+ _2335_ VGND VGND VPWR VPWR _2336_ sky130_fd_sc_hd__a221o_1
XFILLER_0_26_376 VGND VGND VPWR VPWR sky130_fd_sc_hd__decap_8
X_7210_ clknet_leaf_22_clk _0116_ net942 VGND VGND VPWR VPWR u_pe_array.act_from_down\[9\]\[4\]
+ sky130_fd_sc_hd__dfrtp_1
X_4422_ u_pe_array.g_pe_row\[3\].g_pe_col\[0\].u_pe.act_val\[4\] _1287_ VGND VGND
+ VPWR VPWR _1528_ sky130_fd_sc_hd__and2b_1
XFILLER_0_69_7 VGND VGND VPWR VPWR sky130_fd_sc_hd__fill_1
X_7141_ clknet_leaf_20_clk _0047_ net943 VGND VGND VPWR VPWR u_pe_array.g_pe_row\[3\].g_pe_col\[3\].u_pe.psum_out\[4\]
+ sky130_fd_sc_hd__dfrtp_1
X_4353_ net15 u_pe_array.act_from_up\[12\]\[0\] _0857_ VGND VGND VPWR VPWR _1477_
+ sky130_fd_sc_hd__mux2_1
X_4284_ u_pe_array.g_pe_row\[3\].g_pe_col\[0\].u_pe.psum_out\[1\] _1108_ _1110_ _1432_
+ VGND VGND VPWR VPWR _1433_ sky130_fd_sc_hd__o211a_2
X_7072_ net625 _3358_ _3529_ VGND VGND VPWR VPWR _3533_ sky130_fd_sc_hd__mux2_1
XTAP_265 VGND VPWR sky130_fd_sc_hd__tapvpwrvgnd_1
XTAP_243 VGND VPWR sky130_fd_sc_hd__tapvpwrvgnd_1
XTAP_254 VGND VPWR sky130_fd_sc_hd__tapvpwrvgnd_1
X_6023_ _2773_ _2774_ VGND VGND VPWR VPWR _2775_ sky130_fd_sc_hd__xnor2_2
XTAP_298 VGND VPWR sky130_fd_sc_hd__tapvpwrvgnd_1
XTAP_276 VGND VPWR sky130_fd_sc_hd__tapvpwrvgnd_1
XTAP_287 VGND VPWR sky130_fd_sc_hd__tapvpwrvgnd_1
Xclkbuf_leaf_78_clk clknet_3_5__leaf_clk VGND VGND VPWR VPWR clknet_leaf_78_clk sky130_fd_sc_hd__clkbuf_16
XTAP_1409 VGND VPWR sky130_fd_sc_hd__tapvpwrvgnd_1
X_6925_ _3445_ VGND VGND VPWR VPWR _0782_ sky130_fd_sc_hd__clkbuf_1
XFILLER_0_49_413 VGND VGND VPWR VPWR sky130_fd_sc_hd__fill_2
XFILLER_0_76_276 VPWR VGND VPWR VGND sky130_ef_sc_hd__decap_12
XFILLER_0_64_405 VGND VGND VPWR VPWR sky130_fd_sc_hd__fill_1
X_6856_ _3406_ VGND VGND VPWR VPWR _0752_ sky130_fd_sc_hd__clkbuf_1
X_5807_ u_pe_array.g_pe_row\[1\].g_pe_col\[1\].u_pe.psum_out\[10\] _1728_ VGND VGND
+ VPWR VPWR _2608_ sky130_fd_sc_hd__nand2_1
Xfanout69 net71 VGND VGND VPWR VPWR net69 sky130_fd_sc_hd__buf_6
X_3999_ _1187_ _1188_ VGND VGND VPWR VPWR _1202_ sky130_fd_sc_hd__nand2_1
X_6787_ u_pe_array.act_from_up\[12\]\[5\] _0869_ _0854_ VGND VGND VPWR VPWR _3362_
+ sky130_fd_sc_hd__and3_4
X_5738_ u_pe_array.g_pe_row\[1\].g_pe_col\[1\].u_pe.act_val\[3\] _1728_ VGND VGND
+ VPWR VPWR _2545_ sky130_fd_sc_hd__and2b_1
XFILLER_0_91_268 VGND VGND VPWR VPWR sky130_fd_sc_hd__fill_1
XFILLER_0_44_184 VGND VGND VPWR VPWR sky130_fd_sc_hd__decap_6
X_5669_ net106 _2143_ _2491_ _2498_ VGND VGND VPWR VPWR _0473_ sky130_fd_sc_hd__a22o_1
X_7408_ clknet_leaf_14_clk net274 net951 VGND VGND VPWR VPWR u_pe_array.g_pe_row\[2\].g_pe_col\[1\].u_pe.move_reg\[12\]
+ sky130_fd_sc_hd__dfrtp_1
XFILLER_0_60_699 VGND VGND VPWR VPWR sky130_fd_sc_hd__fill_1
Xhold450 u_pe_array.act_from_right\[2\]\[7\] VGND VGND VPWR VPWR net524 sky130_fd_sc_hd__dlygate4sd3_1
Xhold461 u_pe_array.u_fifo1.buffer\[0\]\[5\] VGND VGND VPWR VPWR net535 sky130_fd_sc_hd__dlygate4sd3_1
XFILLER_0_40_390 VGND VGND VPWR VPWR sky130_fd_sc_hd__decap_4
Xhold472 u_pe_array.g_pe_row\[0\].g_pe_col\[2\].u_pe.psum_out\[3\] VGND VGND VPWR
+ VPWR net546 sky130_fd_sc_hd__dlygate4sd3_1
X_7339_ clknet_leaf_5_clk _0245_ net945 VGND VGND VPWR VPWR u_pe_array.g_pe_row\[2\].g_pe_col\[3\].u_pe.psum_out\[12\]
+ sky130_fd_sc_hd__dfrtp_1
XFILLER_0_102_289 VGND VGND VPWR VPWR sky130_fd_sc_hd__fill_2
Xhold494 u_pe_array.g_pe_row\[2\].g_pe_col\[2\].u_pe.psum_out\[5\] VGND VGND VPWR
+ VPWR net568 sky130_fd_sc_hd__dlygate4sd3_1
Xhold483 u_pe_array.g_pe_row\[1\].g_pe_col\[2\].u_pe.psum_out\[3\] VGND VGND VPWR
+ VPWR net557 sky130_fd_sc_hd__dlygate4sd3_1
Xclkbuf_leaf_69_clk clknet_3_4__leaf_clk VGND VGND VPWR VPWR clknet_leaf_69_clk sky130_fd_sc_hd__clkbuf_16
XFILLER_0_99_368 VGND VGND VPWR VPWR sky130_fd_sc_hd__decap_3
XFILLER_0_55_449 VGND VGND VPWR VPWR sky130_fd_sc_hd__decap_6
XFILLER_0_55_438 VGND VGND VPWR VPWR sky130_fd_sc_hd__decap_8
XFILLER_0_36_652 VGND VGND VPWR VPWR sky130_fd_sc_hd__decap_4
XFILLER_0_23_313 VGND VGND VPWR VPWR sky130_fd_sc_hd__decap_4
XFILLER_0_63_493 VGND VGND VPWR VPWR sky130_fd_sc_hd__decap_4
XFILLER_0_23_335 VGND VGND VPWR VPWR sky130_fd_sc_hd__fill_1
XFILLER_0_11_508 VGND VGND VPWR VPWR sky130_fd_sc_hd__decap_4
XFILLER_0_92_15 VPWR VGND VPWR VGND sky130_ef_sc_hd__decap_12
Xclkbuf_leaf_0_clk clknet_3_0__leaf_clk VGND VGND VPWR VPWR clknet_leaf_0_clk sky130_fd_sc_hd__clkbuf_16
XFILLER_0_116_77 VGND VGND VPWR VPWR sky130_fd_sc_hd__decap_6
X_4971_ _1941_ _1943_ VGND VGND VPWR VPWR _1952_ sky130_fd_sc_hd__nor2_1
XFILLER_0_58_210 VPWR VGND VPWR VGND sky130_ef_sc_hd__decap_12
XFILLER_0_25_97 VGND VGND VPWR VPWR sky130_fd_sc_hd__decap_3
X_6710_ u_pe_array.g_pe_row\[0\].g_pe_col\[0\].u_pe.act_val\[5\] u_pe_array.g_pe_row\[0\].g_pe_col\[0\].u_pe.psum_out\[6\]
+ _2488_ VGND VGND VPWR VPWR _3297_ sky130_fd_sc_hd__and3b_1
X_7690_ clknet_leaf_56_clk _0596_ net74 VGND VGND VPWR VPWR u_pe_array.g_pe_row\[0\].g_pe_col\[3\].u_pe.psum_out\[9\]
+ sky130_fd_sc_hd__dfrtp_1
X_3922_ u_pe_array.g_pe_row\[3\].g_pe_col\[2\].u_pe.move_reg\[12\] _1118_ VGND VGND
+ VPWR VPWR _1155_ sky130_fd_sc_hd__or2_1
X_6641_ u_pe_array.g_pe_row\[0\].g_pe_col\[0\].u_pe.act_val\[4\] _2343_ _2320_ net276
+ VGND VGND VPWR VPWR _0701_ sky130_fd_sc_hd__a22o_1
X_3853_ _1085_ _1090_ _1097_ _1100_ _1096_ VGND VGND VPWR VPWR _1101_ sky130_fd_sc_hd__a32o_1
XFILLER_0_41_41 VGND VGND VPWR VPWR sky130_fd_sc_hd__decap_4
X_6572_ u_pe_array.g_pe_row\[0\].g_pe_col\[1\].u_pe.psum_out\[8\] _3184_ VGND VGND
+ VPWR VPWR _3198_ sky130_fd_sc_hd__nor2_1
X_3784_ u_pe_array.g_pe_row\[3\].g_pe_col\[3\].u_pe.psum_out\[4\] _1025_ _1038_ VGND
+ VGND VPWR VPWR _1039_ sky130_fd_sc_hd__a21oi_2
XFILLER_0_27_696 VGND VGND VPWR VPWR sky130_fd_sc_hd__decap_8
X_5523_ u_pe_array.act_from_up\[6\]\[9\] _2016_ _1883_ net200 VGND VGND VPWR VPWR
+ _0447_ sky130_fd_sc_hd__a22o_1
XFILLER_0_41_121 VGND VGND VPWR VPWR sky130_fd_sc_hd__decap_4
X_5454_ net149 _1159_ _2312_ _1476_ VGND VGND VPWR VPWR _0437_ sky130_fd_sc_hd__a22o_1
XFILLER_0_14_379 VGND VGND VPWR VPWR sky130_fd_sc_hd__fill_2
XFILLER_0_42_699 VGND VGND VPWR VPWR sky130_fd_sc_hd__fill_1
XFILLER_0_112_576 VPWR VGND VPWR VGND sky130_ef_sc_hd__decap_12
XFILLER_0_10_530 VGND VGND VPWR VPWR sky130_fd_sc_hd__fill_2
X_5385_ u_pe_array.g_pe_row\[1\].g_pe_col\[2\].u_pe.act_val\[1\] _1118_ VGND VGND
+ VPWR VPWR _2275_ sky130_fd_sc_hd__or2_1
X_4405_ _1509_ _1511_ VGND VGND VPWR VPWR _1513_ sky130_fd_sc_hd__nand2_1
X_4336_ _1471_ VGND VGND VPWR VPWR _0167_ sky130_fd_sc_hd__clkbuf_1
X_7124_ clknet_leaf_4_clk _0030_ net69 VGND VGND VPWR VPWR u_pe_array.g_pe_row\[3\].g_pe_col\[3\].u_pe.act_val\[0\]
+ sky130_fd_sc_hd__dfrtp_2
XFILLER_0_10_596 VGND VGND VPWR VPWR sky130_fd_sc_hd__decap_8
X_4267_ _1406_ _1410_ _1417_ _1419_ _1416_ VGND VGND VPWR VPWR _1420_ sky130_fd_sc_hd__a32o_1
XFILLER_0_66_71 VGND VGND VPWR VPWR sky130_fd_sc_hd__fill_1
X_7055_ _3523_ VGND VGND VPWR VPWR _0834_ sky130_fd_sc_hd__clkbuf_1
X_4198_ u_pe_array.g_pe_row\[3\].g_pe_col\[1\].u_pe.act_val\[5\] u_pe_array.g_pe_row\[3\].g_pe_col\[1\].u_pe.w_out\[0\]
+ VGND VGND VPWR VPWR _1358_ sky130_fd_sc_hd__nand2_1
X_6006_ _2758_ _2759_ VGND VGND VPWR VPWR _2760_ sky130_fd_sc_hd__or2b_1
XFILLER_0_89_390 VGND VGND VPWR VPWR sky130_fd_sc_hd__fill_2
XTAP_1239 VGND VPWR sky130_fd_sc_hd__tapvpwrvgnd_1
XTAP_1228 VGND VPWR sky130_fd_sc_hd__tapvpwrvgnd_1
XTAP_1217 VGND VPWR sky130_fd_sc_hd__tapvpwrvgnd_1
XTAP_1206 VGND VPWR sky130_fd_sc_hd__tapvpwrvgnd_1
X_7888_ clknet_leaf_80_clk _0793_ net13 VGND VGND VPWR VPWR u_pe_array.u_fifo1.wr_ptr\[2\]
+ sky130_fd_sc_hd__dfrtp_1
X_6908_ _0926_ net660 _3431_ VGND VGND VPWR VPWR _3436_ sky130_fd_sc_hd__mux2_1
XFILLER_0_92_533 VGND VGND VPWR VPWR sky130_fd_sc_hd__fill_1
XFILLER_0_92_522 VGND VGND VPWR VPWR sky130_fd_sc_hd__fill_1
XFILLER_0_64_202 VGND VGND VPWR VPWR sky130_fd_sc_hd__decap_8
XFILLER_0_18_630 VPWR VGND VPWR VGND sky130_ef_sc_hd__decap_12
X_6839_ net549 _0926_ _3392_ VGND VGND VPWR VPWR _3397_ sky130_fd_sc_hd__mux2_1
XFILLER_0_107_337 VGND VGND VPWR VPWR sky130_fd_sc_hd__decap_8
XFILLER_0_92_555 VGND VGND VPWR VPWR sky130_fd_sc_hd__fill_2
XFILLER_0_17_184 VGND VGND VPWR VPWR sky130_fd_sc_hd__fill_1
XFILLER_0_32_176 VGND VGND VPWR VPWR sky130_fd_sc_hd__decap_6
Xhold280 u_pe_array.act_from_down\[9\]\[6\] VGND VGND VPWR VPWR net354 sky130_fd_sc_hd__dlygate4sd3_1
Xhold291 u_pe_array.g_pe_row\[2\].g_pe_col\[3\].u_pe.move_reg\[8\] VGND VGND VPWR
+ VPWR net365 sky130_fd_sc_hd__dlygate4sd3_1
XFILLER_0_1_3 VPWR VGND VPWR VGND sky130_ef_sc_hd__decap_12
XFILLER_0_68_541 VGND VGND VPWR VPWR sky130_fd_sc_hd__fill_2
XFILLER_0_62_29 VGND VGND VPWR VPWR sky130_fd_sc_hd__fill_1
XTAP_1740 VGND VPWR sky130_fd_sc_hd__tapvpwrvgnd_1
XFILLER_0_68_563 VGND VGND VPWR VPWR sky130_fd_sc_hd__decap_3
XFILLER_0_55_279 VGND VGND VPWR VPWR sky130_fd_sc_hd__fill_1
XFILLER_0_24_622 VGND VGND VPWR VPWR sky130_fd_sc_hd__fill_1
XFILLER_0_63_290 VGND VGND VPWR VPWR sky130_fd_sc_hd__decap_6
XFILLER_0_11_55 VGND VGND VPWR VPWR sky130_fd_sc_hd__fill_1
XFILLER_0_3_505 VPWR VGND VPWR VGND sky130_ef_sc_hd__decap_12
XFILLER_0_23_121 VGND VGND VPWR VPWR sky130_fd_sc_hd__fill_2
XFILLER_0_11_77 VGND VGND VPWR VPWR sky130_fd_sc_hd__fill_1
X_5170_ _2100_ _2102_ _2107_ VGND VGND VPWR VPWR _2108_ sky130_fd_sc_hd__o21ai_1
X_4121_ net434 _1167_ _1169_ _1300_ VGND VGND VPWR VPWR _0123_ sky130_fd_sc_hd__a22o_1
X_4052_ _1232_ _1242_ u_pe_array.g_pe_row\[3\].g_pe_col\[2\].u_pe.psum_out\[7\] _1228_
+ VGND VGND VPWR VPWR _1250_ sky130_fd_sc_hd__o2bb2a_1
Xinput4 h_in0[3] VGND VGND VPWR VPWR net4 sky130_fd_sc_hd__clkbuf_2
XFILLER_0_78_327 VGND VGND VPWR VPWR sky130_fd_sc_hd__decap_4
X_7811_ clknet_leaf_52_clk _0716_ net74 VGND VGND VPWR VPWR u_pe_array.g_pe_row\[0\].g_pe_col\[0\].u_pe.psum_out\[6\]
+ sky130_fd_sc_hd__dfrtp_1
X_7742_ clknet_leaf_53_clk _0648_ net74 VGND VGND VPWR VPWR u_pe_array.act_from_right\[0\]\[5\]
+ sky130_fd_sc_hd__dfrtp_1
X_4954_ _1924_ _1927_ _1935_ VGND VGND VPWR VPWR _1937_ sky130_fd_sc_hd__o21ai_1
XFILLER_0_86_371 VGND VGND VPWR VPWR sky130_fd_sc_hd__fill_1
XFILLER_0_19_449 VPWR VGND VPWR VGND sky130_ef_sc_hd__decap_12
X_3905_ _1142_ VGND VGND VPWR VPWR _0065_ sky130_fd_sc_hd__clkbuf_1
X_4885_ u_pe_array.g_pe_row\[2\].g_pe_col\[1\].u_pe.act_val\[3\] _1882_ _1873_ net214
+ VGND VGND VPWR VPWR _0305_ sky130_fd_sc_hd__a22o_1
X_7673_ clknet_leaf_57_clk net527 net74 VGND VGND VPWR VPWR u_pe_array.g_pe_row\[0\].g_pe_col\[3\].u_pe.act_val\[5\]
+ sky130_fd_sc_hd__dfrtp_2
XFILLER_0_34_408 VGND VGND VPWR VPWR sky130_fd_sc_hd__fill_1
XFILLER_0_46_268 VGND VGND VPWR VPWR sky130_fd_sc_hd__decap_8
X_3836_ u_pe_array.g_pe_row\[3\].g_pe_col\[3\].u_pe.psum_out\[10\] _0988_ VGND VGND
+ VPWR VPWR _1086_ sky130_fd_sc_hd__nand2_1
X_6624_ net409 _1731_ _1734_ _3236_ VGND VGND VPWR VPWR _0690_ sky130_fd_sc_hd__a22o_1
XFILLER_0_61_205 VGND VGND VPWR VPWR sky130_fd_sc_hd__decap_4
XFILLER_0_6_321 VGND VGND VPWR VPWR sky130_fd_sc_hd__decap_4
X_6555_ _3171_ _3173_ VGND VGND VPWR VPWR _3182_ sky130_fd_sc_hd__nor2_1
X_3767_ u_pe_array.g_pe_row\[3\].g_pe_col\[3\].u_pe.act_val\[3\] _0988_ VGND VGND
+ VPWR VPWR _1023_ sky130_fd_sc_hd__and2b_1
XFILLER_0_42_441 VGND VGND VPWR VPWR sky130_fd_sc_hd__fill_1
X_5506_ u_pe_array.u_fifo2.buffer\[5\]\[4\] _2333_ _2334_ u_pe_array.u_fifo2.buffer\[6\]\[4\]
+ _2335_ VGND VGND VPWR VPWR _2367_ sky130_fd_sc_hd__a221o_1
X_6486_ u_pe_array.g_pe_row\[0\].g_pe_col\[1\].u_pe.act_val\[1\] u_pe_array.g_pe_row\[0\].g_pe_col\[1\].u_pe.w_out\[0\]
+ VGND VGND VPWR VPWR _3119_ sky130_fd_sc_hd__nand2_1
X_3698_ net908 _0949_ _0944_ _0967_ VGND VGND VPWR VPWR _0033_ sky130_fd_sc_hd__a22o_1
X_5437_ _2314_ VGND VGND VPWR VPWR _0425_ sky130_fd_sc_hd__clkbuf_1
XFILLER_0_30_669 VPWR VGND VPWR VGND sky130_ef_sc_hd__decap_12
XFILLER_0_100_568 VGND VGND VPWR VPWR sky130_fd_sc_hd__fill_1
X_5368_ net744 _1904_ _2262_ _1726_ VGND VGND VPWR VPWR _0408_ sky130_fd_sc_hd__a22o_1
X_4319_ net847 _1459_ _1116_ VGND VGND VPWR VPWR _1460_ sky130_fd_sc_hd__mux2_1
X_5299_ _2199_ _2200_ VGND VGND VPWR VPWR _2201_ sky130_fd_sc_hd__xnor2_2
XFILLER_0_77_92 VGND VGND VPWR VPWR sky130_fd_sc_hd__fill_1
X_7107_ clknet_leaf_88_clk _0013_ VGND VGND VPWR VPWR u_pe_array.u_fifo2.buffer\[8\]\[4\]
+ sky130_fd_sc_hd__dfxtp_1
X_7038_ _3350_ _3513_ VGND VGND VPWR VPWR _3514_ sky130_fd_sc_hd__and2_2
XFILLER_0_97_636 VGND VGND VPWR VPWR sky130_fd_sc_hd__fill_1
XTAP_1003 VGND VPWR sky130_fd_sc_hd__tapvpwrvgnd_1
XTAP_1047 VGND VPWR sky130_fd_sc_hd__tapvpwrvgnd_1
XTAP_1036 VGND VPWR sky130_fd_sc_hd__tapvpwrvgnd_1
XTAP_1025 VGND VPWR sky130_fd_sc_hd__tapvpwrvgnd_1
XTAP_1014 VGND VPWR sky130_fd_sc_hd__tapvpwrvgnd_1
XFILLER_0_77_393 VGND VGND VPWR VPWR sky130_fd_sc_hd__decap_3
XTAP_1069 VGND VPWR sky130_fd_sc_hd__tapvpwrvgnd_1
XTAP_1058 VGND VPWR sky130_fd_sc_hd__tapvpwrvgnd_1
XFILLER_0_108_657 VPWR VGND VPWR VGND sky130_ef_sc_hd__decap_12
XFILLER_0_107_145 VGND VGND VPWR VPWR sky130_fd_sc_hd__decap_3
XFILLER_0_21_625 VGND VGND VPWR VPWR sky130_fd_sc_hd__decap_4
XTAP_809 VGND VPWR sky130_fd_sc_hd__tapvpwrvgnd_1
XFILLER_0_88_669 VPWR VGND VPWR VGND sky130_ef_sc_hd__decap_12
XFILLER_0_87_113 VGND VGND VPWR VPWR sky130_fd_sc_hd__decap_4
XFILLER_0_96_691 VGND VGND VPWR VPWR sky130_fd_sc_hd__decap_8
XFILLER_0_28_224 VGND VGND VPWR VPWR sky130_fd_sc_hd__decap_6
XTAP_1592 VGND VPWR sky130_fd_sc_hd__tapvpwrvgnd_1
XTAP_1570 VGND VPWR sky130_fd_sc_hd__tapvpwrvgnd_1
XTAP_1581 VGND VPWR sky130_fd_sc_hd__tapvpwrvgnd_1
X_4670_ u_pe_array.g_pe_row\[1\].g_pe_col\[1\].u_pe.w_out\[0\] u_pe_array.g_pe_row\[2\].g_pe_col\[1\].u_pe.w_out\[0\]
+ _0931_ VGND VGND VPWR VPWR _1727_ sky130_fd_sc_hd__mux2_1
XFILLER_0_71_503 VGND VGND VPWR VPWR sky130_fd_sc_hd__fill_1
XFILLER_0_56_577 VGND VGND VPWR VPWR sky130_fd_sc_hd__fill_1
X_3621_ _0914_ VGND VGND VPWR VPWR _0915_ sky130_fd_sc_hd__inv_2
XFILLER_0_113_137 VPWR VGND VPWR VGND sky130_ef_sc_hd__decap_12
X_3552_ _0853_ VGND VGND VPWR VPWR _0860_ sky130_fd_sc_hd__clkinv_4
X_6340_ _3007_ _3011_ VGND VGND VPWR VPWR _3012_ sky130_fd_sc_hd__xnor2_1
XFILLER_0_12_614 VGND VGND VPWR VPWR sky130_fd_sc_hd__fill_1
XFILLER_0_11_113 VGND VGND VPWR VPWR sky130_fd_sc_hd__fill_1
XFILLER_0_24_474 VGND VGND VPWR VPWR sky130_fd_sc_hd__fill_2
X_6271_ net30 _2268_ net63 VGND VGND VPWR VPWR _2973_ sky130_fd_sc_hd__mux2_1
XFILLER_0_12_669 VPWR VGND VPWR VGND sky130_ef_sc_hd__decap_12
X_5222_ net193 _2143_ _2132_ _2144_ VGND VGND VPWR VPWR _0380_ sky130_fd_sc_hd__a22o_1
X_5153_ _2067_ _2068_ _2079_ _2089_ VGND VGND VPWR VPWR _2092_ sky130_fd_sc_hd__or4_1
X_4104_ net461 u_pe_array.g_pe_row\[3\].g_pe_col\[1\].u_pe.act_val\[3\] _0947_ VGND
+ VGND VPWR VPWR _1292_ sky130_fd_sc_hd__mux2_1
XFILLER_0_47_73 VGND VGND VPWR VPWR sky130_fd_sc_hd__fill_1
X_5084_ u_pe_array.g_pe_row\[2\].g_pe_col\[0\].u_pe.act_val\[0\] VGND VGND VPWR VPWR
+ _2029_ sky130_fd_sc_hd__inv_2
X_4035_ _1223_ VGND VGND VPWR VPWR _1235_ sky130_fd_sc_hd__inv_2
XFILLER_0_78_113 VGND VGND VPWR VPWR sky130_fd_sc_hd__fill_1
XFILLER_0_2_53 VPWR VGND VPWR VGND sky130_ef_sc_hd__decap_12
XFILLER_0_2_97 VPWR VGND VPWR VGND sky130_ef_sc_hd__decap_12
XPHY_119 VGND VGND VPWR VPWR sky130_fd_sc_hd__decap_3
XPHY_108 VGND VGND VPWR VPWR sky130_fd_sc_hd__decap_3
X_5986_ u_pe_array.g_pe_row\[1\].g_pe_col\[0\].u_pe.psum_out\[1\] _2737_ _2740_ VGND
+ VGND VPWR VPWR _2741_ sky130_fd_sc_hd__a21bo_1
X_4937_ _1919_ _1920_ VGND VGND VPWR VPWR _1921_ sky130_fd_sc_hd__xnor2_1
XFILLER_0_19_257 VGND VGND VPWR VPWR sky130_fd_sc_hd__decap_3
X_7725_ clknet_leaf_75_clk _0631_ net13 VGND VGND VPWR VPWR u_pe_array.g_pe_row\[0\].g_pe_col\[2\].u_pe.psum_out\[3\]
+ sky130_fd_sc_hd__dfrtp_1
X_4868_ net494 _1749_ _1873_ _1875_ VGND VGND VPWR VPWR _0295_ sky130_fd_sc_hd__a22o_1
X_7656_ clknet_leaf_60_clk _0562_ net74 VGND VGND VPWR VPWR u_pe_array.act_from_right\[2\]\[1\]
+ sky130_fd_sc_hd__dfrtp_1
XFILLER_0_62_514 VGND VGND VPWR VPWR sky130_fd_sc_hd__decap_3
XFILLER_0_19_279 VGND VGND VPWR VPWR sky130_fd_sc_hd__fill_1
X_3819_ u_pe_array.g_pe_row\[3\].g_pe_col\[3\].u_pe.psum_out\[8\] _0988_ VGND VGND
+ VPWR VPWR _1071_ sky130_fd_sc_hd__or2_1
XFILLER_0_7_685 VPWR VGND VPWR VGND sky130_ef_sc_hd__decap_12
XFILLER_0_34_249 VGND VGND VPWR VPWR sky130_fd_sc_hd__decap_3
X_6607_ _0977_ _0862_ u_fsm.ch_cnt\[0\] VGND VGND VPWR VPWR _3228_ sky130_fd_sc_hd__mux2_1
X_7587_ clknet_leaf_45_clk _0493_ net947 VGND VGND VPWR VPWR u_pe_array.g_pe_row\[1\].g_pe_col\[1\].u_pe.psum_out\[1\]
+ sky130_fd_sc_hd__dfrtp_1
XFILLER_0_6_195 VGND VGND VPWR VPWR sky130_fd_sc_hd__fill_1
X_4799_ u_pe_array.g_pe_row\[2\].g_pe_col\[2\].u_pe.psum_out\[7\] _0933_ VGND VGND
+ VPWR VPWR _1821_ sky130_fd_sc_hd__or2_1
X_6538_ _3154_ _3157_ _3165_ VGND VGND VPWR VPWR _3167_ sky130_fd_sc_hd__o21ai_1
X_6469_ u_pe_array.g_pe_row\[0\].g_pe_col\[1\].u_pe.act_val\[0\] _3101_ _2987_ net469
+ VGND VGND VPWR VPWR _0656_ sky130_fd_sc_hd__a22o_1
XFILLER_0_85_617 VPWR VGND VPWR VGND sky130_ef_sc_hd__decap_12
Xmax_cap66 _2197_ VGND VGND VPWR VPWR net66 sky130_fd_sc_hd__buf_1
XFILLER_0_84_116 VGND VGND VPWR VPWR sky130_fd_sc_hd__fill_1
XFILLER_0_78_680 VGND VGND VPWR VPWR sky130_fd_sc_hd__decap_3
XFILLER_0_38_533 VGND VGND VPWR VPWR sky130_fd_sc_hd__decap_8
XFILLER_0_108_421 VGND VGND VPWR VPWR sky130_fd_sc_hd__fill_1
XFILLER_0_65_385 VGND VGND VPWR VPWR sky130_fd_sc_hd__decap_6
XFILLER_0_80_388 VPWR VGND VPWR VGND sky130_ef_sc_hd__decap_12
XFILLER_0_33_271 VGND VGND VPWR VPWR sky130_fd_sc_hd__decap_8
XFILLER_0_104_693 VGND VGND VPWR VPWR sky130_fd_sc_hd__decap_6
XTAP_606 VGND VPWR sky130_fd_sc_hd__tapvpwrvgnd_1
XTAP_617 VGND VPWR sky130_fd_sc_hd__tapvpwrvgnd_1
XTAP_628 VGND VPWR sky130_fd_sc_hd__tapvpwrvgnd_1
XTAP_639 VGND VPWR sky130_fd_sc_hd__tapvpwrvgnd_1
XFILLER_0_17_65 VGND VGND VPWR VPWR sky130_fd_sc_hd__fill_1
XFILLER_0_88_477 VGND VGND VPWR VPWR sky130_fd_sc_hd__decap_6
XFILLER_0_88_455 VGND VGND VPWR VPWR sky130_fd_sc_hd__fill_1
XFILLER_0_29_522 VGND VGND VPWR VPWR sky130_fd_sc_hd__fill_1
XFILLER_0_33_31 VPWR VGND VPWR VGND sky130_ef_sc_hd__decap_12
X_5840_ u_pe_array.g_pe_row\[1\].g_pe_col\[0\].u_pe.act_val\[2\] VGND VGND VPWR VPWR
+ _2634_ sky130_fd_sc_hd__inv_2
X_5771_ _2570_ _2575_ VGND VGND VPWR VPWR _2576_ sky130_fd_sc_hd__or2_1
XFILLER_0_56_374 VGND VGND VPWR VPWR sky130_fd_sc_hd__decap_4
X_4722_ u_pe_array.g_pe_row\[2\].g_pe_col\[2\].u_pe.act_val\[0\] u_pe_array.g_pe_row\[2\].g_pe_col\[2\].u_pe.w_out\[0\]
+ u_pe_array.g_pe_row\[2\].g_pe_col\[2\].u_pe.psum_out\[0\] VGND VGND VPWR VPWR _1751_
+ sky130_fd_sc_hd__a21o_1
X_7510_ clknet_leaf_95_clk _0416_ net951 VGND VGND VPWR VPWR u_pe_array.act_from_right\[5\]\[4\]
+ sky130_fd_sc_hd__dfrtp_1
X_7441_ clknet_leaf_28_clk net78 net71 VGND VGND VPWR VPWR u_pe_array.g_pe_row\[2\].g_pe_col\[0\].u_pe.act_val\[4\]
+ sky130_fd_sc_hd__dfrtp_2
X_4653_ u_pe_array.g_pe_row\[2\].g_pe_col\[3\].u_pe.psum_out\[10\] _1712_ _1702_ VGND
+ VGND VPWR VPWR _1713_ sky130_fd_sc_hd__mux2_1
X_7372_ clknet_leaf_106_clk _0278_ net944 VGND VGND VPWR VPWR u_pe_array.g_pe_row\[2\].g_pe_col\[2\].u_pe.psum_out\[4\]
+ sky130_fd_sc_hd__dfrtp_1
X_3604_ net609 VGND VGND VPWR VPWR _0902_ sky130_fd_sc_hd__inv_2
Xhold802 u_pe_array.act_from_right\[5\]\[4\] VGND VGND VPWR VPWR net876 sky130_fd_sc_hd__dlygate4sd3_1
X_4584_ _1648_ u_pe_array.g_pe_row\[2\].g_pe_col\[3\].u_pe.psum_out\[4\] _1427_ VGND
+ VGND VPWR VPWR _1650_ sky130_fd_sc_hd__and3_1
XFILLER_0_101_129 VGND VGND VPWR VPWR sky130_fd_sc_hd__decap_3
Xhold846 u_pe_array.g_pe_row\[1\].g_pe_col\[1\].u_pe.act_val\[4\] VGND VGND VPWR VPWR
+ net920 sky130_fd_sc_hd__dlygate4sd3_1
XFILLER_0_12_455 VGND VGND VPWR VPWR sky130_fd_sc_hd__fill_2
Xhold835 u_pe_array.u_fifo2.count\[0\] VGND VGND VPWR VPWR net909 sky130_fd_sc_hd__dlygate4sd3_1
X_6323_ u_pe_array.g_pe_row\[0\].g_pe_col\[2\].u_pe.act_val\[2\] _2128_ VGND VGND
+ VPWR VPWR _2996_ sky130_fd_sc_hd__nand2_1
Xhold813 u_pe_array.g_pe_row\[1\].g_pe_col\[2\].u_pe.psum_out\[5\] VGND VGND VPWR
+ VPWR net887 sky130_fd_sc_hd__dlygate4sd3_1
Xhold824 u_pe_array.g_pe_row\[3\].g_pe_col\[0\].u_pe.psum_out\[4\] VGND VGND VPWR
+ VPWR net898 sky130_fd_sc_hd__dlygate4sd3_1
X_6254_ _2954_ _2959_ VGND VGND VPWR VPWR _2960_ sky130_fd_sc_hd__and2_1
Xhold857 u_pe_array.u_fifo1.wr_ptr\[1\] VGND VGND VPWR VPWR net931 sky130_fd_sc_hd__dlygate4sd3_1
XFILLER_0_12_477 VGND VGND VPWR VPWR sky130_fd_sc_hd__fill_1
X_5205_ net171 _1882_ _2132_ _2135_ VGND VGND VPWR VPWR _0372_ sky130_fd_sc_hd__a22o_1
XFILLER_0_58_72 VGND VGND VPWR VPWR sky130_fd_sc_hd__fill_1
X_6185_ u_pe_array.g_pe_row\[0\].g_pe_col\[3\].u_pe.psum_out\[3\] _2882_ _2883_ VGND
+ VGND VPWR VPWR _2897_ sky130_fd_sc_hd__a21boi_1
XFILLER_0_42_3 VGND VGND VPWR VPWR sky130_fd_sc_hd__decap_4
X_5136_ _2073_ _2074_ _2076_ VGND VGND VPWR VPWR _2077_ sky130_fd_sc_hd__and3_1
X_5067_ _0866_ VGND VGND VPWR VPWR _2016_ sky130_fd_sc_hd__clkbuf_8
XFILLER_0_74_71 VGND VGND VPWR VPWR sky130_fd_sc_hd__fill_1
X_4018_ u_pe_array.g_pe_row\[3\].g_pe_col\[2\].u_pe.act_val\[5\] u_pe_array.g_pe_row\[3\].g_pe_col\[2\].u_pe.w_out\[0\]
+ VGND VGND VPWR VPWR _1219_ sky130_fd_sc_hd__nand2_1
XFILLER_0_67_617 VPWR VGND VPWR VGND sky130_ef_sc_hd__decap_12
XFILLER_0_94_425 VPWR VGND VPWR VGND sky130_ef_sc_hd__decap_12
XFILLER_0_79_499 VGND VGND VPWR VPWR sky130_fd_sc_hd__decap_4
XFILLER_0_109_218 VGND VGND VPWR VPWR sky130_fd_sc_hd__decap_6
XFILLER_0_94_458 VGND VGND VPWR VPWR sky130_fd_sc_hd__decap_6
XFILLER_0_90_70 VGND VGND VPWR VPWR sky130_fd_sc_hd__fill_2
XFILLER_0_66_138 VGND VGND VPWR VPWR sky130_fd_sc_hd__fill_2
X_5969_ u_pe_array.act_from_up\[4\]\[8\] _2730_ _2511_ net228 VGND VGND VPWR VPWR
+ _0541_ sky130_fd_sc_hd__a22o_1
XFILLER_0_47_341 VGND VGND VPWR VPWR sky130_fd_sc_hd__fill_1
XFILLER_0_74_160 VGND VGND VPWR VPWR sky130_fd_sc_hd__fill_2
X_7708_ clknet_leaf_62_clk _0614_ net72 VGND VGND VPWR VPWR u_pe_array.act_from_up\[6\]\[12\]
+ sky130_fd_sc_hd__dfrtp_1
XFILLER_0_75_694 VGND VGND VPWR VPWR sky130_fd_sc_hd__decap_8
XFILLER_0_35_547 VPWR VGND VPWR VGND sky130_ef_sc_hd__decap_12
XFILLER_0_47_396 VGND VGND VPWR VPWR sky130_fd_sc_hd__decap_4
XFILLER_0_117_273 VGND VGND VPWR VPWR sky130_fd_sc_hd__decap_6
X_7639_ clknet_leaf_65_clk net304 net946 VGND VGND VPWR VPWR u_pe_array.g_pe_row\[1\].g_pe_col\[0\].u_pe.move_reg\[12\]
+ sky130_fd_sc_hd__dfrtp_1
XFILLER_0_62_344 VGND VGND VPWR VPWR sky130_fd_sc_hd__fill_1
XFILLER_0_90_697 VGND VGND VPWR VPWR sky130_fd_sc_hd__decap_3
XFILLER_0_101_685 VPWR VGND VPWR VGND sky130_ef_sc_hd__decap_12
XFILLER_0_85_447 VGND VGND VPWR VPWR sky130_fd_sc_hd__fill_1
XFILLER_0_38_352 VGND VGND VPWR VPWR sky130_fd_sc_hd__fill_2
XFILLER_0_38_363 VGND VGND VPWR VPWR sky130_fd_sc_hd__fill_1
XFILLER_0_65_160 VGND VGND VPWR VPWR sky130_fd_sc_hd__decap_8
XFILLER_0_108_262 VGND VGND VPWR VPWR sky130_fd_sc_hd__decap_8
Xhold109 u_pe_array.act_from_down\[3\]\[11\] VGND VGND VPWR VPWR net183 sky130_fd_sc_hd__dlygate4sd3_1
XFILLER_0_111_449 VGND VGND VPWR VPWR sky130_fd_sc_hd__fill_1
XFILLER_0_104_490 VGND VGND VPWR VPWR sky130_fd_sc_hd__decap_8
XFILLER_0_0_113 VPWR VGND VPWR VGND sky130_ef_sc_hd__decap_12
XTAP_414 VGND VPWR sky130_fd_sc_hd__tapvpwrvgnd_1
XTAP_403 VGND VPWR sky130_fd_sc_hd__tapvpwrvgnd_1
XTAP_425 VGND VPWR sky130_fd_sc_hd__tapvpwrvgnd_1
XTAP_436 VGND VPWR sky130_fd_sc_hd__tapvpwrvgnd_1
XTAP_447 VGND VPWR sky130_fd_sc_hd__tapvpwrvgnd_1
XTAP_458 VGND VPWR sky130_fd_sc_hd__tapvpwrvgnd_1
XTAP_469 VGND VPWR sky130_fd_sc_hd__tapvpwrvgnd_1
XFILLER_0_28_97 VGND VGND VPWR VPWR sky130_fd_sc_hd__fill_2
X_6941_ _1427_ _0988_ net63 VGND VGND VPWR VPWR _3454_ sky130_fd_sc_hd__mux2_1
X_6872_ net667 _0911_ _3415_ VGND VGND VPWR VPWR _3416_ sky130_fd_sc_hd__mux2_1
XFILLER_0_49_617 VGND VGND VPWR VPWR sky130_fd_sc_hd__decap_8
X_5823_ u_pe_array.g_pe_row\[1\].g_pe_col\[1\].u_pe.psum_out\[9\] u_pe_array.g_pe_row\[1\].g_pe_col\[1\].u_pe.psum_out\[10\]
+ _1728_ VGND VGND VPWR VPWR _2622_ sky130_fd_sc_hd__o21a_1
XFILLER_0_57_661 VGND VGND VPWR VPWR sky130_fd_sc_hd__decap_4
XFILLER_0_17_503 VGND VGND VPWR VPWR sky130_fd_sc_hd__fill_1
X_5754_ u_pe_array.g_pe_row\[1\].g_pe_col\[1\].u_pe.psum_out\[4\] _2547_ _2559_ VGND
+ VGND VPWR VPWR _2560_ sky130_fd_sc_hd__a21oi_1
XFILLER_0_72_675 VGND VGND VPWR VPWR sky130_fd_sc_hd__fill_2
X_5685_ u_pe_array.act_from_right\[5\]\[2\] u_pe_array.act_from_left\[5\]\[2\] _0963_
+ VGND VGND VPWR VPWR _2507_ sky130_fd_sc_hd__mux2_1
XFILLER_0_17_569 VGND VGND VPWR VPWR sky130_fd_sc_hd__decap_3
X_4705_ u_pe_array.g_pe_row\[2\].g_pe_col\[2\].u_pe.psum_out\[12\] u_pe_array.g_pe_row\[2\].g_pe_col\[2\].u_pe.move_reg\[12\]
+ _1599_ VGND VGND VPWR VPWR _1748_ sky130_fd_sc_hd__mux2_1
XFILLER_0_114_232 VPWR VGND VPWR VGND sky130_ef_sc_hd__decap_12
X_7424_ clknet_leaf_12_clk _0330_ net951 VGND VGND VPWR VPWR u_pe_array.act_from_up\[12\]\[0\]
+ sky130_fd_sc_hd__dfrtp_2
XFILLER_0_8_41 VPWR VGND VPWR VGND sky130_ef_sc_hd__decap_12
XFILLER_0_32_517 VGND VGND VPWR VPWR sky130_fd_sc_hd__decap_6
X_4636_ u_pe_array.g_pe_row\[2\].g_pe_col\[3\].u_pe.psum_out\[8\] _1683_ VGND VGND
+ VPWR VPWR _1698_ sky130_fd_sc_hd__nor2_1
XFILLER_0_114_265 VGND VGND VPWR VPWR sky130_fd_sc_hd__decap_4
XFILLER_0_71_196 VGND VGND VPWR VPWR sky130_fd_sc_hd__fill_2
XFILLER_0_4_474 VGND VGND VPWR VPWR sky130_fd_sc_hd__fill_2
Xhold621 u_pe_array.u_fifo1.buffer\[5\]\[4\] VGND VGND VPWR VPWR net695 sky130_fd_sc_hd__dlygate4sd3_1
X_7355_ clknet_leaf_0_clk net334 net944 VGND VGND VPWR VPWR u_pe_array.g_pe_row\[2\].g_pe_col\[2\].u_pe.act_val\[0\]
+ sky130_fd_sc_hd__dfrtp_4
Xhold610 u_pe_array.g_pe_row\[1\].g_pe_col\[0\].u_pe.psum_out\[5\] VGND VGND VPWR
+ VPWR net684 sky130_fd_sc_hd__dlygate4sd3_1
X_6306_ net324 _2730_ _2511_ u_pe_array.g_pe_row\[0\].g_pe_col\[2\].u_pe.move_reg\[6\]
+ VGND VGND VPWR VPWR _0621_ sky130_fd_sc_hd__a22o_1
Xhold632 u_pe_array.u_fifo2.buffer\[5\]\[3\] VGND VGND VPWR VPWR net706 sky130_fd_sc_hd__dlygate4sd3_1
XFILLER_0_8_85 VPWR VGND VPWR VGND sky130_ef_sc_hd__decap_12
Xhold654 u_pe_array.u_fifo2.buffer\[2\]\[5\] VGND VGND VPWR VPWR net728 sky130_fd_sc_hd__dlygate4sd3_1
X_4567_ u_pe_array.g_pe_row\[2\].g_pe_col\[3\].u_pe.act_val\[3\] _1424_ VGND VGND
+ VPWR VPWR _1634_ sky130_fd_sc_hd__nand2_1
Xhold643 u_pe_array.g_pe_row\[1\].g_pe_col\[2\].u_pe.act_val\[0\] VGND VGND VPWR VPWR
+ net717 sky130_fd_sc_hd__dlygate4sd3_1
Xhold687 u_pe_array.g_pe_row\[1\].g_pe_col\[1\].u_pe.act_val\[2\] VGND VGND VPWR VPWR
+ net761 sky130_fd_sc_hd__dlygate4sd3_1
X_7286_ clknet_leaf_13_clk _0192_ net943 VGND VGND VPWR VPWR u_pe_array.g_pe_row\[3\].g_pe_col\[0\].u_pe.psum_out\[0\]
+ sky130_fd_sc_hd__dfrtp_1
Xhold665 u_pe_array.g_pe_row\[3\].g_pe_col\[2\].u_pe.act_val\[5\] VGND VGND VPWR VPWR
+ net739 sky130_fd_sc_hd__dlygate4sd3_1
Xhold676 u_pe_array.u_fifo2.buffer\[6\]\[1\] VGND VGND VPWR VPWR net750 sky130_fd_sc_hd__dlygate4sd3_1
X_4498_ _1595_ u_pe_array.g_pe_row\[2\].g_pe_col\[2\].u_pe.w_out\[0\] _0931_ VGND
+ VGND VPWR VPWR _1596_ sky130_fd_sc_hd__mux2_1
XFILLER_0_40_583 VGND VGND VPWR VPWR sky130_fd_sc_hd__decap_4
XFILLER_0_40_594 VPWR VGND VPWR VGND sky130_ef_sc_hd__decap_12
X_6237_ _2936_ _2938_ _2943_ VGND VGND VPWR VPWR _2945_ sky130_fd_sc_hd__o21a_1
Xhold698 u_pe_array.g_pe_row\[3\].g_pe_col\[2\].u_pe.act_val\[1\] VGND VGND VPWR VPWR
+ net772 sky130_fd_sc_hd__dlygate4sd3_1
X_6168_ u_pe_array.g_pe_row\[0\].g_pe_col\[3\].u_pe.act_val\[2\] VGND VGND VPWR VPWR
+ _2881_ sky130_fd_sc_hd__inv_2
XTAP_970 VGND VPWR sky130_fd_sc_hd__tapvpwrvgnd_1
X_5119_ _1884_ _2060_ _2061_ _1803_ net517 VGND VGND VPWR VPWR _0360_ sky130_fd_sc_hd__a32o_1
XFILLER_0_85_92 VPWR VGND VPWR VGND sky130_ef_sc_hd__decap_12
XTAP_992 VGND VPWR sky130_fd_sc_hd__tapvpwrvgnd_1
XTAP_981 VGND VPWR sky130_fd_sc_hd__tapvpwrvgnd_1
X_6099_ _2842_ VGND VGND VPWR VPWR _0559_ sky130_fd_sc_hd__clkbuf_1
XFILLER_0_39_105 VGND VGND VPWR VPWR sky130_fd_sc_hd__decap_6
XFILLER_0_67_458 VGND VGND VPWR VPWR sky130_fd_sc_hd__decap_4
XFILLER_0_67_469 VGND VGND VPWR VPWR sky130_fd_sc_hd__fill_1
XFILLER_0_54_119 VPWR VGND VPWR VGND sky130_ef_sc_hd__decap_12
XFILLER_0_48_694 VGND VGND VPWR VPWR sky130_fd_sc_hd__fill_2
XFILLER_0_62_141 VGND VGND VPWR VPWR sky130_fd_sc_hd__decap_6
XFILLER_0_62_130 VGND VGND VPWR VPWR sky130_fd_sc_hd__fill_1
XFILLER_0_86_701 VGND VGND VPWR VPWR sky130_fd_sc_hd__decap_4
XFILLER_0_58_403 VGND VGND VPWR VPWR sky130_fd_sc_hd__fill_2
XFILLER_0_105_57 VPWR VGND VPWR VGND sky130_ef_sc_hd__decap_12
XFILLER_0_85_233 VGND VGND VPWR VPWR sky130_fd_sc_hd__fill_1
XFILLER_0_58_436 VGND VGND VPWR VPWR sky130_fd_sc_hd__fill_1
XFILLER_0_109_593 VGND VGND VPWR VPWR sky130_fd_sc_hd__decap_6
XFILLER_0_5_205 VPWR VGND VPWR VGND sky130_ef_sc_hd__decap_12
XFILLER_0_38_193 VGND VGND VPWR VPWR sky130_fd_sc_hd__decap_3
XFILLER_0_53_141 VGND VGND VPWR VPWR sky130_fd_sc_hd__decap_3
X_5470_ _2322_ _2323_ VGND VGND VPWR VPWR _2335_ sky130_fd_sc_hd__nor2_2
XFILLER_0_100_3 VPWR VGND VPWR VGND sky130_ef_sc_hd__decap_12
X_4421_ u_pe_array.g_pe_row\[3\].g_pe_col\[0\].u_pe.act_val\[5\] u_pe_array.g_pe_row\[3\].g_pe_col\[0\].u_pe.w_out\[0\]
+ VGND VGND VPWR VPWR _1527_ sky130_fd_sc_hd__nand2_1
XFILLER_0_10_701 VGND VGND VPWR VPWR sky130_fd_sc_hd__decap_4
XFILLER_0_22_561 VGND VGND VPWR VPWR sky130_fd_sc_hd__fill_1
XFILLER_0_111_279 VGND VGND VPWR VPWR sky130_fd_sc_hd__fill_1
X_7140_ clknet_leaf_18_clk _0046_ net943 VGND VGND VPWR VPWR u_pe_array.g_pe_row\[3\].g_pe_col\[3\].u_pe.psum_out\[3\]
+ sky130_fd_sc_hd__dfrtp_1
X_4352_ net142 _1166_ _1468_ _1476_ VGND VGND VPWR VPWR _0178_ sky130_fd_sc_hd__a22o_1
X_4283_ u_pe_array.g_pe_row\[3\].g_pe_col\[0\].u_pe.act_val\[1\] net62 VGND VGND VPWR
+ VPWR _1432_ sky130_fd_sc_hd__or2_1
X_7071_ _3532_ VGND VGND VPWR VPWR _0841_ sky130_fd_sc_hd__clkbuf_1
XTAP_266 VGND VPWR sky130_fd_sc_hd__tapvpwrvgnd_1
XTAP_244 VGND VPWR sky130_fd_sc_hd__tapvpwrvgnd_1
XTAP_255 VGND VPWR sky130_fd_sc_hd__tapvpwrvgnd_1
X_6022_ u_pe_array.g_pe_row\[1\].g_pe_col\[0\].u_pe.act_val\[5\] u_pe_array.g_pe_row\[1\].g_pe_col\[0\].u_pe.w_out\[0\]
+ VGND VGND VPWR VPWR _2774_ sky130_fd_sc_hd__nand2_1
XTAP_299 VGND VPWR sky130_fd_sc_hd__tapvpwrvgnd_1
XTAP_277 VGND VPWR sky130_fd_sc_hd__tapvpwrvgnd_1
XTAP_288 VGND VPWR sky130_fd_sc_hd__tapvpwrvgnd_1
XFILLER_0_76_200 VGND VGND VPWR VPWR sky130_fd_sc_hd__decap_3
X_6924_ _0928_ net786 _3439_ VGND VGND VPWR VPWR _3445_ sky130_fd_sc_hd__mux2_1
XFILLER_0_49_447 VGND VGND VPWR VPWR sky130_fd_sc_hd__fill_1
XFILLER_0_71_83 VGND VGND VPWR VPWR sky130_fd_sc_hd__decap_6
XFILLER_0_9_522 VGND VGND VPWR VPWR sky130_fd_sc_hd__decap_8
XFILLER_0_9_511 VGND VGND VPWR VPWR sky130_fd_sc_hd__fill_1
X_6855_ net671 _0928_ _3400_ VGND VGND VPWR VPWR _3406_ sky130_fd_sc_hd__mux2_1
X_5806_ _2600_ _2601_ _2606_ _2603_ _2598_ VGND VGND VPWR VPWR _2607_ sky130_fd_sc_hd__a32o_1
XFILLER_0_17_300 VGND VGND VPWR VPWR sky130_fd_sc_hd__decap_4
X_3998_ _1200_ VGND VGND VPWR VPWR _1201_ sky130_fd_sc_hd__inv_2
X_6786_ _3361_ VGND VGND VPWR VPWR _0727_ sky130_fd_sc_hd__clkbuf_1
X_5737_ _2532_ _2541_ _2540_ VGND VGND VPWR VPWR _2544_ sky130_fd_sc_hd__a21oi_1
XFILLER_0_9_588 VGND VGND VPWR VPWR sky130_fd_sc_hd__fill_2
XFILLER_0_17_333 VGND VGND VPWR VPWR sky130_fd_sc_hd__decap_3
XFILLER_0_72_472 VGND VGND VPWR VPWR sky130_fd_sc_hd__decap_4
X_5668_ u_pe_array.g_pe_row\[1\].g_pe_col\[1\].u_pe.psum_out\[7\] u_pe_array.g_pe_row\[1\].g_pe_col\[1\].u_pe.move_reg\[7\]
+ _2133_ VGND VGND VPWR VPWR _2498_ sky130_fd_sc_hd__mux2_1
X_7407_ clknet_leaf_14_clk net294 net951 VGND VGND VPWR VPWR u_pe_array.g_pe_row\[2\].g_pe_col\[1\].u_pe.move_reg\[11\]
+ sky130_fd_sc_hd__dfrtp_1
XFILLER_0_60_645 VGND VGND VPWR VPWR sky130_fd_sc_hd__decap_4
XFILLER_0_102_213 VGND VGND VPWR VPWR sky130_fd_sc_hd__fill_1
XFILLER_0_4_293 VGND VGND VPWR VPWR sky130_fd_sc_hd__decap_4
X_4619_ u_pe_array.g_pe_row\[2\].g_pe_col\[3\].u_pe.psum_out\[7\] VGND VGND VPWR VPWR
+ _1682_ sky130_fd_sc_hd__inv_2
X_5599_ u_pe_array.g_pe_row\[1\].g_pe_col\[2\].u_pe.psum_out\[7\] _1597_ VGND VGND
+ VPWR VPWR _2444_ sky130_fd_sc_hd__or2_1
Xhold451 u_pe_array.g_pe_row\[0\].g_pe_col\[0\].u_pe.psum_out\[6\] VGND VGND VPWR
+ VPWR net525 sky130_fd_sc_hd__dlygate4sd3_1
Xhold440 u_pe_array.g_pe_row\[1\].g_pe_col\[3\].u_pe.move_reg\[10\] VGND VGND VPWR
+ VPWR net514 sky130_fd_sc_hd__dlygate4sd3_1
Xhold462 u_pe_array.g_pe_row\[1\].g_pe_col\[2\].u_pe.psum_out\[4\] VGND VGND VPWR
+ VPWR net536 sky130_fd_sc_hd__dlygate4sd3_1
X_7338_ clknet_leaf_5_clk _0244_ net945 VGND VGND VPWR VPWR u_pe_array.g_pe_row\[2\].g_pe_col\[3\].u_pe.psum_out\[11\]
+ sky130_fd_sc_hd__dfrtp_1
Xhold495 u_pe_array.g_pe_row\[1\].g_pe_col\[3\].u_pe.psum_out\[4\] VGND VGND VPWR
+ VPWR net569 sky130_fd_sc_hd__dlygate4sd3_1
Xhold484 u_pe_array.g_pe_row\[3\].g_pe_col\[3\].u_pe.psum_out\[6\] VGND VGND VPWR
+ VPWR net558 sky130_fd_sc_hd__dlygate4sd3_1
X_7269_ clknet_leaf_38_clk _0175_ net942 VGND VGND VPWR VPWR u_pe_array.act_from_left\[13\]\[9\]
+ sky130_fd_sc_hd__dfrtp_1
Xhold473 u_pe_array.u_fifo2.buffer\[0\]\[1\] VGND VGND VPWR VPWR net547 sky130_fd_sc_hd__dlygate4sd3_1
XFILLER_0_110_290 VGND VGND VPWR VPWR sky130_fd_sc_hd__decap_4
XFILLER_0_99_325 VGND VGND VPWR VPWR sky130_fd_sc_hd__decap_8
XFILLER_0_99_358 VGND VGND VPWR VPWR sky130_fd_sc_hd__fill_1
XFILLER_0_68_701 VGND VGND VPWR VPWR sky130_fd_sc_hd__decap_4
XFILLER_0_67_222 VGND VGND VPWR VPWR sky130_fd_sc_hd__fill_2
XFILLER_0_95_586 VGND VGND VPWR VPWR sky130_fd_sc_hd__fill_1
XFILLER_0_55_417 VGND VGND VPWR VPWR sky130_fd_sc_hd__decap_6
XFILLER_0_35_141 VGND VGND VPWR VPWR sky130_fd_sc_hd__fill_2
XFILLER_0_50_166 VGND VGND VPWR VPWR sky130_fd_sc_hd__decap_3
XFILLER_0_50_177 VGND VGND VPWR VPWR sky130_fd_sc_hd__decap_3
XFILLER_0_50_188 VGND VGND VPWR VPWR sky130_fd_sc_hd__fill_1
XFILLER_0_92_27 VGND VGND VPWR VPWR sky130_fd_sc_hd__fill_1
X_4970_ _1884_ _1950_ _1951_ _1803_ net741 VGND VGND VPWR VPWR _0321_ sky130_fd_sc_hd__a32o_1
XFILLER_0_58_222 VGND VGND VPWR VPWR sky130_fd_sc_hd__decap_4
XFILLER_0_86_564 VGND VGND VPWR VPWR sky130_fd_sc_hd__fill_1
XFILLER_0_19_609 VGND VGND VPWR VPWR sky130_fd_sc_hd__decap_6
X_3921_ _1154_ VGND VGND VPWR VPWR _0069_ sky130_fd_sc_hd__clkbuf_1
X_6640_ u_pe_array.g_pe_row\[0\].g_pe_col\[0\].u_pe.act_val\[3\] _2343_ _2320_ net319
+ VGND VGND VPWR VPWR _0700_ sky130_fd_sc_hd__a22o_1
X_3852_ u_pe_array.g_pe_row\[3\].g_pe_col\[3\].u_pe.psum_out\[9\] u_pe_array.g_pe_row\[3\].g_pe_col\[3\].u_pe.psum_out\[10\]
+ _0988_ VGND VGND VPWR VPWR _1100_ sky130_fd_sc_hd__o21a_1
XFILLER_0_116_305 VGND VGND VPWR VPWR sky130_fd_sc_hd__decap_3
X_6571_ _3195_ _3196_ VGND VGND VPWR VPWR _3197_ sky130_fd_sc_hd__nand2_1
X_3783_ u_pe_array.g_pe_row\[3\].g_pe_col\[3\].u_pe.act_val\[4\] u_pe_array.g_pe_row\[3\].g_pe_col\[3\].u_pe.w_out\[0\]
+ _1023_ VGND VGND VPWR VPWR _1038_ sky130_fd_sc_hd__and3_1
X_5522_ net114 _2016_ _1883_ u_pe_array.g_pe_row\[1\].g_pe_col\[2\].u_pe.move_reg\[8\]
+ VGND VGND VPWR VPWR _0446_ sky130_fd_sc_hd__a22o_1
XFILLER_0_26_141 VGND VGND VPWR VPWR sky130_fd_sc_hd__decap_4
XFILLER_0_41_111 VGND VGND VPWR VPWR sky130_fd_sc_hd__fill_1
XFILLER_0_42_645 VGND VGND VPWR VPWR sky130_fd_sc_hd__decap_8
XFILLER_0_112_533 VPWR VGND VPWR VGND sky130_ef_sc_hd__decap_12
XFILLER_0_112_511 VGND VGND VPWR VPWR sky130_fd_sc_hd__fill_2
X_5453_ net131 _1159_ _2309_ _1476_ VGND VGND VPWR VPWR _0436_ sky130_fd_sc_hd__a22o_1
XFILLER_0_112_555 VGND VGND VPWR VPWR sky130_fd_sc_hd__decap_4
X_4404_ _1509_ _1511_ VGND VGND VPWR VPWR _1512_ sky130_fd_sc_hd__nor2_1
X_5384_ _2274_ VGND VGND VPWR VPWR _0412_ sky130_fd_sc_hd__clkbuf_1
X_4335_ _1433_ net828 _1159_ VGND VGND VPWR VPWR _1471_ sky130_fd_sc_hd__mux2_1
X_7123_ clknet_leaf_18_clk _0029_ net943 VGND VGND VPWR VPWR u_pe_array.act_from_down\[11\]\[12\]
+ sky130_fd_sc_hd__dfrtp_1
X_4266_ u_pe_array.g_pe_row\[3\].g_pe_col\[1\].u_pe.psum_out\[9\] u_pe_array.g_pe_row\[3\].g_pe_col\[1\].u_pe.psum_out\[10\]
+ _1106_ VGND VGND VPWR VPWR _1419_ sky130_fd_sc_hd__o21a_1
X_7054_ net608 _3354_ _3521_ VGND VGND VPWR VPWR _3523_ sky130_fd_sc_hd__mux2_1
X_4197_ u_pe_array.g_pe_row\[3\].g_pe_col\[1\].u_pe.act_val\[4\] u_pe_array.g_pe_row\[3\].g_pe_col\[1\].u_pe.w_out\[0\]
+ _1347_ VGND VGND VPWR VPWR _1357_ sky130_fd_sc_hd__and3_1
XFILLER_0_66_83 VGND VGND VPWR VPWR sky130_fd_sc_hd__fill_1
X_6005_ _2755_ _2757_ VGND VGND VPWR VPWR _2759_ sky130_fd_sc_hd__nand2_1
XFILLER_0_82_71 VGND VGND VPWR VPWR sky130_fd_sc_hd__decap_3
XTAP_1229 VGND VPWR sky130_fd_sc_hd__tapvpwrvgnd_1
XTAP_1218 VGND VPWR sky130_fd_sc_hd__tapvpwrvgnd_1
XTAP_1207 VGND VPWR sky130_fd_sc_hd__tapvpwrvgnd_1
XFILLER_0_77_564 VGND VGND VPWR VPWR sky130_fd_sc_hd__fill_1
XFILLER_0_65_704 VGND VGND VPWR VPWR sky130_fd_sc_hd__fill_1
X_7887_ clknet_leaf_80_clk _0792_ net13 VGND VGND VPWR VPWR u_pe_array.u_fifo1.wr_ptr\[1\]
+ sky130_fd_sc_hd__dfrtp_2
X_6907_ _3435_ VGND VGND VPWR VPWR _0774_ sky130_fd_sc_hd__clkbuf_1
XFILLER_0_77_586 VGND VGND VPWR VPWR sky130_fd_sc_hd__decap_4
XFILLER_0_9_341 VGND VGND VPWR VPWR sky130_fd_sc_hd__fill_1
X_6838_ _3396_ VGND VGND VPWR VPWR _0744_ sky130_fd_sc_hd__clkbuf_1
XFILLER_0_92_578 VGND VGND VPWR VPWR sky130_fd_sc_hd__fill_1
XFILLER_0_18_642 VGND VGND VPWR VPWR sky130_fd_sc_hd__fill_2
X_6769_ u_pe_array.u_fifo1.count\[1\] u_pe_array.u_fifo1.count\[2\] _3348_ _0858_
+ VGND VGND VPWR VPWR _3349_ sky130_fd_sc_hd__o31a_2
XFILLER_0_18_686 VPWR VGND VPWR VGND sky130_ef_sc_hd__decap_12
XFILLER_0_103_500 VGND VGND VPWR VPWR sky130_fd_sc_hd__decap_4
XFILLER_0_17_196 VGND VGND VPWR VPWR sky130_fd_sc_hd__fill_1
XFILLER_0_115_393 VGND VGND VPWR VPWR sky130_fd_sc_hd__decap_8
XFILLER_0_115_382 VGND VGND VPWR VPWR sky130_fd_sc_hd__decap_8
XFILLER_0_60_475 VGND VGND VPWR VPWR sky130_fd_sc_hd__fill_1
Xhold270 u_pe_array.act_from_right\[2\]\[3\] VGND VGND VPWR VPWR net344 sky130_fd_sc_hd__dlygate4sd3_1
Xhold292 u_pe_array.act_from_down\[1\]\[8\] VGND VGND VPWR VPWR net366 sky130_fd_sc_hd__dlygate4sd3_1
Xhold281 u_pe_array.act_from_down\[9\]\[1\] VGND VGND VPWR VPWR net355 sky130_fd_sc_hd__dlygate4sd3_1
XFILLER_0_99_111 VGND VGND VPWR VPWR sky130_fd_sc_hd__fill_1
XFILLER_0_99_199 VGND VGND VPWR VPWR sky130_fd_sc_hd__decap_8
XTAP_1741 VGND VPWR sky130_fd_sc_hd__tapvpwrvgnd_1
XTAP_1730 VGND VPWR sky130_fd_sc_hd__tapvpwrvgnd_1
XFILLER_0_55_225 VGND VGND VPWR VPWR sky130_fd_sc_hd__fill_1
XFILLER_0_3_517 VPWR VGND VPWR VGND sky130_ef_sc_hd__decap_12
XFILLER_0_24_645 VGND VGND VPWR VPWR sky130_fd_sc_hd__decap_4
XFILLER_0_11_306 VGND VGND VPWR VPWR sky130_fd_sc_hd__fill_1
X_4120_ u_pe_array.g_pe_row\[3\].g_pe_col\[1\].u_pe.psum_out\[11\] u_pe_array.g_pe_row\[3\].g_pe_col\[1\].u_pe.move_reg\[11\]
+ _0947_ VGND VGND VPWR VPWR _1300_ sky130_fd_sc_hd__mux2_1
X_4051_ _1212_ _1223_ _1224_ VGND VGND VPWR VPWR _1249_ sky130_fd_sc_hd__o21bai_1
Xinput5 h_in0[4] VGND VGND VPWR VPWR net5 sky130_fd_sc_hd__dlymetal6s2s_1
X_7810_ clknet_leaf_54_clk _0715_ net74 VGND VGND VPWR VPWR u_pe_array.g_pe_row\[0\].g_pe_col\[0\].u_pe.psum_out\[5\]
+ sky130_fd_sc_hd__dfrtp_1
X_7741_ clknet_leaf_53_clk _0647_ net74 VGND VGND VPWR VPWR u_pe_array.act_from_right\[0\]\[4\]
+ sky130_fd_sc_hd__dfrtp_1
X_4953_ _1924_ _1927_ _1935_ VGND VGND VPWR VPWR _1936_ sky130_fd_sc_hd__or3_1
X_7672_ clknet_leaf_57_clk net475 net74 VGND VGND VPWR VPWR u_pe_array.g_pe_row\[0\].g_pe_col\[3\].u_pe.act_val\[4\]
+ sky130_fd_sc_hd__dfrtp_1
X_3904_ net121 _1141_ _1116_ VGND VGND VPWR VPWR _1142_ sky130_fd_sc_hd__mux2_1
X_6623_ u_pe_array.g_pe_row\[0\].g_pe_col\[0\].u_pe.psum_out\[6\] u_pe_array.g_pe_row\[0\].g_pe_col\[0\].u_pe.move_reg\[6\]
+ _3102_ VGND VGND VPWR VPWR _3236_ sky130_fd_sc_hd__mux2_1
X_4884_ _0938_ VGND VGND VPWR VPWR _1882_ sky130_fd_sc_hd__clkbuf_8
XFILLER_0_74_567 VGND VGND VPWR VPWR sky130_fd_sc_hd__fill_1
XFILLER_0_117_669 VGND VGND VPWR VPWR sky130_fd_sc_hd__decap_3
X_3835_ _1078_ _1079_ _1084_ _1081_ _1076_ VGND VGND VPWR VPWR _1085_ sky130_fd_sc_hd__a32o_1
XFILLER_0_74_589 VGND VGND VPWR VPWR sky130_fd_sc_hd__decap_4
XFILLER_0_116_157 VGND VGND VPWR VPWR sky130_fd_sc_hd__fill_1
X_6554_ _1092_ _3180_ _3181_ _1005_ net538 VGND VGND VPWR VPWR _0675_ sky130_fd_sc_hd__a32o_1
X_3766_ _1009_ _1018_ _1017_ VGND VGND VPWR VPWR _1022_ sky130_fd_sc_hd__a21oi_1
XFILLER_0_15_634 VGND VGND VPWR VPWR sky130_fd_sc_hd__fill_2
X_6485_ _2795_ _3116_ _3118_ _1005_ net512 VGND VGND VPWR VPWR _0669_ sky130_fd_sc_hd__a32o_1
XFILLER_0_6_399 VGND VGND VPWR VPWR sky130_fd_sc_hd__decap_6
X_5505_ u_pe_array.u_fifo2.buffer\[7\]\[4\] _2327_ _2329_ u_pe_array.u_fifo2.buffer\[1\]\[4\]
+ VGND VGND VPWR VPWR _2366_ sky130_fd_sc_hd__a22o_1
XFILLER_0_72_3 VGND VGND VPWR VPWR sky130_fd_sc_hd__decap_8
X_3697_ net10 u_pe_array.act_from_left\[15\]\[3\] _0963_ VGND VGND VPWR VPWR _0967_
+ sky130_fd_sc_hd__mux2_1
X_5436_ _2272_ net832 _1158_ VGND VGND VPWR VPWR _2314_ sky130_fd_sc_hd__mux2_1
X_5367_ _2257_ _2261_ VGND VGND VPWR VPWR _2262_ sky130_fd_sc_hd__xor2_1
X_5298_ _2185_ _2186_ VGND VGND VPWR VPWR _2200_ sky130_fd_sc_hd__and2b_1
X_4318_ u_pe_array.g_pe_row\[3\].g_pe_col\[0\].u_pe.psum_out\[9\] _1108_ _1110_ _1458_
+ VGND VGND VPWR VPWR _1459_ sky130_fd_sc_hd__o211a_2
X_7106_ clknet_leaf_88_clk _0012_ VGND VGND VPWR VPWR u_pe_array.u_fifo2.buffer\[8\]\[3\]
+ sky130_fd_sc_hd__dfxtp_1
X_4249_ _1033_ _1403_ _1404_ _1356_ net797 VGND VGND VPWR VPWR _0147_ sky130_fd_sc_hd__a32o_1
X_7037_ u_pe_array.u_fifo1.wr_ptr\[3\] net948 _3349_ u_pe_array.u_fifo1.wr_ptr\[2\]
+ VGND VGND VPWR VPWR _3513_ sky130_fd_sc_hd__and4b_1
XFILLER_0_97_615 VGND VGND VPWR VPWR sky130_fd_sc_hd__fill_1
XFILLER_0_93_81 VGND VGND VPWR VPWR sky130_fd_sc_hd__decap_8
XTAP_1004 VGND VPWR sky130_fd_sc_hd__tapvpwrvgnd_1
XFILLER_0_77_350 VGND VGND VPWR VPWR sky130_fd_sc_hd__fill_2
XTAP_1037 VGND VPWR sky130_fd_sc_hd__tapvpwrvgnd_1
XTAP_1026 VGND VPWR sky130_fd_sc_hd__tapvpwrvgnd_1
XTAP_1015 VGND VPWR sky130_fd_sc_hd__tapvpwrvgnd_1
X_7939_ clknet_leaf_77_clk _0844_ VGND VGND VPWR VPWR u_pe_array.u_fifo1.buffer\[6\]\[5\]
+ sky130_fd_sc_hd__dfxtp_1
XFILLER_0_65_523 VGND VGND VPWR VPWR sky130_fd_sc_hd__decap_3
XTAP_1059 VGND VPWR sky130_fd_sc_hd__tapvpwrvgnd_1
XTAP_1048 VGND VPWR sky130_fd_sc_hd__tapvpwrvgnd_1
XFILLER_0_108_614 VPWR VGND VPWR VGND sky130_ef_sc_hd__decap_12
XFILLER_0_108_669 VPWR VGND VPWR VGND sky130_ef_sc_hd__decap_12
XFILLER_0_107_113 VGND VGND VPWR VPWR sky130_fd_sc_hd__decap_8
XFILLER_0_21_615 VGND VGND VPWR VPWR sky130_fd_sc_hd__fill_1
XFILLER_0_88_615 VGND VGND VPWR VPWR sky130_fd_sc_hd__decap_8
XFILLER_0_87_169 VGND VGND VPWR VPWR sky130_fd_sc_hd__decap_4
XTAP_1560 VGND VPWR sky130_fd_sc_hd__tapvpwrvgnd_1
XTAP_1593 VGND VPWR sky130_fd_sc_hd__tapvpwrvgnd_1
XTAP_1571 VGND VPWR sky130_fd_sc_hd__tapvpwrvgnd_1
XTAP_1582 VGND VPWR sky130_fd_sc_hd__tapvpwrvgnd_1
XFILLER_0_113_57 VPWR VGND VPWR VGND sky130_ef_sc_hd__decap_12
XFILLER_0_98_15 VPWR VGND VPWR VGND sky130_ef_sc_hd__decap_12
XFILLER_0_71_559 VGND VGND VPWR VPWR sky130_fd_sc_hd__fill_1
X_3620_ u_pe_array.u_fifo2.count\[1\] u_pe_array.u_fifo2.count\[2\] _0913_ _0858_
+ VGND VGND VPWR VPWR _0914_ sky130_fd_sc_hd__o31a_2
XFILLER_0_113_105 VGND VGND VPWR VPWR sky130_fd_sc_hd__decap_6
X_3551_ u_fsm.state\[1\] _0852_ _0858_ VGND VGND VPWR VPWR _0859_ sky130_fd_sc_hd__a21boi_1
XFILLER_0_24_464 VGND VGND VPWR VPWR sky130_fd_sc_hd__decap_6
XFILLER_0_113_149 VPWR VGND VPWR VGND sky130_ef_sc_hd__decap_12
XFILLER_0_11_103 VGND VGND VPWR VPWR sky130_fd_sc_hd__decap_8
XFILLER_0_24_497 VGND VGND VPWR VPWR sky130_fd_sc_hd__decap_8
X_6270_ _2972_ VGND VGND VPWR VPWR _0600_ sky130_fd_sc_hd__clkbuf_1
X_5221_ u_pe_array.g_pe_row\[1\].g_pe_col\[3\].u_pe.psum_out\[9\] net539 _2133_ VGND
+ VGND VPWR VPWR _2144_ sky130_fd_sc_hd__mux2_1
X_5152_ _1884_ _2090_ _2091_ _1803_ net854 VGND VGND VPWR VPWR _0363_ sky130_fd_sc_hd__a32o_1
X_4103_ net378 _1167_ _1169_ _1291_ VGND VGND VPWR VPWR _0114_ sky130_fd_sc_hd__a22o_1
X_5083_ _2025_ _2027_ VGND VGND VPWR VPWR _2028_ sky130_fd_sc_hd__xnor2_1
XFILLER_0_37_6 VGND VGND VPWR VPWR sky130_fd_sc_hd__decap_4
XFILLER_0_79_615 VGND VGND VPWR VPWR sky130_fd_sc_hd__fill_1
X_4034_ _1232_ _1233_ VGND VGND VPWR VPWR _1234_ sky130_fd_sc_hd__or2b_1
XFILLER_0_2_65 VPWR VGND VPWR VGND sky130_ef_sc_hd__decap_12
XFILLER_0_94_618 VGND VGND VPWR VPWR sky130_fd_sc_hd__fill_2
XFILLER_0_78_147 VGND VGND VPWR VPWR sky130_fd_sc_hd__fill_1
XPHY_109 VGND VGND VPWR VPWR sky130_fd_sc_hd__decap_3
XFILLER_0_19_203 VPWR VGND VPWR VGND sky130_ef_sc_hd__decap_12
X_7724_ clknet_leaf_75_clk _0630_ net13 VGND VGND VPWR VPWR u_pe_array.g_pe_row\[0\].g_pe_col\[2\].u_pe.psum_out\[2\]
+ sky130_fd_sc_hd__dfrtp_1
X_5985_ _2732_ _2736_ VGND VGND VPWR VPWR _2740_ sky130_fd_sc_hd__nand2_1
X_4936_ u_pe_array.g_pe_row\[2\].g_pe_col\[1\].u_pe.act_val\[4\] u_pe_array.g_pe_row\[2\].g_pe_col\[1\].u_pe.w_out\[0\]
+ VGND VGND VPWR VPWR _1920_ sky130_fd_sc_hd__nand2_1
XFILLER_0_19_225 VGND VGND VPWR VPWR sky130_fd_sc_hd__decap_4
X_4867_ u_pe_array.g_pe_row\[2\].g_pe_col\[1\].u_pe.psum_out\[6\] net226 _1867_ VGND
+ VGND VPWR VPWR _1875_ sky130_fd_sc_hd__mux2_1
X_7655_ clknet_leaf_61_clk _0561_ net74 VGND VGND VPWR VPWR u_pe_array.act_from_right\[2\]\[0\]
+ sky130_fd_sc_hd__dfrtp_1
XFILLER_0_7_620 VGND VGND VPWR VPWR sky130_fd_sc_hd__decap_3
XANTENNA_10 net21 VGND VGND VPWR VPWR sky130_fd_sc_hd__diode_2
XFILLER_0_105_617 VGND VGND VPWR VPWR sky130_fd_sc_hd__decap_4
X_7586_ clknet_leaf_33_clk _0492_ net71 VGND VGND VPWR VPWR u_pe_array.g_pe_row\[1\].g_pe_col\[1\].u_pe.psum_out\[0\]
+ sky130_fd_sc_hd__dfrtp_1
X_6606_ net607 _2586_ _3227_ _0978_ VGND VGND VPWR VPWR _0681_ sky130_fd_sc_hd__a22o_1
X_3818_ u_pe_array.g_pe_row\[3\].g_pe_col\[3\].u_pe.psum_out\[8\] _0988_ VGND VGND
+ VPWR VPWR _1070_ sky130_fd_sc_hd__nand2_1
XFILLER_0_6_141 VPWR VGND VPWR VGND sky130_ef_sc_hd__decap_12
X_6537_ _3154_ _3157_ _3165_ VGND VGND VPWR VPWR _3166_ sky130_fd_sc_hd__or3_1
XFILLER_0_7_697 VGND VGND VPWR VPWR sky130_fd_sc_hd__decap_4
X_4798_ u_pe_array.g_pe_row\[2\].g_pe_col\[2\].u_pe.psum_out\[7\] _0933_ VGND VGND
+ VPWR VPWR _1820_ sky130_fd_sc_hd__nand2_1
XFILLER_0_70_570 VPWR VGND VPWR VGND sky130_ef_sc_hd__decap_12
X_3749_ _1002_ _1004_ net464 _1006_ VGND VGND VPWR VPWR _0045_ sky130_fd_sc_hd__a2bb2o_1
XFILLER_0_42_250 VGND VGND VPWR VPWR sky130_fd_sc_hd__fill_2
XFILLER_0_42_261 VGND VGND VPWR VPWR sky130_fd_sc_hd__decap_4
XFILLER_0_113_661 VGND VGND VPWR VPWR sky130_fd_sc_hd__decap_8
X_6468_ net398 _3101_ _2987_ _3115_ VGND VGND VPWR VPWR _0655_ sky130_fd_sc_hd__a22o_1
XFILLER_0_42_294 VGND VGND VPWR VPWR sky130_fd_sc_hd__decap_3
X_5419_ _2301_ VGND VGND VPWR VPWR _0420_ sky130_fd_sc_hd__clkbuf_1
X_6399_ _3048_ _3058_ u_pe_array.g_pe_row\[0\].g_pe_col\[2\].u_pe.psum_out\[7\] _3044_
+ VGND VGND VPWR VPWR _3066_ sky130_fd_sc_hd__o2bb2a_1
XFILLER_0_100_355 VGND VGND VPWR VPWR sky130_fd_sc_hd__fill_1
XFILLER_0_97_478 VGND VGND VPWR VPWR sky130_fd_sc_hd__decap_6
XFILLER_0_97_456 VGND VGND VPWR VPWR sky130_fd_sc_hd__decap_6
XFILLER_0_97_445 VGND VGND VPWR VPWR sky130_fd_sc_hd__decap_3
Xmax_cap67 _2177_ VGND VGND VPWR VPWR net67 sky130_fd_sc_hd__buf_1
XFILLER_0_85_629 VPWR VGND VPWR VGND sky130_ef_sc_hd__decap_12
XFILLER_0_93_673 VPWR VGND VPWR VGND sky130_ef_sc_hd__decap_12
XFILLER_0_80_301 VGND VGND VPWR VPWR sky130_fd_sc_hd__decap_6
XFILLER_0_65_353 VGND VGND VPWR VPWR sky130_fd_sc_hd__decap_3
XFILLER_0_53_515 VPWR VGND VPWR VGND sky130_ef_sc_hd__decap_12
XFILLER_0_108_477 VGND VGND VPWR VPWR sky130_fd_sc_hd__fill_2
XFILLER_0_68_29 VGND VGND VPWR VPWR sky130_fd_sc_hd__decap_4
XTAP_607 VGND VPWR sky130_fd_sc_hd__tapvpwrvgnd_1
XTAP_618 VGND VPWR sky130_fd_sc_hd__tapvpwrvgnd_1
XTAP_629 VGND VPWR sky130_fd_sc_hd__tapvpwrvgnd_1
XFILLER_0_17_55 VGND VGND VPWR VPWR sky130_fd_sc_hd__fill_1
XFILLER_0_88_467 VGND VGND VPWR VPWR sky130_fd_sc_hd__fill_1
XFILLER_0_48_309 VPWR VGND VPWR VGND sky130_ef_sc_hd__decap_12
XFILLER_0_33_43 VPWR VGND VPWR VGND sky130_ef_sc_hd__decap_12
X_5770_ _2571_ _2572_ _2574_ VGND VGND VPWR VPWR _2575_ sky130_fd_sc_hd__a21oi_1
XFILLER_0_75_139 VGND VGND VPWR VPWR sky130_fd_sc_hd__decap_3
XFILLER_0_68_191 VGND VGND VPWR VPWR sky130_fd_sc_hd__decap_4
XTAP_1390 VGND VPWR sky130_fd_sc_hd__tapvpwrvgnd_1
XFILLER_0_84_673 VPWR VGND VPWR VGND sky130_ef_sc_hd__decap_12
XFILLER_0_84_651 VGND VGND VPWR VPWR sky130_fd_sc_hd__fill_2
X_4721_ net93 _1750_ _1483_ u_pe_array.g_pe_row\[2\].g_pe_col\[2\].u_pe.move_reg\[12\]
+ VGND VGND VPWR VPWR _0273_ sky130_fd_sc_hd__a22o_1
X_7440_ clknet_leaf_34_clk net485 net71 VGND VGND VPWR VPWR u_pe_array.g_pe_row\[2\].g_pe_col\[0\].u_pe.act_val\[3\]
+ sky130_fd_sc_hd__dfrtp_2
XFILLER_0_4_601 VPWR VGND VPWR VGND sky130_ef_sc_hd__decap_12
X_4652_ _1710_ _1711_ VGND VGND VPWR VPWR _1712_ sky130_fd_sc_hd__and2_1
Xinput30 w_in_flat[3] VGND VGND VPWR VPWR net30 sky130_fd_sc_hd__clkbuf_1
XFILLER_0_71_345 VGND VGND VPWR VPWR sky130_fd_sc_hd__fill_1
XFILLER_0_3_111 VGND VGND VPWR VPWR sky130_fd_sc_hd__fill_1
X_3603_ net507 _0899_ _0901_ VGND VGND VPWR VPWR _0004_ sky130_fd_sc_hd__o21a_1
Xhold803 u_pe_array.g_pe_row\[3\].g_pe_col\[1\].u_pe.psum_out\[8\] VGND VGND VPWR
+ VPWR net877 sky130_fd_sc_hd__dlygate4sd3_1
XFILLER_0_4_645 VPWR VGND VPWR VGND sky130_ef_sc_hd__decap_12
X_7371_ clknet_leaf_104_clk _0277_ net944 VGND VGND VPWR VPWR u_pe_array.g_pe_row\[2\].g_pe_col\[2\].u_pe.psum_out\[3\]
+ sky130_fd_sc_hd__dfrtp_1
X_4583_ _1648_ _1427_ u_pe_array.g_pe_row\[2\].g_pe_col\[3\].u_pe.psum_out\[4\] VGND
+ VGND VPWR VPWR _1649_ sky130_fd_sc_hd__a21oi_1
Xhold836 u_pe_array.act_from_right\[5\]\[3\] VGND VGND VPWR VPWR net910 sky130_fd_sc_hd__dlygate4sd3_1
Xhold825 u_pe_array.g_pe_row\[3\].g_pe_col\[2\].u_pe.psum_out\[9\] VGND VGND VPWR
+ VPWR net899 sky130_fd_sc_hd__dlygate4sd3_1
X_6322_ _2795_ _2994_ _2995_ _2621_ net732 VGND VGND VPWR VPWR _0629_ sky130_fd_sc_hd__a32o_1
Xhold814 u_pe_array.g_pe_row\[2\].g_pe_col\[3\].u_pe.psum_out\[10\] VGND VGND VPWR
+ VPWR net888 sky130_fd_sc_hd__dlygate4sd3_1
XFILLER_0_110_631 VPWR VGND VPWR VGND sky130_ef_sc_hd__decap_12
Xhold858 u_pe_array.g_pe_row\[1\].g_pe_col\[1\].u_pe.psum_out\[10\] VGND VGND VPWR
+ VPWR net932 sky130_fd_sc_hd__dlygate4sd3_1
X_6253_ _2947_ _2957_ _2958_ VGND VGND VPWR VPWR _2959_ sky130_fd_sc_hd__a21oi_1
Xhold847 u_pe_array.g_pe_row\[3\].g_pe_col\[2\].u_pe.psum_out\[5\] VGND VGND VPWR
+ VPWR net921 sky130_fd_sc_hd__dlygate4sd3_1
X_5204_ u_pe_array.g_pe_row\[1\].g_pe_col\[3\].u_pe.psum_out\[1\] u_pe_array.g_pe_row\[1\].g_pe_col\[3\].u_pe.act_val\[1\]
+ _2133_ VGND VGND VPWR VPWR _2135_ sky130_fd_sc_hd__mux2_1
X_6184_ u_pe_array.g_pe_row\[0\].g_pe_col\[3\].u_pe.psum_out\[4\] _2895_ VGND VGND
+ VPWR VPWR _2896_ sky130_fd_sc_hd__xnor2_1
X_5135_ u_pe_array.g_pe_row\[2\].g_pe_col\[0\].u_pe.act_val\[4\] _2075_ _2065_ _2063_
+ VGND VGND VPWR VPWR _2076_ sky130_fd_sc_hd__o22ai_1
XFILLER_0_35_3 VPWR VGND VPWR VGND sky130_ef_sc_hd__decap_12
X_5066_ u_pe_array.act_from_right\[8\]\[10\] _1750_ _1883_ net195 VGND VGND VPWR VPWR
+ _0353_ sky130_fd_sc_hd__a22o_1
X_4017_ u_pe_array.g_pe_row\[3\].g_pe_col\[2\].u_pe.act_val\[4\] u_pe_array.g_pe_row\[3\].g_pe_col\[2\].u_pe.w_out\[0\]
+ _1209_ VGND VGND VPWR VPWR _1218_ sky130_fd_sc_hd__and3_1
XFILLER_0_67_629 VPWR VGND VPWR VGND sky130_ef_sc_hd__decap_12
XFILLER_0_109_208 VGND VGND VPWR VPWR sky130_fd_sc_hd__fill_2
XFILLER_0_94_437 VGND VGND VPWR VPWR sky130_fd_sc_hd__fill_1
X_5968_ _0866_ VGND VGND VPWR VPWR _2730_ sky130_fd_sc_hd__clkbuf_8
XFILLER_0_66_128 VGND VGND VPWR VPWR sky130_fd_sc_hd__decap_6
XFILLER_0_90_93 VGND VGND VPWR VPWR sky130_fd_sc_hd__decap_8
XFILLER_0_75_673 VGND VGND VPWR VPWR sky130_fd_sc_hd__fill_1
X_7707_ clknet_leaf_73_clk _0613_ net72 VGND VGND VPWR VPWR u_pe_array.act_from_up\[6\]\[11\]
+ sky130_fd_sc_hd__dfrtp_1
X_4919_ _0985_ VGND VGND VPWR VPWR _1904_ sky130_fd_sc_hd__buf_8
X_5899_ net141 _1159_ _2652_ _1476_ VGND VGND VPWR VPWR _0527_ sky130_fd_sc_hd__a22o_1
XFILLER_0_105_425 VGND VGND VPWR VPWR sky130_fd_sc_hd__decap_6
X_7638_ clknet_leaf_65_clk net209 net946 VGND VGND VPWR VPWR u_pe_array.g_pe_row\[1\].g_pe_col\[0\].u_pe.move_reg\[11\]
+ sky130_fd_sc_hd__dfrtp_1
XFILLER_0_35_559 VGND VGND VPWR VPWR sky130_fd_sc_hd__fill_1
XFILLER_0_105_447 VGND VGND VPWR VPWR sky130_fd_sc_hd__fill_1
X_7569_ clknet_leaf_44_clk _0475_ net947 VGND VGND VPWR VPWR u_pe_array.act_from_down\[1\]\[9\]
+ sky130_fd_sc_hd__dfrtp_1
XFILLER_0_15_272 VGND VGND VPWR VPWR sky130_fd_sc_hd__decap_8
XFILLER_0_100_141 VGND VGND VPWR VPWR sky130_fd_sc_hd__decap_4
XFILLER_0_30_286 VGND VGND VPWR VPWR sky130_fd_sc_hd__decap_3
XFILLER_0_101_697 VGND VGND VPWR VPWR sky130_fd_sc_hd__decap_8
XFILLER_0_97_253 VGND VGND VPWR VPWR sky130_fd_sc_hd__decap_8
XFILLER_0_53_323 VGND VGND VPWR VPWR sky130_fd_sc_hd__decap_4
XFILLER_0_53_378 VPWR VGND VPWR VGND sky130_ef_sc_hd__decap_12
XFILLER_0_80_197 VGND VGND VPWR VPWR sky130_fd_sc_hd__fill_1
XFILLER_0_1_615 VGND VGND VPWR VPWR sky130_fd_sc_hd__fill_1
XFILLER_0_0_125 VGND VGND VPWR VPWR sky130_fd_sc_hd__fill_2
XFILLER_0_21_242 VGND VGND VPWR VPWR sky130_fd_sc_hd__fill_2
XTAP_415 VGND VPWR sky130_fd_sc_hd__tapvpwrvgnd_1
XTAP_404 VGND VPWR sky130_fd_sc_hd__tapvpwrvgnd_1
XFILLER_0_0_169 VGND VGND VPWR VPWR sky130_fd_sc_hd__fill_2
XTAP_426 VGND VPWR sky130_fd_sc_hd__tapvpwrvgnd_1
XTAP_437 VGND VPWR sky130_fd_sc_hd__tapvpwrvgnd_1
XTAP_448 VGND VPWR sky130_fd_sc_hd__tapvpwrvgnd_1
XTAP_459 VGND VPWR sky130_fd_sc_hd__tapvpwrvgnd_1
XFILLER_0_28_76 VGND VGND VPWR VPWR sky130_fd_sc_hd__decap_8
X_6940_ _3453_ VGND VGND VPWR VPWR _0789_ sky130_fd_sc_hd__clkbuf_1
XFILLER_0_76_404 VGND VGND VPWR VPWR sky130_fd_sc_hd__fill_2
X_6871_ u_pe_array.u_fifo2.wr_ptr\[0\] u_pe_array.u_fifo2.wr_ptr\[1\] _3391_ VGND
+ VGND VPWR VPWR _3415_ sky130_fd_sc_hd__and3_2
XFILLER_0_44_75 VGND VGND VPWR VPWR sky130_fd_sc_hd__decap_3
X_5822_ _2233_ _2619_ _2620_ _2621_ net668 VGND VGND VPWR VPWR _0503_ sky130_fd_sc_hd__a32o_1
X_5753_ u_pe_array.g_pe_row\[1\].g_pe_col\[1\].u_pe.act_val\[4\] u_pe_array.g_pe_row\[1\].g_pe_col\[1\].u_pe.w_out\[0\]
+ _2545_ VGND VGND VPWR VPWR _2559_ sky130_fd_sc_hd__and3_1
XFILLER_0_57_673 VGND VGND VPWR VPWR sky130_fd_sc_hd__decap_4
XFILLER_0_57_651 VGND VGND VPWR VPWR sky130_fd_sc_hd__decap_3
XFILLER_0_17_526 VGND VGND VPWR VPWR sky130_fd_sc_hd__decap_3
X_4704_ net89 _1732_ _1735_ _1747_ VGND VGND VPWR VPWR _0259_ sky130_fd_sc_hd__a22o_1
X_5684_ net870 _2499_ _2491_ _2506_ VGND VGND VPWR VPWR _0480_ sky130_fd_sc_hd__a22o_1
XFILLER_0_60_85 VGND VGND VPWR VPWR sky130_fd_sc_hd__decap_8
XFILLER_0_114_244 VGND VGND VPWR VPWR sky130_fd_sc_hd__decap_8
X_7423_ clknet_leaf_64_clk _0329_ net946 VGND VGND VPWR VPWR u_pe_array.g_pe_row\[1\].g_pe_col\[3\].u_pe.w_out\[1\]
+ sky130_fd_sc_hd__dfrtp_1
XFILLER_0_72_698 VGND VGND VPWR VPWR sky130_fd_sc_hd__fill_2
XFILLER_0_71_164 VGND VGND VPWR VPWR sky130_fd_sc_hd__decap_4
X_4635_ _1695_ _1696_ VGND VGND VPWR VPWR _1697_ sky130_fd_sc_hd__nand2_1
XFILLER_0_8_53 VPWR VGND VPWR VGND sky130_ef_sc_hd__decap_12
XFILLER_0_4_453 VGND VGND VPWR VPWR sky130_fd_sc_hd__fill_2
Xhold611 u_pe_array.u_fifo1.buffer\[4\]\[4\] VGND VGND VPWR VPWR net685 sky130_fd_sc_hd__dlygate4sd3_1
Xhold600 u_pe_array.u_fifo2.buffer\[7\]\[4\] VGND VGND VPWR VPWR net674 sky130_fd_sc_hd__dlygate4sd3_1
X_4566_ u_pe_array.g_pe_row\[2\].g_pe_col\[3\].u_pe.act_val\[2\] _1424_ _1625_ VGND
+ VGND VPWR VPWR _1633_ sky130_fd_sc_hd__and3_1
X_7354_ clknet_leaf_8_clk net450 net950 VGND VGND VPWR VPWR u_pe_array.act_from_up\[14\]\[12\]
+ sky130_fd_sc_hd__dfrtp_1
Xhold622 u_pe_array.g_pe_row\[1\].g_pe_col\[3\].u_pe.psum_out\[7\] VGND VGND VPWR
+ VPWR net696 sky130_fd_sc_hd__dlygate4sd3_1
X_6305_ u_pe_array.g_pe_row\[0\].g_pe_col\[2\].u_pe.act_val\[5\] _2853_ _2987_ net238
+ VGND VGND VPWR VPWR _0620_ sky130_fd_sc_hd__a22o_1
XFILLER_0_8_97 VPWR VGND VPWR VGND sky130_ef_sc_hd__decap_12
Xhold633 u_pe_array.u_fifo1.buffer\[1\]\[5\] VGND VGND VPWR VPWR net707 sky130_fd_sc_hd__dlygate4sd3_1
Xhold644 _0438_ VGND VGND VPWR VPWR net718 sky130_fd_sc_hd__dlygate4sd3_1
Xhold688 u_pe_array.g_pe_row\[1\].g_pe_col\[3\].u_pe.psum_out\[10\] VGND VGND VPWR
+ VPWR net762 sky130_fd_sc_hd__dlygate4sd3_1
X_7285_ clknet_leaf_13_clk net358 net942 VGND VGND VPWR VPWR u_pe_array.g_pe_row\[3\].g_pe_col\[0\].u_pe.move_reg\[12\]
+ sky130_fd_sc_hd__dfrtp_1
Xhold666 u_pe_array.u_fifo2.buffer\[6\]\[4\] VGND VGND VPWR VPWR net740 sky130_fd_sc_hd__dlygate4sd3_1
Xhold655 u_pe_array.u_fifo1.buffer\[1\]\[3\] VGND VGND VPWR VPWR net729 sky130_fd_sc_hd__dlygate4sd3_1
X_4497_ u_pe_array.g_pe_row\[1\].g_pe_col\[2\].u_pe.w_out\[0\] VGND VGND VPWR VPWR
+ _1595_ sky130_fd_sc_hd__clkbuf_4
Xhold677 u_pe_array.g_pe_row\[0\].g_pe_col\[2\].u_pe.psum_out\[11\] VGND VGND VPWR
+ VPWR net751 sky130_fd_sc_hd__dlygate4sd3_1
XFILLER_0_110_461 VGND VGND VPWR VPWR sky130_fd_sc_hd__fill_1
X_6236_ _2936_ _2938_ _2943_ VGND VGND VPWR VPWR _2944_ sky130_fd_sc_hd__or3_1
Xhold699 u_pe_array.act_from_up\[12\]\[5\] VGND VGND VPWR VPWR net773 sky130_fd_sc_hd__dlygate4sd3_1
X_6167_ _2870_ _2876_ _2879_ VGND VGND VPWR VPWR _2880_ sky130_fd_sc_hd__a21o_1
XTAP_971 VGND VPWR sky130_fd_sc_hd__tapvpwrvgnd_1
XTAP_960 VGND VPWR sky130_fd_sc_hd__tapvpwrvgnd_1
X_5118_ _2058_ _2059_ VGND VGND VPWR VPWR _2061_ sky130_fd_sc_hd__nand2_1
XTAP_993 VGND VPWR sky130_fd_sc_hd__tapvpwrvgnd_1
XTAP_982 VGND VPWR sky130_fd_sc_hd__tapvpwrvgnd_1
X_6098_ net31 _2128_ _0931_ VGND VGND VPWR VPWR _2842_ sky130_fd_sc_hd__mux2_1
XFILLER_0_79_242 VGND VGND VPWR VPWR sky130_fd_sc_hd__decap_8
X_5049_ net504 _2006_ _2009_ _2012_ VGND VGND VPWR VPWR _0339_ sky130_fd_sc_hd__a22o_1
XFILLER_0_75_470 VGND VGND VPWR VPWR sky130_fd_sc_hd__fill_2
XFILLER_0_47_172 VGND VGND VPWR VPWR sky130_fd_sc_hd__decap_4
XFILLER_0_118_583 VGND VGND VPWR VPWR sky130_fd_sc_hd__decap_4
XFILLER_0_118_561 VGND VGND VPWR VPWR sky130_fd_sc_hd__decap_6
XFILLER_0_106_701 VGND VGND VPWR VPWR sky130_fd_sc_hd__decap_4
XFILLER_0_105_222 VGND VGND VPWR VPWR sky130_fd_sc_hd__fill_2
XFILLER_0_90_473 VGND VGND VPWR VPWR sky130_fd_sc_hd__decap_3
XFILLER_0_62_175 VGND VGND VPWR VPWR sky130_fd_sc_hd__decap_4
XFILLER_0_105_69 VPWR VGND VPWR VGND sky130_ef_sc_hd__decap_12
XFILLER_0_39_640 VPWR VGND VPWR VGND sky130_ef_sc_hd__decap_12
XFILLER_0_39_662 VGND VGND VPWR VPWR sky130_fd_sc_hd__decap_6
XFILLER_0_109_550 VGND VGND VPWR VPWR sky130_fd_sc_hd__decap_8
XFILLER_0_85_289 VGND VGND VPWR VPWR sky130_fd_sc_hd__fill_1
XFILLER_0_26_301 VGND VGND VPWR VPWR sky130_fd_sc_hd__decap_6
XFILLER_0_109_561 VPWR VGND VPWR VGND sky130_ef_sc_hd__decap_12
XFILLER_0_81_440 VGND VGND VPWR VPWR sky130_fd_sc_hd__decap_8
XFILLER_0_54_643 VGND VGND VPWR VPWR sky130_fd_sc_hd__fill_1
XFILLER_0_5_217 VGND VGND VPWR VPWR sky130_fd_sc_hd__decap_6
XFILLER_0_26_356 VGND VGND VPWR VPWR sky130_fd_sc_hd__decap_8
XFILLER_0_53_120 VGND VGND VPWR VPWR sky130_fd_sc_hd__fill_1
XFILLER_0_54_676 VPWR VGND VPWR VGND sky130_ef_sc_hd__decap_12
XFILLER_0_30_33 VGND VGND VPWR VPWR sky130_fd_sc_hd__decap_4
X_4420_ _1525_ _1526_ net898 _1006_ VGND VGND VPWR VPWR _0196_ sky130_fd_sc_hd__a2bb2o_1
X_4351_ net145 _1166_ _1465_ _1476_ VGND VGND VPWR VPWR _0177_ sky130_fd_sc_hd__a22o_1
X_4282_ _1431_ VGND VGND VPWR VPWR _0153_ sky130_fd_sc_hd__clkbuf_1
X_7070_ net576 _3356_ _3529_ VGND VGND VPWR VPWR _3532_ sky130_fd_sc_hd__mux2_1
XTAP_245 VGND VPWR sky130_fd_sc_hd__tapvpwrvgnd_1
XTAP_256 VGND VPWR sky130_fd_sc_hd__tapvpwrvgnd_1
X_6021_ u_pe_array.g_pe_row\[1\].g_pe_col\[0\].u_pe.act_val\[4\] _1865_ VGND VGND
+ VPWR VPWR _2773_ sky130_fd_sc_hd__and2b_1
XTAP_267 VGND VPWR sky130_fd_sc_hd__tapvpwrvgnd_1
XTAP_278 VGND VPWR sky130_fd_sc_hd__tapvpwrvgnd_1
XTAP_289 VGND VPWR sky130_fd_sc_hd__tapvpwrvgnd_1
XFILLER_0_55_41 VGND VGND VPWR VPWR sky130_fd_sc_hd__fill_1
XFILLER_0_77_702 VGND VGND VPWR VPWR sky130_fd_sc_hd__decap_3
X_6923_ _3444_ VGND VGND VPWR VPWR _0781_ sky130_fd_sc_hd__clkbuf_1
XFILLER_0_49_426 VGND VGND VPWR VPWR sky130_fd_sc_hd__decap_4
XFILLER_0_71_73 VGND VGND VPWR VPWR sky130_fd_sc_hd__fill_1
X_6854_ _3405_ VGND VGND VPWR VPWR _0751_ sky130_fd_sc_hd__clkbuf_1
X_5805_ u_pe_array.g_pe_row\[1\].g_pe_col\[1\].u_pe.psum_out\[7\] u_pe_array.g_pe_row\[1\].g_pe_col\[1\].u_pe.psum_out\[8\]
+ _1728_ VGND VGND VPWR VPWR _2606_ sky130_fd_sc_hd__o21a_1
XFILLER_0_9_545 VGND VGND VPWR VPWR sky130_fd_sc_hd__decap_4
X_3997_ _1192_ _1193_ _1198_ VGND VGND VPWR VPWR _1200_ sky130_fd_sc_hd__o21ai_1
X_6785_ _3360_ net788 _3352_ VGND VGND VPWR VPWR _3361_ sky130_fd_sc_hd__mux2_1
XFILLER_0_29_161 VGND VGND VPWR VPWR sky130_fd_sc_hd__decap_6
X_5736_ net559 _1904_ _2543_ _0978_ VGND VGND VPWR VPWR _0495_ sky130_fd_sc_hd__a22o_1
X_5667_ net305 _2143_ _2491_ _2497_ VGND VGND VPWR VPWR _0472_ sky130_fd_sc_hd__a22o_1
X_7406_ clknet_leaf_35_clk net386 net951 VGND VGND VPWR VPWR u_pe_array.g_pe_row\[2\].g_pe_col\[1\].u_pe.move_reg\[10\]
+ sky130_fd_sc_hd__dfrtp_1
X_4618_ _1676_ _1679_ _1675_ VGND VGND VPWR VPWR _1681_ sky130_fd_sc_hd__a21oi_1
X_5598_ u_pe_array.g_pe_row\[1\].g_pe_col\[2\].u_pe.psum_out\[7\] _1597_ VGND VGND
+ VPWR VPWR _2443_ sky130_fd_sc_hd__nand2_1
XFILLER_0_102_247 VGND VGND VPWR VPWR sky130_fd_sc_hd__decap_4
Xhold452 u_pe_array.act_from_down\[3\]\[5\] VGND VGND VPWR VPWR net526 sky130_fd_sc_hd__buf_1
Xhold430 u_pe_array.act_from_up\[12\]\[9\] VGND VGND VPWR VPWR net504 sky130_fd_sc_hd__dlygate4sd3_1
Xhold441 u_pe_array.g_pe_row\[1\].g_pe_col\[3\].u_pe.psum_out\[0\] VGND VGND VPWR
+ VPWR net515 sky130_fd_sc_hd__dlygate4sd3_1
XFILLER_0_13_573 VGND VGND VPWR VPWR sky130_fd_sc_hd__fill_2
Xhold463 u_pe_array.g_pe_row\[3\].g_pe_col\[2\].u_pe.psum_out\[4\] VGND VGND VPWR
+ VPWR net537 sky130_fd_sc_hd__dlygate4sd3_1
X_4549_ u_pe_array.g_pe_row\[2\].g_pe_col\[3\].u_pe.act_val\[0\] u_pe_array.g_pe_row\[2\].g_pe_col\[3\].u_pe.psum_out\[1\]
+ _1427_ VGND VGND VPWR VPWR _1618_ sky130_fd_sc_hd__and3_1
X_7337_ clknet_leaf_3_clk _0243_ net945 VGND VGND VPWR VPWR u_pe_array.g_pe_row\[2\].g_pe_col\[3\].u_pe.psum_out\[10\]
+ sky130_fd_sc_hd__dfrtp_2
Xhold485 u_pe_array.g_pe_row\[1\].g_pe_col\[1\].u_pe.psum_out\[3\] VGND VGND VPWR
+ VPWR net559 sky130_fd_sc_hd__dlygate4sd3_1
X_7268_ clknet_leaf_12_clk _0174_ net942 VGND VGND VPWR VPWR u_pe_array.act_from_left\[13\]\[8\]
+ sky130_fd_sc_hd__dfrtp_1
Xhold496 u_pe_array.g_pe_row\[3\].g_pe_col\[2\].u_pe.psum_out\[0\] VGND VGND VPWR
+ VPWR net570 sky130_fd_sc_hd__dlygate4sd3_1
Xhold474 u_pe_array.u_fifo1.buffer\[0\]\[1\] VGND VGND VPWR VPWR net548 sky130_fd_sc_hd__dlygate4sd3_1
XFILLER_0_96_81 VGND VGND VPWR VPWR sky130_fd_sc_hd__decap_3
X_6219_ u_pe_array.g_pe_row\[0\].g_pe_col\[3\].u_pe.psum_out\[7\] _1999_ VGND VGND
+ VPWR VPWR _2928_ sky130_fd_sc_hd__nand2_1
X_7199_ clknet_leaf_97_clk _0105_ net950 VGND VGND VPWR VPWR u_pe_array.g_pe_row\[3\].g_pe_col\[2\].u_pe.psum_out\[8\]
+ sky130_fd_sc_hd__dfrtp_4
XFILLER_0_99_337 VGND VGND VPWR VPWR sky130_fd_sc_hd__fill_1
XTAP_790 VGND VPWR sky130_fd_sc_hd__tapvpwrvgnd_1
XFILLER_0_95_521 VGND VGND VPWR VPWR sky130_fd_sc_hd__fill_1
XFILLER_0_36_610 VGND VGND VPWR VPWR sky130_fd_sc_hd__decap_8
XFILLER_0_35_164 VGND VGND VPWR VPWR sky130_fd_sc_hd__decap_4
XFILLER_0_63_484 VGND VGND VPWR VPWR sky130_fd_sc_hd__fill_1
XFILLER_0_2_209 VPWR VGND VPWR VGND sky130_ef_sc_hd__decap_12
XFILLER_0_23_337 VGND VGND VPWR VPWR sky130_fd_sc_hd__decap_4
XFILLER_0_51_668 VGND VGND VPWR VPWR sky130_fd_sc_hd__decap_4
XFILLER_0_59_702 VGND VGND VPWR VPWR sky130_fd_sc_hd__decap_3
XFILLER_0_25_55 VGND VGND VPWR VPWR sky130_fd_sc_hd__fill_1
X_3920_ net939 _1153_ _1116_ VGND VGND VPWR VPWR _1154_ sky130_fd_sc_hd__mux2_1
X_3851_ _1033_ _1098_ _1099_ _0986_ net646 VGND VGND VPWR VPWR _0054_ sky130_fd_sc_hd__a32o_1
XFILLER_0_46_418 VGND VGND VPWR VPWR sky130_fd_sc_hd__fill_2
X_6570_ u_pe_array.g_pe_row\[0\].g_pe_col\[1\].u_pe.psum_out\[8\] _2268_ VGND VGND
+ VPWR VPWR _3196_ sky130_fd_sc_hd__or2_1
X_3782_ u_pe_array.g_pe_row\[3\].g_pe_col\[3\].u_pe.psum_out\[5\] _1036_ VGND VGND
+ VPWR VPWR _1037_ sky130_fd_sc_hd__xnor2_2
XFILLER_0_41_65 VGND VGND VPWR VPWR sky130_fd_sc_hd__fill_2
X_5521_ net185 _2016_ _1883_ u_pe_array.g_pe_row\[1\].g_pe_col\[2\].u_pe.move_reg\[7\]
+ VGND VGND VPWR VPWR _0445_ sky130_fd_sc_hd__a22o_1
XFILLER_0_81_281 VGND VGND VPWR VPWR sky130_fd_sc_hd__decap_3
X_5452_ net140 _1159_ _2306_ _1476_ VGND VGND VPWR VPWR _0435_ sky130_fd_sc_hd__a22o_1
XFILLER_0_112_545 VGND VGND VPWR VPWR sky130_fd_sc_hd__decap_4
X_4403_ u_pe_array.g_pe_row\[3\].g_pe_col\[0\].u_pe.psum_out\[2\] _1499_ _1510_ VGND
+ VGND VPWR VPWR _1511_ sky130_fd_sc_hd__a21oi_1
X_5383_ net758 _2272_ _2273_ VGND VGND VPWR VPWR _2274_ sky130_fd_sc_hd__mux2_1
XFILLER_0_112_589 VGND VGND VPWR VPWR sky130_fd_sc_hd__decap_8
X_7122_ clknet_leaf_18_clk net440 net943 VGND VGND VPWR VPWR u_pe_array.act_from_down\[11\]\[11\]
+ sky130_fd_sc_hd__dfrtp_1
X_4334_ _1470_ VGND VGND VPWR VPWR _0166_ sky130_fd_sc_hd__clkbuf_1
XFILLER_0_10_587 VGND VGND VPWR VPWR sky130_fd_sc_hd__fill_1
X_7053_ _3522_ VGND VGND VPWR VPWR _0833_ sky130_fd_sc_hd__clkbuf_1
X_4265_ net704 _1273_ _1418_ _1021_ VGND VGND VPWR VPWR _0149_ sky130_fd_sc_hd__a22o_1
X_6004_ _2755_ _2757_ VGND VGND VPWR VPWR _2758_ sky130_fd_sc_hd__nor2_1
X_4196_ _1033_ _1354_ _1355_ _1356_ net423 VGND VGND VPWR VPWR _0142_ sky130_fd_sc_hd__a32o_1
XFILLER_0_82_61 VGND VGND VPWR VPWR sky130_fd_sc_hd__fill_1
XTAP_1219 VGND VPWR sky130_fd_sc_hd__tapvpwrvgnd_1
XTAP_1208 VGND VPWR sky130_fd_sc_hd__tapvpwrvgnd_1
X_6906_ _0924_ net706 _3431_ VGND VGND VPWR VPWR _3435_ sky130_fd_sc_hd__mux2_1
X_7886_ clknet_leaf_80_clk _0791_ net13 VGND VGND VPWR VPWR u_pe_array.u_fifo1.wr_ptr\[0\]
+ sky130_fd_sc_hd__dfrtp_4
XFILLER_0_18_610 VGND VGND VPWR VPWR sky130_fd_sc_hd__decap_8
X_6837_ net563 _0924_ _3392_ VGND VGND VPWR VPWR _3396_ sky130_fd_sc_hd__mux2_1
XFILLER_0_37_418 VGND VGND VPWR VPWR sky130_fd_sc_hd__fill_1
XFILLER_0_64_259 VGND VGND VPWR VPWR sky130_fd_sc_hd__fill_1
XFILLER_0_17_120 VPWR VGND VPWR VGND sky130_ef_sc_hd__decap_12
X_6768_ u_pe_array.u_fifo1.count\[0\] u_pe_array.u_fifo1.count\[3\] VGND VGND VPWR
+ VPWR _3348_ sky130_fd_sc_hd__nand2_1
X_5719_ _2523_ _2527_ VGND VGND VPWR VPWR _2528_ sky130_fd_sc_hd__xor2_1
X_6699_ u_pe_array.g_pe_row\[0\].g_pe_col\[0\].u_pe.act_val\[4\] _3246_ _3285_ _3286_
+ VGND VGND VPWR VPWR _3287_ sky130_fd_sc_hd__or4_2
XFILLER_0_60_421 VGND VGND VPWR VPWR sky130_fd_sc_hd__decap_3
XFILLER_0_18_698 VGND VGND VPWR VPWR sky130_fd_sc_hd__fill_2
Xhold271 _0618_ VGND VGND VPWR VPWR net345 sky130_fd_sc_hd__dlygate4sd3_1
Xhold260 _0261_ VGND VGND VPWR VPWR net334 sky130_fd_sc_hd__dlygate4sd3_1
Xhold293 _0664_ VGND VGND VPWR VPWR net367 sky130_fd_sc_hd__dlygate4sd3_1
Xhold282 _0303_ VGND VGND VPWR VPWR net356 sky130_fd_sc_hd__dlygate4sd3_1
XFILLER_0_99_101 VGND VGND VPWR VPWR sky130_fd_sc_hd__decap_3
XFILLER_0_68_510 VGND VGND VPWR VPWR sky130_fd_sc_hd__decap_3
XTAP_1742 VGND VPWR sky130_fd_sc_hd__tapvpwrvgnd_1
XTAP_1731 VGND VPWR sky130_fd_sc_hd__tapvpwrvgnd_1
XTAP_1720 VGND VPWR sky130_fd_sc_hd__tapvpwrvgnd_1
XFILLER_0_28_418 VGND VGND VPWR VPWR sky130_fd_sc_hd__fill_2
XFILLER_0_102_15 VPWR VGND VPWR VGND sky130_ef_sc_hd__decap_12
XFILLER_0_91_590 VPWR VGND VPWR VGND sky130_ef_sc_hd__decap_12
XFILLER_0_63_281 VGND VGND VPWR VPWR sky130_fd_sc_hd__fill_1
XFILLER_0_11_57 VPWR VGND VPWR VGND sky130_ef_sc_hd__decap_12
XFILLER_0_3_529 VPWR VGND VPWR VGND sky130_ef_sc_hd__decap_12
XFILLER_0_24_668 VGND VGND VPWR VPWR sky130_fd_sc_hd__decap_8
XFILLER_0_87_39 VGND VGND VPWR VPWR sky130_fd_sc_hd__fill_1
XFILLER_0_23_189 VGND VGND VPWR VPWR sky130_fd_sc_hd__decap_8
X_4050_ _1214_ _1215_ _1247_ VGND VGND VPWR VPWR _1248_ sky130_fd_sc_hd__or3_1
Xinput6 h_in0[5] VGND VGND VPWR VPWR net6 sky130_fd_sc_hd__clkbuf_2
X_7740_ clknet_leaf_53_clk _0646_ net74 VGND VGND VPWR VPWR u_pe_array.act_from_right\[0\]\[3\]
+ sky130_fd_sc_hd__dfrtp_1
X_4952_ _1932_ _1934_ VGND VGND VPWR VPWR _1935_ sky130_fd_sc_hd__xor2_1
X_4883_ u_pe_array.g_pe_row\[2\].g_pe_col\[1\].u_pe.act_val\[2\] _1749_ _1873_ net378
+ VGND VGND VPWR VPWR _0304_ sky130_fd_sc_hd__a22o_1
X_7671_ clknet_leaf_59_clk net426 net74 VGND VGND VPWR VPWR u_pe_array.g_pe_row\[0\].g_pe_col\[3\].u_pe.act_val\[3\]
+ sky130_fd_sc_hd__dfrtp_1
X_3903_ u_pe_array.g_pe_row\[3\].g_pe_col\[2\].u_pe.psum_out\[7\] _1112_ _1109_ _1140_
+ VGND VGND VPWR VPWR _1141_ sky130_fd_sc_hd__o211a_1
XFILLER_0_46_215 VGND VGND VPWR VPWR sky130_fd_sc_hd__fill_2
X_3834_ u_pe_array.g_pe_row\[3\].g_pe_col\[3\].u_pe.psum_out\[7\] u_pe_array.g_pe_row\[3\].g_pe_col\[3\].u_pe.psum_out\[8\]
+ _0988_ VGND VGND VPWR VPWR _1084_ sky130_fd_sc_hd__o21a_1
XFILLER_0_46_237 VGND VGND VPWR VPWR sky130_fd_sc_hd__decap_4
X_6622_ net275 _1731_ _1734_ _3235_ VGND VGND VPWR VPWR _0689_ sky130_fd_sc_hd__a22o_1
XFILLER_0_117_637 VPWR VGND VPWR VGND sky130_ef_sc_hd__decap_12
X_6553_ _3174_ _3179_ VGND VGND VPWR VPWR _3181_ sky130_fd_sc_hd__nand2_1
X_3765_ net431 _1007_ _1020_ _1021_ VGND VGND VPWR VPWR _0046_ sky130_fd_sc_hd__a22o_1
XFILLER_0_14_101 VGND VGND VPWR VPWR sky130_fd_sc_hd__fill_1
X_6484_ _3117_ VGND VGND VPWR VPWR _3118_ sky130_fd_sc_hd__inv_2
X_3696_ net819 _0949_ _0944_ _0966_ VGND VGND VPWR VPWR _0032_ sky130_fd_sc_hd__a22o_1
XFILLER_0_14_134 VGND VGND VPWR VPWR sky130_fd_sc_hd__fill_1
X_5504_ u_pe_array.u_fifo2.buffer\[0\]\[4\] _2324_ VGND VGND VPWR VPWR _2365_ sky130_fd_sc_hd__or2_1
X_5435_ _2313_ VGND VGND VPWR VPWR _0424_ sky130_fd_sc_hd__clkbuf_1
XFILLER_0_65_3 VPWR VGND VPWR VGND sky130_ef_sc_hd__decap_12
XFILLER_0_112_397 VGND VGND VPWR VPWR sky130_fd_sc_hd__fill_2
X_5366_ u_pe_array.g_pe_row\[1\].g_pe_col\[3\].u_pe.psum_out\[11\] _2260_ _2251_ VGND
+ VGND VPWR VPWR _2261_ sky130_fd_sc_hd__mux2_1
X_5297_ _2197_ _2198_ VGND VGND VPWR VPWR _2199_ sky130_fd_sc_hd__or2_1
X_4317_ u_pe_array.g_pe_row\[3\].g_pe_col\[0\].u_pe.move_reg\[9\] net62 VGND VGND
+ VPWR VPWR _1458_ sky130_fd_sc_hd__or2_1
X_7105_ clknet_leaf_86_clk _0011_ VGND VGND VPWR VPWR u_pe_array.u_fifo2.buffer\[8\]\[2\]
+ sky130_fd_sc_hd__dfxtp_1
X_4248_ _1395_ _1397_ _1402_ VGND VGND VPWR VPWR _1404_ sky130_fd_sc_hd__or3_1
X_7036_ _3512_ VGND VGND VPWR VPWR _0826_ sky130_fd_sc_hd__clkbuf_1
X_4179_ _1336_ _1338_ _1340_ VGND VGND VPWR VPWR _1341_ sky130_fd_sc_hd__o21ai_1
XFILLER_0_97_649 VPWR VGND VPWR VGND sky130_ef_sc_hd__decap_12
XTAP_1038 VGND VPWR sky130_fd_sc_hd__tapvpwrvgnd_1
XTAP_1027 VGND VPWR sky130_fd_sc_hd__tapvpwrvgnd_1
XTAP_1016 VGND VPWR sky130_fd_sc_hd__tapvpwrvgnd_1
XTAP_1005 VGND VPWR sky130_fd_sc_hd__tapvpwrvgnd_1
X_7938_ clknet_leaf_77_clk _0843_ VGND VGND VPWR VPWR u_pe_array.u_fifo1.buffer\[6\]\[4\]
+ sky130_fd_sc_hd__dfxtp_1
XFILLER_0_65_502 VGND VGND VPWR VPWR sky130_fd_sc_hd__fill_2
XTAP_1049 VGND VPWR sky130_fd_sc_hd__tapvpwrvgnd_1
XFILLER_0_108_626 VPWR VGND VPWR VGND sky130_ef_sc_hd__decap_12
XFILLER_0_92_332 VGND VGND VPWR VPWR sky130_fd_sc_hd__decap_8
X_7869_ clknet_leaf_102_clk _0774_ VGND VGND VPWR VPWR u_pe_array.u_fifo2.buffer\[5\]\[3\]
+ sky130_fd_sc_hd__dfxtp_1
XFILLER_0_92_365 VGND VGND VPWR VPWR sky130_fd_sc_hd__decap_4
Xclkbuf_3_3__f_clk clknet_0_clk VGND VGND VPWR VPWR clknet_3_3__leaf_clk sky130_fd_sc_hd__clkbuf_16
XFILLER_0_65_568 VGND VGND VPWR VPWR sky130_fd_sc_hd__fill_1
XFILLER_0_107_169 VGND VGND VPWR VPWR sky130_fd_sc_hd__fill_1
XFILLER_0_116_681 VPWR VGND VPWR VGND sky130_ef_sc_hd__decap_12
XFILLER_0_33_487 VPWR VGND VPWR VGND sky130_ef_sc_hd__decap_12
XFILLER_0_20_126 VPWR VGND VPWR VGND sky130_ef_sc_hd__decap_12
XTAP_1550 VGND VPWR sky130_fd_sc_hd__tapvpwrvgnd_1
XFILLER_0_56_524 VGND VGND VPWR VPWR sky130_fd_sc_hd__decap_4
XTAP_1594 VGND VPWR sky130_fd_sc_hd__tapvpwrvgnd_1
XTAP_1572 VGND VPWR sky130_fd_sc_hd__tapvpwrvgnd_1
XTAP_1583 VGND VPWR sky130_fd_sc_hd__tapvpwrvgnd_1
XTAP_1561 VGND VPWR sky130_fd_sc_hd__tapvpwrvgnd_1
XFILLER_0_68_395 VGND VGND VPWR VPWR sky130_fd_sc_hd__decap_4
XFILLER_0_56_557 VGND VGND VPWR VPWR sky130_fd_sc_hd__decap_8
XFILLER_0_22_23 VGND VGND VPWR VPWR sky130_fd_sc_hd__decap_4
XPHY_90 VGND VGND VPWR VPWR sky130_fd_sc_hd__decap_3
XFILLER_0_113_69 VPWR VGND VPWR VGND sky130_ef_sc_hd__decap_12
XFILLER_0_71_505 VGND VGND VPWR VPWR sky130_fd_sc_hd__fill_2
XFILLER_0_98_27 VGND VGND VPWR VPWR sky130_fd_sc_hd__fill_1
X_3550_ u_fsm.state\[1\] _0854_ _0857_ VGND VGND VPWR VPWR _0858_ sky130_fd_sc_hd__o21ai_2
X_5220_ _0938_ VGND VGND VPWR VPWR _2143_ sky130_fd_sc_hd__clkbuf_8
XFILLER_0_11_148 VGND VGND VPWR VPWR sky130_fd_sc_hd__decap_8
X_5151_ _2083_ _2089_ VGND VGND VPWR VPWR _2091_ sky130_fd_sc_hd__or2_1
XFILLER_0_51_9 VGND VGND VPWR VPWR sky130_fd_sc_hd__fill_1
X_5082_ u_pe_array.g_pe_row\[2\].g_pe_col\[0\].u_pe.psum_out\[2\] _2026_ VGND VGND
+ VPWR VPWR _2027_ sky130_fd_sc_hd__xnor2_1
X_4102_ u_pe_array.g_pe_row\[3\].g_pe_col\[1\].u_pe.psum_out\[2\] u_pe_array.g_pe_row\[3\].g_pe_col\[1\].u_pe.act_val\[2\]
+ _0947_ VGND VGND VPWR VPWR _1291_ sky130_fd_sc_hd__mux2_1
X_4033_ _1228_ _1229_ _1231_ VGND VGND VPWR VPWR _1233_ sky130_fd_sc_hd__a21o_1
XFILLER_0_63_63 VPWR VGND VPWR VGND sky130_ef_sc_hd__decap_12
XFILLER_0_2_77 VGND VGND VPWR VPWR sky130_fd_sc_hd__decap_6
XFILLER_0_63_96 VGND VGND VPWR VPWR sky130_fd_sc_hd__fill_1
XFILLER_0_19_215 VGND VGND VPWR VPWR sky130_fd_sc_hd__fill_2
X_7723_ clknet_leaf_75_clk _0629_ net13 VGND VGND VPWR VPWR u_pe_array.g_pe_row\[0\].g_pe_col\[2\].u_pe.psum_out\[1\]
+ sky130_fd_sc_hd__dfrtp_1
X_5984_ _2233_ _2738_ _2739_ _2621_ net666 VGND VGND VPWR VPWR _0547_ sky130_fd_sc_hd__a32o_1
X_4935_ u_pe_array.g_pe_row\[2\].g_pe_col\[1\].u_pe.act_val\[3\] _1105_ VGND VGND
+ VPWR VPWR _1919_ sky130_fd_sc_hd__and2b_1
X_4866_ net383 _1749_ _1873_ _1874_ VGND VGND VPWR VPWR _0294_ sky130_fd_sc_hd__a22o_1
X_7654_ clknet_leaf_95_clk _0560_ net951 VGND VGND VPWR VPWR u_pe_array.g_pe_row\[0\].g_pe_col\[2\].u_pe.w_out\[1\]
+ sky130_fd_sc_hd__dfrtp_1
XANTENNA_11 net21 VGND VGND VPWR VPWR sky130_fd_sc_hd__diode_2
X_6605_ _3225_ _3226_ VGND VGND VPWR VPWR _3227_ sky130_fd_sc_hd__xnor2_1
X_3817_ _1068_ _1044_ _1057_ _1061_ VGND VGND VPWR VPWR _1069_ sky130_fd_sc_hd__a22o_1
X_7585_ clknet_leaf_67_clk net241 net946 VGND VGND VPWR VPWR u_pe_array.g_pe_row\[1\].g_pe_col\[1\].u_pe.move_reg\[12\]
+ sky130_fd_sc_hd__dfrtp_1
XFILLER_0_6_153 VPWR VGND VPWR VGND sky130_ef_sc_hd__decap_12
X_4797_ _1810_ _1815_ _1818_ VGND VGND VPWR VPWR _1819_ sky130_fd_sc_hd__o21bai_1
XFILLER_0_117_489 VGND VGND VPWR VPWR sky130_fd_sc_hd__decap_6
X_6536_ _3162_ _3164_ VGND VGND VPWR VPWR _3165_ sky130_fd_sc_hd__xor2_1
XFILLER_0_27_292 VGND VGND VPWR VPWR sky130_fd_sc_hd__fill_1
X_3748_ _1005_ VGND VGND VPWR VPWR _1006_ sky130_fd_sc_hd__buf_8
XFILLER_0_104_139 VGND VGND VPWR VPWR sky130_fd_sc_hd__fill_1
XFILLER_0_70_582 VGND VGND VPWR VPWR sky130_fd_sc_hd__decap_6
XFILLER_0_6_197 VPWR VGND VPWR VGND sky130_ef_sc_hd__decap_12
XFILLER_0_113_673 VPWR VGND VPWR VGND sky130_ef_sc_hd__decap_12
X_6467_ u_pe_array.g_pe_row\[0\].g_pe_col\[1\].u_pe.psum_out\[12\] u_pe_array.g_pe_row\[0\].g_pe_col\[1\].u_pe.move_reg\[12\]
+ _3102_ VGND VGND VPWR VPWR _3115_ sky130_fd_sc_hd__mux2_1
X_3679_ u_pe_array.g_pe_row\[3\].g_pe_col\[3\].u_pe.psum_out\[8\] u_pe_array.g_pe_row\[3\].g_pe_col\[3\].u_pe.move_reg\[8\]
+ _0947_ VGND VGND VPWR VPWR _0957_ sky130_fd_sc_hd__mux2_1
XFILLER_0_112_161 VPWR VGND VPWR VGND sky130_ef_sc_hd__decap_12
XFILLER_0_88_93 VGND VGND VPWR VPWR sky130_fd_sc_hd__decap_6
X_5418_ net81 _2300_ _2273_ VGND VGND VPWR VPWR _2301_ sky130_fd_sc_hd__mux2_1
X_6398_ _3027_ _3038_ _3039_ VGND VGND VPWR VPWR _3065_ sky130_fd_sc_hd__o21bai_1
XFILLER_0_100_345 VGND VGND VPWR VPWR sky130_fd_sc_hd__fill_1
X_5349_ u_pe_array.g_pe_row\[1\].g_pe_col\[3\].u_pe.psum_out\[8\] u_pe_array.g_pe_row\[1\].g_pe_col\[3\].u_pe.psum_out\[9\]
+ _1426_ VGND VGND VPWR VPWR _2246_ sky130_fd_sc_hd__and3_1
XFILLER_0_11_671 VGND VGND VPWR VPWR sky130_fd_sc_hd__fill_1
X_7019_ _3503_ VGND VGND VPWR VPWR _0818_ sky130_fd_sc_hd__clkbuf_1
XFILLER_0_85_608 VGND VGND VPWR VPWR sky130_fd_sc_hd__decap_8
XFILLER_0_69_148 VPWR VGND VPWR VGND sky130_ef_sc_hd__decap_12
XFILLER_0_77_181 VGND VGND VPWR VPWR sky130_fd_sc_hd__decap_4
Xclkbuf_leaf_50_clk clknet_3_6__leaf_clk VGND VGND VPWR VPWR clknet_leaf_50_clk sky130_fd_sc_hd__clkbuf_16
XFILLER_0_93_685 VPWR VGND VPWR VGND sky130_ef_sc_hd__decap_12
XFILLER_0_38_568 VGND VGND VPWR VPWR sky130_fd_sc_hd__decap_8
XFILLER_0_53_505 VGND VGND VPWR VPWR sky130_fd_sc_hd__fill_2
XFILLER_0_53_527 VPWR VGND VPWR VGND sky130_ef_sc_hd__decap_12
XFILLER_0_18_292 VGND VGND VPWR VPWR sky130_fd_sc_hd__fill_1
XFILLER_0_61_582 VGND VGND VPWR VPWR sky130_fd_sc_hd__decap_3
XFILLER_0_21_468 VGND VGND VPWR VPWR sky130_fd_sc_hd__fill_2
XTAP_608 VGND VPWR sky130_fd_sc_hd__tapvpwrvgnd_1
XTAP_619 VGND VPWR sky130_fd_sc_hd__tapvpwrvgnd_1
XFILLER_0_84_29 VGND VGND VPWR VPWR sky130_fd_sc_hd__decap_3
XFILLER_0_118_209 VPWR VGND VPWR VGND sky130_ef_sc_hd__decap_12
XFILLER_0_68_170 VGND VGND VPWR VPWR sky130_fd_sc_hd__fill_1
XFILLER_0_56_321 VGND VGND VPWR VPWR sky130_fd_sc_hd__decap_6
XFILLER_0_8_407 VPWR VGND VPWR VGND sky130_ef_sc_hd__decap_12
XFILLER_0_33_55 VGND VGND VPWR VPWR sky130_fd_sc_hd__fill_1
XTAP_1391 VGND VPWR sky130_fd_sc_hd__tapvpwrvgnd_1
XTAP_1380 VGND VPWR sky130_fd_sc_hd__tapvpwrvgnd_1
Xclkbuf_leaf_41_clk clknet_3_6__leaf_clk VGND VGND VPWR VPWR clknet_leaf_41_clk sky130_fd_sc_hd__clkbuf_16
XFILLER_0_8_429 VGND VGND VPWR VPWR sky130_fd_sc_hd__decap_3
X_4720_ u_pe_array.act_from_right\[10\]\[11\] _1750_ _1483_ net314 VGND VGND VPWR
+ VPWR _0272_ sky130_fd_sc_hd__a22o_1
XFILLER_0_84_685 VPWR VGND VPWR VGND sky130_ef_sc_hd__decap_12
XFILLER_0_83_162 VGND VGND VPWR VPWR sky130_fd_sc_hd__decap_6
XFILLER_0_71_313 VGND VGND VPWR VPWR sky130_fd_sc_hd__decap_3
X_4651_ u_pe_array.g_pe_row\[2\].g_pe_col\[3\].u_pe.psum_out\[10\] _1427_ VGND VGND
+ VPWR VPWR _1711_ sky130_fd_sc_hd__or2_1
Xinput20 v_in0[5] VGND VGND VPWR VPWR net20 sky130_fd_sc_hd__buf_1
XFILLER_0_4_613 VPWR VGND VPWR VGND sky130_ef_sc_hd__decap_12
Xinput31 w_in_flat[4] VGND VGND VPWR VPWR net31 sky130_fd_sc_hd__clkbuf_1
X_3602_ _0899_ _0900_ net507 VGND VGND VPWR VPWR _0901_ sky130_fd_sc_hd__o21ai_1
XFILLER_0_12_413 VGND VGND VPWR VPWR sky130_fd_sc_hd__fill_1
X_7370_ clknet_leaf_104_clk _0276_ net944 VGND VGND VPWR VPWR u_pe_array.g_pe_row\[2\].g_pe_col\[2\].u_pe.psum_out\[2\]
+ sky130_fd_sc_hd__dfrtp_1
XFILLER_0_4_657 VPWR VGND VPWR VGND sky130_ef_sc_hd__decap_12
X_4582_ u_pe_array.g_pe_row\[2\].g_pe_col\[3\].u_pe.act_val\[3\] VGND VGND VPWR VPWR
+ _1648_ sky130_fd_sc_hd__inv_2
Xhold804 u_pe_array.act_from_left\[13\]\[3\] VGND VGND VPWR VPWR net878 sky130_fd_sc_hd__dlygate4sd3_1
Xhold826 net49 VGND VGND VPWR VPWR net900 sky130_fd_sc_hd__dlygate4sd3_1
XFILLER_0_3_167 VGND VGND VPWR VPWR sky130_fd_sc_hd__fill_1
Xhold837 u_pe_array.u_fifo1.count\[3\] VGND VGND VPWR VPWR net911 sky130_fd_sc_hd__dlygate4sd3_1
Xhold815 u_pe_array.act_from_left\[7\]\[4\] VGND VGND VPWR VPWR net889 sky130_fd_sc_hd__dlygate4sd3_1
X_6321_ u_pe_array.g_pe_row\[0\].g_pe_col\[2\].u_pe.act_val\[1\] _2128_ _2992_ _2993_
+ VGND VGND VPWR VPWR _2995_ sky130_fd_sc_hd__a22o_1
Xhold848 u_pe_array.g_pe_row\[2\].g_pe_col\[0\].u_pe.psum_out\[8\] VGND VGND VPWR
+ VPWR net922 sky130_fd_sc_hd__dlygate4sd3_1
Xhold859 u_pe_array.g_pe_row\[1\].g_pe_col\[3\].u_pe.psum_out\[9\] VGND VGND VPWR
+ VPWR net933 sky130_fd_sc_hd__dlygate4sd3_1
X_6252_ u_pe_array.g_pe_row\[0\].g_pe_col\[3\].u_pe.psum_out\[10\] _2947_ VGND VGND
+ VPWR VPWR _2958_ sky130_fd_sc_hd__nor2_1
XFILLER_0_110_643 VGND VGND VPWR VPWR sky130_fd_sc_hd__fill_1
X_6183_ _2893_ _2894_ VGND VGND VPWR VPWR _2895_ sky130_fd_sc_hd__xnor2_1
X_5203_ net154 _1882_ _2132_ _2134_ VGND VGND VPWR VPWR _0371_ sky130_fd_sc_hd__a22o_1
X_5134_ u_pe_array.g_pe_row\[2\].g_pe_col\[0\].u_pe.psum_out\[5\] _1286_ VGND VGND
+ VPWR VPWR _2075_ sky130_fd_sc_hd__nand2_1
X_5065_ u_pe_array.act_from_right\[8\]\[9\] _1750_ _1883_ net232 VGND VGND VPWR VPWR
+ _0352_ sky130_fd_sc_hd__a22o_1
X_4016_ _1033_ _1216_ _1217_ _0986_ net537 VGND VGND VPWR VPWR _0101_ sky130_fd_sc_hd__a32o_1
XFILLER_0_90_61 VGND VGND VPWR VPWR sky130_fd_sc_hd__fill_1
XFILLER_0_75_630 VGND VGND VPWR VPWR sky130_fd_sc_hd__decap_4
X_5967_ net168 _2016_ _2511_ u_pe_array.g_pe_row\[1\].g_pe_col\[0\].u_pe.move_reg\[7\]
+ VGND VGND VPWR VPWR _0540_ sky130_fd_sc_hd__a22o_1
Xclkbuf_leaf_32_clk clknet_3_3__leaf_clk VGND VGND VPWR VPWR clknet_leaf_32_clk sky130_fd_sc_hd__clkbuf_16
X_4918_ _1902_ _1903_ net502 _1006_ VGND VGND VPWR VPWR _0317_ sky130_fd_sc_hd__a2bb2o_1
X_7706_ clknet_leaf_73_clk _0612_ net72 VGND VGND VPWR VPWR u_pe_array.act_from_up\[6\]\[10\]
+ sky130_fd_sc_hd__dfrtp_1
X_7637_ clknet_leaf_62_clk net225 net74 VGND VGND VPWR VPWR u_pe_array.g_pe_row\[1\].g_pe_col\[0\].u_pe.move_reg\[10\]
+ sky130_fd_sc_hd__dfrtp_1
XFILLER_0_7_440 VGND VGND VPWR VPWR sky130_fd_sc_hd__decap_8
X_5898_ net164 _1159_ _2649_ _1476_ VGND VGND VPWR VPWR _0526_ sky130_fd_sc_hd__a22o_1
X_4849_ _1864_ VGND VGND VPWR VPWR _0287_ sky130_fd_sc_hd__clkbuf_1
XFILLER_0_99_81 VPWR VGND VPWR VGND sky130_ef_sc_hd__decap_12
X_7568_ clknet_leaf_44_clk _0474_ net947 VGND VGND VPWR VPWR u_pe_array.act_from_down\[1\]\[8\]
+ sky130_fd_sc_hd__dfrtp_1
X_6519_ u_pe_array.g_pe_row\[0\].g_pe_col\[1\].u_pe.act_val\[3\] _2268_ VGND VGND
+ VPWR VPWR _3149_ sky130_fd_sc_hd__and2b_1
X_7499_ clknet_leaf_45_clk _0405_ net947 VGND VGND VPWR VPWR u_pe_array.g_pe_row\[1\].g_pe_col\[3\].u_pe.psum_out\[8\]
+ sky130_fd_sc_hd__dfrtp_2
XFILLER_0_101_643 VPWR VGND VPWR VGND sky130_ef_sc_hd__decap_12
Xclkbuf_leaf_99_clk clknet_3_1__leaf_clk VGND VGND VPWR VPWR clknet_leaf_99_clk sky130_fd_sc_hd__clkbuf_16
XFILLER_0_100_197 VGND VGND VPWR VPWR sky130_fd_sc_hd__decap_8
XFILLER_0_97_221 VGND VGND VPWR VPWR sky130_fd_sc_hd__decap_3
XFILLER_0_85_416 VGND VGND VPWR VPWR sky130_fd_sc_hd__fill_2
XFILLER_0_85_449 VGND VGND VPWR VPWR sky130_fd_sc_hd__decap_4
Xclkbuf_leaf_23_clk clknet_3_2__leaf_clk VGND VGND VPWR VPWR clknet_leaf_23_clk sky130_fd_sc_hd__clkbuf_16
XFILLER_0_38_365 VGND VGND VPWR VPWR sky130_fd_sc_hd__decap_6
XFILLER_0_81_633 VGND VGND VPWR VPWR sky130_fd_sc_hd__fill_2
XFILLER_0_80_121 VPWR VGND VPWR VGND sky130_ef_sc_hd__decap_12
XFILLER_0_53_335 VGND VGND VPWR VPWR sky130_fd_sc_hd__fill_1
XFILLER_0_110_15 VPWR VGND VPWR VGND sky130_ef_sc_hd__decap_12
XFILLER_0_108_297 VGND VGND VPWR VPWR sky130_fd_sc_hd__fill_1
XFILLER_0_108_286 VGND VGND VPWR VPWR sky130_fd_sc_hd__fill_2
XFILLER_0_53_368 VGND VGND VPWR VPWR sky130_fd_sc_hd__fill_2
XFILLER_0_111_418 VGND VGND VPWR VPWR sky130_fd_sc_hd__fill_1
XFILLER_0_61_390 VGND VGND VPWR VPWR sky130_fd_sc_hd__fill_2
XFILLER_0_34_582 VGND VGND VPWR VPWR sky130_fd_sc_hd__decap_6
XTAP_405 VGND VPWR sky130_fd_sc_hd__tapvpwrvgnd_1
XFILLER_0_21_287 VGND VGND VPWR VPWR sky130_fd_sc_hd__fill_1
XTAP_416 VGND VPWR sky130_fd_sc_hd__tapvpwrvgnd_1
XTAP_427 VGND VPWR sky130_fd_sc_hd__tapvpwrvgnd_1
XTAP_438 VGND VPWR sky130_fd_sc_hd__tapvpwrvgnd_1
XTAP_449 VGND VPWR sky130_fd_sc_hd__tapvpwrvgnd_1
XFILLER_0_88_243 VGND VGND VPWR VPWR sky130_fd_sc_hd__fill_1
XFILLER_0_88_232 VGND VGND VPWR VPWR sky130_fd_sc_hd__decap_3
X_6870_ _3414_ VGND VGND VPWR VPWR _0758_ sky130_fd_sc_hd__clkbuf_1
XFILLER_0_69_490 VGND VGND VPWR VPWR sky130_fd_sc_hd__fill_1
X_5821_ _0985_ VGND VGND VPWR VPWR _2621_ sky130_fd_sc_hd__buf_8
X_5752_ u_pe_array.g_pe_row\[1\].g_pe_col\[1\].u_pe.psum_out\[5\] _2557_ VGND VGND
+ VPWR VPWR _2558_ sky130_fd_sc_hd__xnor2_2
XFILLER_0_17_505 VGND VGND VPWR VPWR sky130_fd_sc_hd__fill_2
Xclkbuf_leaf_14_clk clknet_3_3__leaf_clk VGND VGND VPWR VPWR clknet_leaf_14_clk sky130_fd_sc_hd__clkbuf_16
XFILLER_0_57_696 VGND VGND VPWR VPWR sky130_fd_sc_hd__decap_6
X_4703_ u_pe_array.g_pe_row\[2\].g_pe_col\[2\].u_pe.psum_out\[11\] net314 _1599_ VGND
+ VGND VPWR VPWR _1747_ sky130_fd_sc_hd__mux2_1
X_5683_ u_pe_array.act_from_right\[5\]\[1\] u_pe_array.act_from_left\[5\]\[1\] _0963_
+ VGND VGND VPWR VPWR _2506_ sky130_fd_sc_hd__mux2_1
X_7422_ clknet_leaf_16_clk _0328_ net943 VGND VGND VPWR VPWR u_pe_array.g_pe_row\[1\].g_pe_col\[3\].u_pe.w_out\[0\]
+ sky130_fd_sc_hd__dfrtp_1
XFILLER_0_4_421 VPWR VGND VPWR VGND sky130_ef_sc_hd__decap_12
X_4634_ u_pe_array.g_pe_row\[2\].g_pe_col\[3\].u_pe.psum_out\[8\] _1427_ VGND VGND
+ VPWR VPWR _1696_ sky130_fd_sc_hd__or2_1
XFILLER_0_102_418 VGND VGND VPWR VPWR sky130_fd_sc_hd__fill_2
XFILLER_0_8_65 VPWR VGND VPWR VGND sky130_ef_sc_hd__decap_12
Xhold601 u_pe_array.u_fifo2.buffer\[8\]\[4\] VGND VGND VPWR VPWR net675 sky130_fd_sc_hd__dlygate4sd3_1
X_4565_ u_pe_array.g_pe_row\[2\].g_pe_col\[3\].u_pe.act_val\[1\] u_pe_array.g_pe_row\[2\].g_pe_col\[3\].u_pe.psum_out\[2\]
+ _1427_ VGND VGND VPWR VPWR _1632_ sky130_fd_sc_hd__and3b_1
Xhold612 u_pe_array.g_pe_row\[1\].g_pe_col\[2\].u_pe.act_val\[4\] VGND VGND VPWR VPWR
+ net686 sky130_fd_sc_hd__dlygate4sd3_1
X_7353_ clknet_leaf_7_clk _0259_ net950 VGND VGND VPWR VPWR u_pe_array.act_from_up\[14\]\[11\]
+ sky130_fd_sc_hd__dfrtp_1
Xhold623 u_pe_array.g_pe_row\[1\].g_pe_col\[1\].u_pe.psum_out\[12\] VGND VGND VPWR
+ VPWR net697 sky130_fd_sc_hd__dlygate4sd3_1
Xhold645 u_pe_array.g_pe_row\[3\].g_pe_col\[1\].u_pe.act_val\[1\] VGND VGND VPWR VPWR
+ net719 sky130_fd_sc_hd__dlygate4sd3_1
X_6304_ u_pe_array.g_pe_row\[0\].g_pe_col\[2\].u_pe.act_val\[4\] _2853_ _2987_ net259
+ VGND VGND VPWR VPWR _0619_ sky130_fd_sc_hd__a22o_1
Xhold634 u_pe_array.u_fifo2.buffer\[4\]\[5\] VGND VGND VPWR VPWR net708 sky130_fd_sc_hd__dlygate4sd3_1
XFILLER_0_40_541 VPWR VGND VPWR VGND sky130_ef_sc_hd__decap_12
Xhold667 u_pe_array.g_pe_row\[2\].g_pe_col\[1\].u_pe.psum_out\[6\] VGND VGND VPWR
+ VPWR net741 sky130_fd_sc_hd__dlygate4sd3_1
X_7284_ clknet_leaf_38_clk net252 net942 VGND VGND VPWR VPWR u_pe_array.g_pe_row\[3\].g_pe_col\[0\].u_pe.move_reg\[11\]
+ sky130_fd_sc_hd__dfrtp_1
Xhold656 u_pe_array.g_pe_row\[1\].g_pe_col\[0\].u_pe.act_val\[0\] VGND VGND VPWR VPWR
+ net730 sky130_fd_sc_hd__dlygate4sd3_1
X_4496_ net731 _1273_ _1594_ _1021_ VGND VGND VPWR VPWR _0204_ sky130_fd_sc_hd__a22o_1
Xhold678 u_pe_array.g_pe_row\[1\].g_pe_col\[2\].u_pe.psum_out\[6\] VGND VGND VPWR
+ VPWR net752 sky130_fd_sc_hd__dlygate4sd3_1
X_6235_ _2928_ _2941_ _2942_ VGND VGND VPWR VPWR _2943_ sky130_fd_sc_hd__a21oi_1
Xhold689 u_pe_array.g_pe_row\[1\].g_pe_col\[2\].u_pe.act_val\[3\] VGND VGND VPWR VPWR
+ net763 sky130_fd_sc_hd__dlygate4sd3_1
X_6166_ _2871_ _2875_ VGND VGND VPWR VPWR _2879_ sky130_fd_sc_hd__nor2_1
XTAP_961 VGND VPWR sky130_fd_sc_hd__tapvpwrvgnd_1
XTAP_950 VGND VPWR sky130_fd_sc_hd__tapvpwrvgnd_1
XFILLER_0_0_693 VGND VGND VPWR VPWR sky130_fd_sc_hd__decap_6
X_5117_ _2058_ _2059_ VGND VGND VPWR VPWR _2060_ sky130_fd_sc_hd__or2_1
X_6097_ net635 _2586_ _2841_ _0978_ VGND VGND VPWR VPWR _0558_ sky130_fd_sc_hd__a22o_1
XTAP_994 VGND VPWR sky130_fd_sc_hd__tapvpwrvgnd_1
XTAP_983 VGND VPWR sky130_fd_sc_hd__tapvpwrvgnd_1
XTAP_972 VGND VPWR sky130_fd_sc_hd__tapvpwrvgnd_1
X_5048_ u_pe_array.g_pe_row\[2\].g_pe_col\[0\].u_pe.psum_out\[9\] u_pe_array.g_pe_row\[2\].g_pe_col\[0\].u_pe.move_reg\[9\]
+ _1867_ VGND VGND VPWR VPWR _2012_ sky130_fd_sc_hd__mux2_1
XFILLER_0_79_276 VGND VGND VPWR VPWR sky130_fd_sc_hd__decap_4
XFILLER_0_94_246 VGND VGND VPWR VPWR sky130_fd_sc_hd__decap_6
XFILLER_0_82_419 VGND VGND VPWR VPWR sky130_fd_sc_hd__fill_1
X_6999_ _3492_ VGND VGND VPWR VPWR _0809_ sky130_fd_sc_hd__clkbuf_1
XFILLER_0_7_292 VGND VGND VPWR VPWR sky130_fd_sc_hd__decap_4
XFILLER_0_105_245 VGND VGND VPWR VPWR sky130_fd_sc_hd__decap_6
XFILLER_0_31_552 VGND VGND VPWR VPWR sky130_fd_sc_hd__decap_3
XFILLER_0_101_495 VGND VGND VPWR VPWR sky130_fd_sc_hd__fill_2
XFILLER_0_98_541 VGND VGND VPWR VPWR sky130_fd_sc_hd__decap_4
XFILLER_0_39_652 VGND VGND VPWR VPWR sky130_fd_sc_hd__fill_1
XFILLER_0_85_279 VGND VGND VPWR VPWR sky130_fd_sc_hd__fill_1
XFILLER_0_54_688 VPWR VGND VPWR VGND sky130_ef_sc_hd__decap_12
XFILLER_0_41_349 VGND VGND VPWR VPWR sky130_fd_sc_hd__decap_4
X_4350_ net146 _1166_ _1462_ _1476_ VGND VGND VPWR VPWR _0176_ sky130_fd_sc_hd__a22o_1
X_4281_ net900 _1430_ _1116_ VGND VGND VPWR VPWR _1431_ sky130_fd_sc_hd__mux2_1
XTAP_246 VGND VPWR sky130_fd_sc_hd__tapvpwrvgnd_1
XTAP_257 VGND VPWR sky130_fd_sc_hd__tapvpwrvgnd_1
X_6020_ _2771_ _2772_ net871 _1007_ VGND VGND VPWR VPWR _0550_ sky130_fd_sc_hd__a2bb2o_1
Xclkbuf_leaf_3_clk clknet_3_0__leaf_clk VGND VGND VPWR VPWR clknet_leaf_3_clk sky130_fd_sc_hd__clkbuf_16
XTAP_268 VGND VPWR sky130_fd_sc_hd__tapvpwrvgnd_1
XTAP_279 VGND VPWR sky130_fd_sc_hd__tapvpwrvgnd_1
XFILLER_0_55_53 VGND VGND VPWR VPWR sky130_fd_sc_hd__decap_3
XFILLER_0_12_6 VPWR VGND VPWR VGND sky130_ef_sc_hd__decap_12
X_6922_ _0926_ net740 _3439_ VGND VGND VPWR VPWR _3444_ sky130_fd_sc_hd__mux2_1
X_6853_ net662 _0926_ _3400_ VGND VGND VPWR VPWR _3405_ sky130_fd_sc_hd__mux2_1
XFILLER_0_49_449 VGND VGND VPWR VPWR sky130_fd_sc_hd__decap_4
X_5804_ _2233_ _2604_ _2605_ _2173_ net778 VGND VGND VPWR VPWR _0501_ sky130_fd_sc_hd__a32o_1
XFILLER_0_9_557 VGND VGND VPWR VPWR sky130_fd_sc_hd__decap_3
X_3996_ _1192_ _1193_ _1198_ VGND VGND VPWR VPWR _1199_ sky130_fd_sc_hd__nor3_1
XFILLER_0_17_313 VGND VGND VPWR VPWR sky130_fd_sc_hd__fill_2
X_6784_ u_pe_array.act_from_up\[12\]\[4\] _0869_ _0854_ VGND VGND VPWR VPWR _3360_
+ sky130_fd_sc_hd__and3_4
X_5735_ _2532_ _2542_ VGND VGND VPWR VPWR _2543_ sky130_fd_sc_hd__xnor2_1
XFILLER_0_17_324 VGND VGND VPWR VPWR sky130_fd_sc_hd__fill_2
XFILLER_0_29_184 VGND VGND VPWR VPWR sky130_fd_sc_hd__decap_3
X_5666_ u_pe_array.g_pe_row\[1\].g_pe_col\[1\].u_pe.psum_out\[6\] u_pe_array.g_pe_row\[1\].g_pe_col\[1\].u_pe.move_reg\[6\]
+ _2133_ VGND VGND VPWR VPWR _2497_ sky130_fd_sc_hd__mux2_1
X_7405_ clknet_leaf_35_clk net296 net951 VGND VGND VPWR VPWR u_pe_array.g_pe_row\[2\].g_pe_col\[1\].u_pe.move_reg\[9\]
+ sky130_fd_sc_hd__dfrtp_1
XFILLER_0_60_658 VGND VGND VPWR VPWR sky130_fd_sc_hd__decap_3
X_4617_ net835 _1273_ _1680_ _1021_ VGND VGND VPWR VPWR _0239_ sky130_fd_sc_hd__a22o_1
Xhold420 u_pe_array.act_from_right\[8\]\[6\] VGND VGND VPWR VPWR net494 sky130_fd_sc_hd__dlygate4sd3_1
X_5597_ u_pe_array.g_pe_row\[1\].g_pe_col\[2\].u_pe.psum_out\[7\] VGND VGND VPWR VPWR
+ _2442_ sky130_fd_sc_hd__inv_2
XFILLER_0_102_237 VGND VGND VPWR VPWR sky130_fd_sc_hd__fill_2
Xhold442 u_pe_array.g_pe_row\[1\].g_pe_col\[1\].u_pe.psum_out\[0\] VGND VGND VPWR
+ VPWR net516 sky130_fd_sc_hd__dlygate4sd3_1
Xhold453 _0579_ VGND VGND VPWR VPWR net527 sky130_fd_sc_hd__dlygate4sd3_1
Xhold431 _0339_ VGND VGND VPWR VPWR net505 sky130_fd_sc_hd__dlygate4sd3_1
X_4548_ u_pe_array.g_pe_row\[2\].g_pe_col\[3\].u_pe.act_val\[0\] _1427_ u_pe_array.g_pe_row\[2\].g_pe_col\[3\].u_pe.psum_out\[1\]
+ VGND VGND VPWR VPWR _1617_ sky130_fd_sc_hd__a21oi_1
X_7336_ clknet_leaf_3_clk _0242_ net944 VGND VGND VPWR VPWR u_pe_array.g_pe_row\[2\].g_pe_col\[3\].u_pe.psum_out\[9\]
+ sky130_fd_sc_hd__dfrtp_1
Xhold464 u_pe_array.g_pe_row\[0\].g_pe_col\[1\].u_pe.psum_out\[6\] VGND VGND VPWR
+ VPWR net538 sky130_fd_sc_hd__dlygate4sd3_1
X_7267_ clknet_leaf_12_clk _0173_ net942 VGND VGND VPWR VPWR u_pe_array.act_from_left\[13\]\[7\]
+ sky130_fd_sc_hd__dfrtp_1
Xhold475 u_pe_array.u_fifo2.buffer\[0\]\[4\] VGND VGND VPWR VPWR net549 sky130_fd_sc_hd__dlygate4sd3_1
Xhold486 u_pe_array.u_fifo1.buffer\[0\]\[3\] VGND VGND VPWR VPWR net560 sky130_fd_sc_hd__dlygate4sd3_1
X_4479_ _1578_ _1579_ VGND VGND VPWR VPWR _1580_ sky130_fd_sc_hd__nand2_1
X_6218_ _2918_ _2923_ _2926_ VGND VGND VPWR VPWR _2927_ sky130_fd_sc_hd__o21bai_1
Xhold497 u_pe_array.u_fifo1.buffer\[7\]\[0\] VGND VGND VPWR VPWR net571 sky130_fd_sc_hd__dlygate4sd3_1
X_7198_ clknet_leaf_98_clk _0104_ net950 VGND VGND VPWR VPWR u_pe_array.g_pe_row\[3\].g_pe_col\[2\].u_pe.psum_out\[7\]
+ sky130_fd_sc_hd__dfrtp_4
XFILLER_0_99_305 VGND VGND VPWR VPWR sky130_fd_sc_hd__decap_4
X_6149_ u_pe_array.g_pe_row\[0\].g_pe_col\[3\].u_pe.act_val\[0\] _1999_ VGND VGND
+ VPWR VPWR _2864_ sky130_fd_sc_hd__nand2_1
XTAP_780 VGND VPWR sky130_fd_sc_hd__tapvpwrvgnd_1
XTAP_791 VGND VPWR sky130_fd_sc_hd__tapvpwrvgnd_1
XFILLER_0_67_202 VPWR VGND VPWR VGND sky130_ef_sc_hd__decap_12
XFILLER_0_82_205 VPWR VGND VPWR VGND sky130_ef_sc_hd__decap_12
XFILLER_0_67_279 VGND VGND VPWR VPWR sky130_fd_sc_hd__fill_1
XFILLER_0_63_441 VGND VGND VPWR VPWR sky130_fd_sc_hd__decap_6
XFILLER_0_35_121 VGND VGND VPWR VPWR sky130_fd_sc_hd__decap_3
XFILLER_0_106_521 VGND VGND VPWR VPWR sky130_fd_sc_hd__decap_8
XFILLER_0_36_699 VGND VGND VPWR VPWR sky130_fd_sc_hd__fill_1
XFILLER_0_106_587 VGND VGND VPWR VPWR sky130_fd_sc_hd__fill_1
XFILLER_0_31_393 VGND VGND VPWR VPWR sky130_fd_sc_hd__fill_2
XFILLER_0_101_281 VPWR VGND VPWR VGND sky130_ef_sc_hd__decap_12
XFILLER_0_92_29 VPWR VGND VPWR VGND sky130_ef_sc_hd__decap_12
XFILLER_0_25_23 VGND VGND VPWR VPWR sky130_fd_sc_hd__decap_8
XFILLER_0_46_408 VGND VGND VPWR VPWR sky130_fd_sc_hd__decap_4
X_3850_ _1089_ _1091_ _1097_ VGND VGND VPWR VPWR _1099_ sky130_fd_sc_hd__or3_1
X_3781_ _1034_ _1035_ VGND VGND VPWR VPWR _1036_ sky130_fd_sc_hd__xnor2_2
XFILLER_0_6_527 VGND VGND VPWR VPWR sky130_fd_sc_hd__decap_4
XFILLER_0_6_505 VPWR VGND VPWR VGND sky130_ef_sc_hd__decap_12
X_5520_ net190 _2016_ _1883_ u_pe_array.g_pe_row\[1\].g_pe_col\[2\].u_pe.move_reg\[6\]
+ VGND VGND VPWR VPWR _0444_ sky130_fd_sc_hd__a22o_1
XFILLER_0_14_305 VGND VGND VPWR VPWR sky130_fd_sc_hd__decap_3
XFILLER_0_41_77 VGND VGND VPWR VPWR sky130_fd_sc_hd__fill_1
XFILLER_0_14_316 VPWR VGND VPWR VGND sky130_ef_sc_hd__decap_12
X_5451_ net161 _1166_ _2303_ _1476_ VGND VGND VPWR VPWR _0434_ sky130_fd_sc_hd__a22o_1
X_4402_ u_pe_array.g_pe_row\[3\].g_pe_col\[0\].u_pe.act_val\[2\] u_pe_array.g_pe_row\[3\].g_pe_col\[0\].u_pe.w_out\[0\]
+ _1497_ VGND VGND VPWR VPWR _1510_ sky130_fd_sc_hd__and3_1
X_5382_ _1115_ VGND VGND VPWR VPWR _2273_ sky130_fd_sc_hd__buf_12
X_7121_ clknet_leaf_18_clk _0027_ net943 VGND VGND VPWR VPWR u_pe_array.act_from_down\[11\]\[10\]
+ sky130_fd_sc_hd__dfrtp_1
X_4333_ _1430_ net917 _1159_ VGND VGND VPWR VPWR _1470_ sky130_fd_sc_hd__mux2_1
X_4264_ _1413_ _1417_ VGND VGND VPWR VPWR _1418_ sky130_fd_sc_hd__xor2_1
X_7052_ net644 _3347_ _3521_ VGND VGND VPWR VPWR _3522_ sky130_fd_sc_hd__mux2_1
XFILLER_0_66_41 VPWR VGND VPWR VGND sky130_ef_sc_hd__decap_12
XFILLER_0_5_55 VGND VGND VPWR VPWR sky130_fd_sc_hd__fill_1
X_6003_ u_pe_array.g_pe_row\[1\].g_pe_col\[0\].u_pe.psum_out\[2\] _2745_ _2756_ VGND
+ VGND VPWR VPWR _2757_ sky130_fd_sc_hd__a21oi_1
X_4195_ _0985_ VGND VGND VPWR VPWR _1356_ sky130_fd_sc_hd__buf_8
XFILLER_0_89_393 VGND VGND VPWR VPWR sky130_fd_sc_hd__decap_8
XFILLER_0_89_382 VGND VGND VPWR VPWR sky130_fd_sc_hd__decap_8
XTAP_1209 VGND VPWR sky130_fd_sc_hd__tapvpwrvgnd_1
XFILLER_0_10_3 VPWR VGND VPWR VGND sky130_ef_sc_hd__decap_12
X_6905_ _3434_ VGND VGND VPWR VPWR _0773_ sky130_fd_sc_hd__clkbuf_1
X_7885_ clknet_leaf_20_clk _0790_ net943 VGND VGND VPWR VPWR u_pe_array.g_pe_row\[3\].g_pe_col\[3\].u_pe.w_out\[1\]
+ sky130_fd_sc_hd__dfrtp_1
X_6836_ _3395_ VGND VGND VPWR VPWR _0743_ sky130_fd_sc_hd__clkbuf_1
XFILLER_0_49_279 VGND VGND VPWR VPWR sky130_fd_sc_hd__fill_1
X_6767_ u_pe_array.act_from_up\[12\]\[0\] _0869_ _0854_ VGND VGND VPWR VPWR _3347_
+ sky130_fd_sc_hd__and3_4
X_5718_ u_pe_array.g_pe_row\[1\].g_pe_col\[1\].u_pe.psum_out\[2\] _2526_ VGND VGND
+ VPWR VPWR _2527_ sky130_fd_sc_hd__xnor2_1
XFILLER_0_17_132 VPWR VGND VPWR VGND sky130_ef_sc_hd__decap_12
X_3979_ _1033_ _1182_ _1183_ _0986_ net725 VGND VGND VPWR VPWR _0098_ sky130_fd_sc_hd__a32o_1
X_6698_ u_pe_array.g_pe_row\[0\].g_pe_col\[0\].u_pe.psum_out\[5\] u_pe_array.g_pe_row\[0\].g_pe_col\[0\].u_pe.act_val\[5\]
+ _2486_ VGND VGND VPWR VPWR _3286_ sky130_fd_sc_hd__and3_1
XFILLER_0_60_400 VGND VGND VPWR VPWR sky130_fd_sc_hd__fill_2
XFILLER_0_103_513 VGND VGND VPWR VPWR sky130_fd_sc_hd__fill_1
X_5649_ _2487_ VGND VGND VPWR VPWR _0464_ sky130_fd_sc_hd__clkbuf_1
XFILLER_0_60_477 VGND VGND VPWR VPWR sky130_fd_sc_hd__decap_6
XFILLER_0_13_360 VGND VGND VPWR VPWR sky130_fd_sc_hd__decap_4
Xhold261 u_pe_array.act_from_right\[2\]\[12\] VGND VGND VPWR VPWR net335 sky130_fd_sc_hd__dlygate4sd3_1
Xhold250 u_pe_array.act_from_right\[2\]\[6\] VGND VGND VPWR VPWR net324 sky130_fd_sc_hd__dlygate4sd3_1
XFILLER_0_13_393 VGND VGND VPWR VPWR sky130_fd_sc_hd__decap_6
X_7319_ clknet_leaf_3_clk net156 net945 VGND VGND VPWR VPWR u_pe_array.g_pe_row\[2\].g_pe_col\[3\].u_pe.act_val\[5\]
+ sky130_fd_sc_hd__dfrtp_2
Xhold294 u_pe_array.act_from_right\[0\]\[6\] VGND VGND VPWR VPWR net368 sky130_fd_sc_hd__dlygate4sd3_1
Xhold283 u_pe_array.act_from_up\[12\]\[12\] VGND VGND VPWR VPWR net357 sky130_fd_sc_hd__dlygate4sd3_1
Xhold272 u_pe_array.act_from_right\[10\]\[7\] VGND VGND VPWR VPWR net346 sky130_fd_sc_hd__dlygate4sd3_1
XTAP_1743 VGND VPWR sky130_fd_sc_hd__tapvpwrvgnd_1
XTAP_1732 VGND VPWR sky130_fd_sc_hd__tapvpwrvgnd_1
XTAP_1721 VGND VPWR sky130_fd_sc_hd__tapvpwrvgnd_1
XTAP_1710 VGND VPWR sky130_fd_sc_hd__tapvpwrvgnd_1
XFILLER_0_83_503 VGND VGND VPWR VPWR sky130_fd_sc_hd__fill_1
XFILLER_0_55_205 VGND VGND VPWR VPWR sky130_fd_sc_hd__decap_3
XFILLER_0_83_558 VGND VGND VPWR VPWR sky130_fd_sc_hd__fill_2
XFILLER_0_83_547 VGND VGND VPWR VPWR sky130_fd_sc_hd__fill_2
XFILLER_0_48_290 VGND VGND VPWR VPWR sky130_fd_sc_hd__decap_4
XFILLER_0_102_27 VGND VGND VPWR VPWR sky130_fd_sc_hd__fill_1
XFILLER_0_63_260 VGND VGND VPWR VPWR sky130_fd_sc_hd__fill_1
XFILLER_0_23_113 VGND VGND VPWR VPWR sky130_fd_sc_hd__fill_1
XFILLER_0_36_474 VGND VGND VPWR VPWR sky130_fd_sc_hd__fill_2
XFILLER_0_11_69 VGND VGND VPWR VPWR sky130_fd_sc_hd__decap_8
Xinput7 h_in1[0] VGND VGND VPWR VPWR net7 sky130_fd_sc_hd__clkbuf_1
X_4951_ u_pe_array.g_pe_row\[2\].g_pe_col\[1\].u_pe.psum_out\[4\] _1921_ _1933_ VGND
+ VGND VPWR VPWR _1934_ sky130_fd_sc_hd__a21oi_2
X_4882_ u_pe_array.g_pe_row\[2\].g_pe_col\[1\].u_pe.act_val\[1\] _1749_ _1873_ net355
+ VGND VGND VPWR VPWR _0303_ sky130_fd_sc_hd__a22o_1
XFILLER_0_86_363 VGND VGND VPWR VPWR sky130_fd_sc_hd__fill_1
X_7670_ clknet_leaf_61_clk net420 net74 VGND VGND VPWR VPWR u_pe_array.g_pe_row\[0\].g_pe_col\[3\].u_pe.act_val\[2\]
+ sky130_fd_sc_hd__dfrtp_2
X_3902_ u_pe_array.g_pe_row\[3\].g_pe_col\[2\].u_pe.move_reg\[7\] _1118_ VGND VGND
+ VPWR VPWR _1140_ sky130_fd_sc_hd__or2_1
XFILLER_0_46_205 VGND VGND VPWR VPWR sky130_fd_sc_hd__fill_2
XFILLER_0_52_43 VGND VGND VPWR VPWR sky130_fd_sc_hd__fill_2
XFILLER_0_52_65 VGND VGND VPWR VPWR sky130_fd_sc_hd__decap_3
X_6621_ u_pe_array.g_pe_row\[0\].g_pe_col\[0\].u_pe.psum_out\[5\] u_pe_array.g_pe_row\[0\].g_pe_col\[0\].u_pe.act_val\[5\]
+ _3102_ VGND VGND VPWR VPWR _3235_ sky130_fd_sc_hd__mux2_2
X_3833_ _1033_ _1082_ _1083_ _0986_ net789 VGND VGND VPWR VPWR _0052_ sky130_fd_sc_hd__a32o_1
XFILLER_0_74_536 VGND VGND VPWR VPWR sky130_fd_sc_hd__decap_4
XFILLER_0_117_649 VPWR VGND VPWR VGND sky130_ef_sc_hd__decap_12
XFILLER_0_15_603 VPWR VGND VPWR VGND sky130_ef_sc_hd__decap_12
X_6552_ _3174_ _3179_ VGND VGND VPWR VPWR _3180_ sky130_fd_sc_hd__or2_1
X_3764_ _0977_ VGND VGND VPWR VPWR _1021_ sky130_fd_sc_hd__buf_6
X_6483_ u_pe_array.g_pe_row\[0\].g_pe_col\[1\].u_pe.psum_out\[0\] u_pe_array.g_pe_row\[0\].g_pe_col\[1\].u_pe.act_val\[0\]
+ u_pe_array.g_pe_row\[0\].g_pe_col\[1\].u_pe.w_out\[0\] VGND VGND VPWR VPWR _3117_
+ sky130_fd_sc_hd__and3_1
XFILLER_0_54_293 VPWR VGND VPWR VGND sky130_ef_sc_hd__decap_12
XFILLER_0_15_669 VGND VGND VPWR VPWR sky130_fd_sc_hd__decap_3
X_5503_ _2320_ _2363_ _2364_ _2343_ net763 VGND VGND VPWR VPWR _0441_ sky130_fd_sc_hd__a32o_1
X_3695_ net9 u_pe_array.act_from_left\[15\]\[2\] _0963_ VGND VGND VPWR VPWR _0966_
+ sky130_fd_sc_hd__mux2_1
X_5434_ net240 _2312_ _2273_ VGND VGND VPWR VPWR _2313_ sky130_fd_sc_hd__mux2_1
XFILLER_0_112_365 VPWR VGND VPWR VGND sky130_ef_sc_hd__decap_12
X_5365_ _2258_ _2259_ VGND VGND VPWR VPWR _2260_ sky130_fd_sc_hd__or2_1
X_7104_ clknet_leaf_87_clk _0010_ VGND VGND VPWR VPWR u_pe_array.u_fifo2.buffer\[8\]\[1\]
+ sky130_fd_sc_hd__dfxtp_1
X_4316_ _1457_ VGND VGND VPWR VPWR _0161_ sky130_fd_sc_hd__clkbuf_1
XFILLER_0_77_84 VGND VGND VPWR VPWR sky130_fd_sc_hd__decap_8
X_5296_ u_pe_array.g_pe_row\[1\].g_pe_col\[3\].u_pe.act_val\[3\] _2164_ _2195_ _2196_
+ VGND VGND VPWR VPWR _2198_ sky130_fd_sc_hd__o22a_1
XFILLER_0_10_374 VGND VGND VPWR VPWR sky130_fd_sc_hd__decap_3
X_4247_ _1395_ _1397_ _1402_ VGND VGND VPWR VPWR _1403_ sky130_fd_sc_hd__o21ai_1
X_7035_ net615 _3362_ _3506_ VGND VGND VPWR VPWR _3512_ sky130_fd_sc_hd__mux2_1
X_4178_ _1325_ _1326_ _1339_ VGND VGND VPWR VPWR _1340_ sky130_fd_sc_hd__o21a_1
XFILLER_0_97_617 VGND VGND VPWR VPWR sky130_fd_sc_hd__decap_3
XTAP_1028 VGND VPWR sky130_fd_sc_hd__tapvpwrvgnd_1
XTAP_1017 VGND VPWR sky130_fd_sc_hd__tapvpwrvgnd_1
XTAP_1006 VGND VPWR sky130_fd_sc_hd__tapvpwrvgnd_1
X_7937_ clknet_leaf_77_clk _0842_ VGND VGND VPWR VPWR u_pe_array.u_fifo1.buffer\[6\]\[3\]
+ sky130_fd_sc_hd__dfxtp_1
XTAP_1039 VGND VPWR sky130_fd_sc_hd__tapvpwrvgnd_1
X_7868_ clknet_leaf_101_clk _0773_ VGND VGND VPWR VPWR u_pe_array.u_fifo2.buffer\[5\]\[2\]
+ sky130_fd_sc_hd__dfxtp_1
XFILLER_0_92_322 VGND VGND VPWR VPWR sky130_fd_sc_hd__fill_2
X_6819_ net909 _3380_ _3384_ VGND VGND VPWR VPWR _0737_ sky130_fd_sc_hd__o21a_1
XFILLER_0_108_638 VGND VGND VPWR VPWR sky130_fd_sc_hd__decap_6
X_7799_ clknet_leaf_50_clk net288 net74 VGND VGND VPWR VPWR u_pe_array.g_pe_row\[0\].g_pe_col\[0\].u_pe.move_reg\[7\]
+ sky130_fd_sc_hd__dfrtp_1
XFILLER_0_18_441 VGND VGND VPWR VPWR sky130_fd_sc_hd__fill_1
XFILLER_0_33_444 VGND VGND VPWR VPWR sky130_fd_sc_hd__decap_4
XFILLER_0_116_693 VGND VGND VPWR VPWR sky130_fd_sc_hd__decap_6
XFILLER_0_115_181 VPWR VGND VPWR VGND sky130_ef_sc_hd__decap_12
XFILLER_0_103_310 VPWR VGND VPWR VGND sky130_ef_sc_hd__decap_12
XFILLER_0_20_138 VGND VGND VPWR VPWR sky130_fd_sc_hd__fill_2
XFILLER_0_33_499 VGND VGND VPWR VPWR sky130_fd_sc_hd__decap_4
XFILLER_0_87_127 VGND VGND VPWR VPWR sky130_fd_sc_hd__decap_3
XTAP_1551 VGND VPWR sky130_fd_sc_hd__tapvpwrvgnd_1
XTAP_1540 VGND VPWR sky130_fd_sc_hd__tapvpwrvgnd_1
XFILLER_0_68_374 VGND VGND VPWR VPWR sky130_fd_sc_hd__fill_1
XFILLER_0_56_503 VGND VGND VPWR VPWR sky130_fd_sc_hd__fill_2
XFILLER_0_113_15 VPWR VGND VPWR VGND sky130_ef_sc_hd__decap_12
XTAP_1573 VGND VPWR sky130_fd_sc_hd__tapvpwrvgnd_1
XTAP_1584 VGND VPWR sky130_fd_sc_hd__tapvpwrvgnd_1
XTAP_1562 VGND VPWR sky130_fd_sc_hd__tapvpwrvgnd_1
XPHY_80 VGND VGND VPWR VPWR sky130_fd_sc_hd__decap_3
XPHY_91 VGND VGND VPWR VPWR sky130_fd_sc_hd__decap_3
XTAP_1595 VGND VPWR sky130_fd_sc_hd__tapvpwrvgnd_1
XFILLER_0_83_399 VGND VGND VPWR VPWR sky130_fd_sc_hd__fill_1
XFILLER_0_83_388 VGND VGND VPWR VPWR sky130_fd_sc_hd__decap_4
XFILLER_0_71_539 VGND VGND VPWR VPWR sky130_fd_sc_hd__fill_1
XFILLER_0_22_79 VGND VGND VPWR VPWR sky130_fd_sc_hd__decap_4
XFILLER_0_107_671 VGND VGND VPWR VPWR sky130_fd_sc_hd__fill_1
XFILLER_0_12_628 VPWR VGND VPWR VGND sky130_ef_sc_hd__decap_12
X_5150_ _2083_ _2089_ VGND VGND VPWR VPWR _2090_ sky130_fd_sc_hd__nand2_1
XFILLER_0_20_683 VPWR VGND VPWR VGND sky130_ef_sc_hd__decap_12
X_5081_ u_pe_array.g_pe_row\[2\].g_pe_col\[0\].u_pe.act_val\[1\] _1286_ VGND VGND
+ VPWR VPWR _2026_ sky130_fd_sc_hd__or2b_1
X_4101_ net355 _1167_ _1169_ _1290_ VGND VGND VPWR VPWR _0113_ sky130_fd_sc_hd__a22o_1
XFILLER_0_44_9 VGND VGND VPWR VPWR sky130_fd_sc_hd__decap_8
X_4032_ _1228_ _1229_ _1231_ VGND VGND VPWR VPWR _1232_ sky130_fd_sc_hd__and3_1
XFILLER_0_79_617 VPWR VGND VPWR VGND sky130_ef_sc_hd__decap_12
XFILLER_0_78_105 VGND VGND VPWR VPWR sky130_fd_sc_hd__decap_8
XFILLER_0_63_75 VGND VGND VPWR VPWR sky130_fd_sc_hd__fill_1
X_5983_ u_pe_array.g_pe_row\[1\].g_pe_col\[0\].u_pe.psum_out\[1\] _2737_ VGND VGND
+ VPWR VPWR _2739_ sky130_fd_sc_hd__nand2_1
X_4934_ _1906_ _1915_ _1914_ VGND VGND VPWR VPWR _1918_ sky130_fd_sc_hd__a21oi_1
X_7722_ clknet_leaf_75_clk _0628_ net949 VGND VGND VPWR VPWR u_pe_array.g_pe_row\[0\].g_pe_col\[2\].u_pe.psum_out\[0\]
+ sky130_fd_sc_hd__dfrtp_1
XFILLER_0_47_514 VGND VGND VPWR VPWR sky130_fd_sc_hd__decap_3
XFILLER_0_74_322 VPWR VGND VPWR VGND sky130_ef_sc_hd__decap_12
X_4865_ u_pe_array.g_pe_row\[2\].g_pe_col\[1\].u_pe.psum_out\[5\] u_pe_array.g_pe_row\[2\].g_pe_col\[1\].u_pe.act_val\[5\]
+ _1867_ VGND VGND VPWR VPWR _1874_ sky130_fd_sc_hd__mux2_1
X_7653_ clknet_leaf_83_clk _0559_ net948 VGND VGND VPWR VPWR u_pe_array.g_pe_row\[0\].g_pe_col\[2\].u_pe.w_out\[0\]
+ sky130_fd_sc_hd__dfrtp_1
XANTENNA_12 net21 VGND VGND VPWR VPWR sky130_fd_sc_hd__diode_2
X_6604_ u_pe_array.g_pe_row\[0\].g_pe_col\[1\].u_pe.psum_out\[12\] _3218_ VGND VGND
+ VPWR VPWR _3226_ sky130_fd_sc_hd__xnor2_1
X_3816_ u_pe_array.g_pe_row\[3\].g_pe_col\[3\].u_pe.psum_out\[7\] VGND VGND VPWR VPWR
+ _1068_ sky130_fd_sc_hd__inv_2
X_7584_ clknet_leaf_65_clk net188 net946 VGND VGND VPWR VPWR u_pe_array.g_pe_row\[1\].g_pe_col\[1\].u_pe.move_reg\[11\]
+ sky130_fd_sc_hd__dfrtp_1
XFILLER_0_6_121 VPWR VGND VPWR VGND sky130_ef_sc_hd__decap_12
X_4796_ _1807_ _1809_ VGND VGND VPWR VPWR _1818_ sky130_fd_sc_hd__nor2_1
X_6535_ u_pe_array.g_pe_row\[0\].g_pe_col\[1\].u_pe.psum_out\[4\] _3151_ _3163_ VGND
+ VGND VPWR VPWR _3164_ sky130_fd_sc_hd__a21oi_2
XFILLER_0_103_81 VPWR VGND VPWR VGND sky130_ef_sc_hd__decap_12
XFILLER_0_6_165 VPWR VGND VPWR VGND sky130_ef_sc_hd__decap_12
X_3747_ _0985_ VGND VGND VPWR VPWR _1005_ sky130_fd_sc_hd__buf_8
X_6466_ net342 _3101_ _2987_ _3114_ VGND VGND VPWR VPWR _0654_ sky130_fd_sc_hd__a22o_1
XFILLER_0_88_61 VGND VGND VPWR VPWR sky130_fd_sc_hd__decap_6
X_3678_ net441 _0949_ _0944_ _0956_ VGND VGND VPWR VPWR _0024_ sky130_fd_sc_hd__a22o_1
XFILLER_0_113_685 VPWR VGND VPWR VGND sky130_ef_sc_hd__decap_12
XFILLER_0_112_173 VGND VGND VPWR VPWR sky130_fd_sc_hd__decap_6
XFILLER_0_100_302 VGND VGND VPWR VPWR sky130_fd_sc_hd__fill_1
X_5417_ u_pe_array.g_pe_row\[1\].g_pe_col\[2\].u_pe.psum_out\[8\] _1108_ _1110_ _2299_
+ VGND VGND VPWR VPWR _2300_ sky130_fd_sc_hd__o211a_1
X_6397_ _3029_ _3030_ _3063_ VGND VGND VPWR VPWR _3064_ sky130_fd_sc_hd__or3_1
XFILLER_0_112_195 VGND VGND VPWR VPWR sky130_fd_sc_hd__fill_1
X_5348_ u_pe_array.g_pe_row\[1\].g_pe_col\[3\].u_pe.psum_out\[9\] _1426_ VGND VGND
+ VPWR VPWR _2245_ sky130_fd_sc_hd__or2_1
X_5279_ _1884_ _2181_ _2182_ _2173_ net541 VGND VGND VPWR VPWR _0399_ sky130_fd_sc_hd__a32o_1
X_7018_ net672 _3358_ _3499_ VGND VGND VPWR VPWR _3503_ sky130_fd_sc_hd__mux2_1
XFILLER_0_84_108 VGND VGND VPWR VPWR sky130_fd_sc_hd__decap_8
XFILLER_0_78_650 VGND VGND VPWR VPWR sky130_fd_sc_hd__decap_8
XFILLER_0_38_503 VGND VGND VPWR VPWR sky130_fd_sc_hd__fill_1
XFILLER_0_93_697 VGND VGND VPWR VPWR sky130_fd_sc_hd__decap_8
XFILLER_0_21_436 VGND VGND VPWR VPWR sky130_fd_sc_hd__fill_1
XTAP_609 VGND VPWR sky130_fd_sc_hd__tapvpwrvgnd_1
XFILLER_0_108_15 VPWR VGND VPWR VGND sky130_ef_sc_hd__decap_12
XFILLER_0_17_57 VGND VGND VPWR VPWR sky130_fd_sc_hd__decap_8
XFILLER_0_8_419 VGND VGND VPWR VPWR sky130_fd_sc_hd__fill_1
XFILLER_0_29_536 VGND VGND VPWR VPWR sky130_fd_sc_hd__fill_1
XTAP_1392 VGND VPWR sky130_fd_sc_hd__tapvpwrvgnd_1
XTAP_1381 VGND VPWR sky130_fd_sc_hd__tapvpwrvgnd_1
XTAP_1370 VGND VPWR sky130_fd_sc_hd__tapvpwrvgnd_1
XFILLER_0_84_664 VGND VGND VPWR VPWR sky130_fd_sc_hd__fill_1
XFILLER_0_84_697 VGND VGND VPWR VPWR sky130_fd_sc_hd__decap_3
XFILLER_0_44_517 VGND VGND VPWR VPWR sky130_fd_sc_hd__fill_1
X_4650_ u_pe_array.g_pe_row\[2\].g_pe_col\[3\].u_pe.psum_out\[10\] _1427_ VGND VGND
+ VPWR VPWR _1710_ sky130_fd_sc_hd__nand2_1
XFILLER_0_116_3 VGND VGND VPWR VPWR sky130_fd_sc_hd__decap_4
XFILLER_0_114_405 VGND VGND VPWR VPWR sky130_fd_sc_hd__decap_4
Xinput10 h_in1[3] VGND VGND VPWR VPWR net10 sky130_fd_sc_hd__buf_2
XFILLER_0_83_196 VGND VGND VPWR VPWR sky130_fd_sc_hd__fill_1
XFILLER_0_4_625 VPWR VGND VPWR VGND sky130_ef_sc_hd__decap_12
X_3601_ _0853_ _0862_ VGND VGND VPWR VPWR _0900_ sky130_fd_sc_hd__nor2_1
Xinput21 v_in1[0] VGND VGND VPWR VPWR net21 sky130_fd_sc_hd__clkbuf_2
XFILLER_0_71_369 VGND VGND VPWR VPWR sky130_fd_sc_hd__decap_6
XFILLER_0_3_113 VPWR VGND VPWR VGND sky130_ef_sc_hd__decap_12
XFILLER_0_24_241 VGND VGND VPWR VPWR sky130_fd_sc_hd__decap_4
X_4581_ u_pe_array.g_pe_row\[2\].g_pe_col\[3\].u_pe.act_val\[4\] _1424_ VGND VGND
+ VPWR VPWR _1647_ sky130_fd_sc_hd__nand2_1
Xinput32 w_in_flat[5] VGND VGND VPWR VPWR net32 sky130_fd_sc_hd__buf_1
X_6320_ u_pe_array.g_pe_row\[0\].g_pe_col\[2\].u_pe.act_val\[1\] _2128_ _2992_ _2993_
+ VGND VGND VPWR VPWR _2994_ sky130_fd_sc_hd__nand4_1
Xhold805 u_pe_array.act_from_up\[12\]\[1\] VGND VGND VPWR VPWR net879 sky130_fd_sc_hd__dlygate4sd3_1
Xhold816 u_pe_array.act_from_left\[13\]\[4\] VGND VGND VPWR VPWR net890 sky130_fd_sc_hd__dlygate4sd3_1
XFILLER_0_4_669 VGND VGND VPWR VPWR sky130_fd_sc_hd__decap_8
Xhold827 u_pe_array.g_pe_row\[1\].g_pe_col\[0\].u_pe.psum_out\[2\] VGND VGND VPWR
+ VPWR net901 sky130_fd_sc_hd__dlygate4sd3_1
XFILLER_0_52_594 VGND VGND VPWR VPWR sky130_fd_sc_hd__decap_4
X_6251_ _2955_ _2956_ VGND VGND VPWR VPWR _2957_ sky130_fd_sc_hd__nand2_1
Xhold838 u_pe_array.g_pe_row\[0\].g_pe_col\[2\].u_pe.psum_out\[9\] VGND VGND VPWR
+ VPWR net912 sky130_fd_sc_hd__dlygate4sd3_1
Xhold849 u_pe_array.g_pe_row\[0\].g_pe_col\[2\].u_pe.psum_out\[10\] VGND VGND VPWR
+ VPWR net923 sky130_fd_sc_hd__dlygate4sd3_1
X_6182_ u_pe_array.g_pe_row\[0\].g_pe_col\[3\].u_pe.act_val\[4\] u_pe_array.g_pe_row\[0\].g_pe_col\[3\].u_pe.w_out\[0\]
+ VGND VGND VPWR VPWR _2894_ sky130_fd_sc_hd__nand2_1
X_5202_ u_pe_array.g_pe_row\[1\].g_pe_col\[3\].u_pe.psum_out\[0\] u_pe_array.g_pe_row\[1\].g_pe_col\[3\].u_pe.act_val\[0\]
+ _2133_ VGND VGND VPWR VPWR _2134_ sky130_fd_sc_hd__mux2_1
XFILLER_0_110_699 VGND VGND VPWR VPWR sky130_fd_sc_hd__fill_1
X_5133_ _2072_ _1286_ u_pe_array.g_pe_row\[2\].g_pe_col\[0\].u_pe.psum_out\[6\] VGND
+ VGND VPWR VPWR _2074_ sky130_fd_sc_hd__a21o_1
X_5064_ u_pe_array.act_from_right\[8\]\[8\] _1750_ _1883_ net328 VGND VGND VPWR VPWR
+ _0351_ sky130_fd_sc_hd__a22o_1
XFILLER_0_74_85 VGND VGND VPWR VPWR sky130_fd_sc_hd__decap_6
X_4015_ _1214_ _1215_ VGND VGND VPWR VPWR _1217_ sky130_fd_sc_hd__nand2_1
XFILLER_0_79_447 VGND VGND VPWR VPWR sky130_fd_sc_hd__fill_1
XFILLER_0_94_417 VGND VGND VPWR VPWR sky130_fd_sc_hd__decap_3
X_5966_ u_pe_array.act_from_up\[4\]\[6\] _2016_ _2511_ net297 VGND VGND VPWR VPWR
+ _0539_ sky130_fd_sc_hd__a22o_1
X_4917_ _1895_ _1901_ _1003_ VGND VGND VPWR VPWR _1903_ sky130_fd_sc_hd__a21o_1
XFILLER_0_74_141 VGND VGND VPWR VPWR sky130_fd_sc_hd__decap_8
X_7705_ clknet_leaf_61_clk net649 net72 VGND VGND VPWR VPWR u_pe_array.act_from_up\[6\]\[9\]
+ sky130_fd_sc_hd__dfrtp_1
X_5897_ _2674_ VGND VGND VPWR VPWR _0525_ sky130_fd_sc_hd__clkbuf_1
X_4848_ u_pe_array.g_pe_row\[1\].g_pe_col\[0\].u_pe.w_out\[0\] _1284_ _0931_ VGND
+ VGND VPWR VPWR _1864_ sky130_fd_sc_hd__mux2_1
X_7636_ clknet_leaf_62_clk net300 net74 VGND VGND VPWR VPWR u_pe_array.g_pe_row\[1\].g_pe_col\[0\].u_pe.move_reg\[9\]
+ sky130_fd_sc_hd__dfrtp_1
XFILLER_0_105_449 VGND VGND VPWR VPWR sky130_fd_sc_hd__decap_4
X_7567_ clknet_leaf_46_clk _0473_ net947 VGND VGND VPWR VPWR u_pe_array.act_from_down\[1\]\[7\]
+ sky130_fd_sc_hd__dfrtp_1
X_4779_ _0985_ VGND VGND VPWR VPWR _1803_ sky130_fd_sc_hd__buf_8
XFILLER_0_43_561 VPWR VGND VPWR VGND sky130_ef_sc_hd__decap_12
X_6518_ _3136_ _3145_ _3144_ VGND VGND VPWR VPWR _3148_ sky130_fd_sc_hd__a21oi_1
XFILLER_0_99_93 VGND VGND VPWR VPWR sky130_fd_sc_hd__decap_8
X_7498_ clknet_leaf_37_clk _0404_ net947 VGND VGND VPWR VPWR u_pe_array.g_pe_row\[1\].g_pe_col\[3\].u_pe.psum_out\[7\]
+ sky130_fd_sc_hd__dfrtp_2
XFILLER_0_15_296 VGND VGND VPWR VPWR sky130_fd_sc_hd__fill_2
X_6449_ u_pe_array.g_pe_row\[0\].g_pe_col\[1\].u_pe.psum_out\[3\] u_pe_array.g_pe_row\[0\].g_pe_col\[1\].u_pe.act_val\[3\]
+ _3102_ VGND VGND VPWR VPWR _3106_ sky130_fd_sc_hd__mux2_1
XFILLER_0_101_655 VPWR VGND VPWR VGND sky130_ef_sc_hd__decap_12
XFILLER_0_30_277 VGND VGND VPWR VPWR sky130_fd_sc_hd__fill_1
XFILLER_0_98_701 VGND VGND VPWR VPWR sky130_fd_sc_hd__decap_4
XFILLER_0_66_642 VGND VGND VPWR VPWR sky130_fd_sc_hd__fill_2
XFILLER_0_26_528 VGND VGND VPWR VPWR sky130_fd_sc_hd__decap_4
XFILLER_0_80_133 VGND VGND VPWR VPWR sky130_fd_sc_hd__decap_6
XFILLER_0_80_111 VGND VGND VPWR VPWR sky130_fd_sc_hd__fill_2
XFILLER_0_65_196 VGND VGND VPWR VPWR sky130_fd_sc_hd__decap_8
XFILLER_0_65_185 VGND VGND VPWR VPWR sky130_fd_sc_hd__fill_2
XFILLER_0_22_701 VGND VGND VPWR VPWR sky130_fd_sc_hd__decap_4
XFILLER_0_110_27 VGND VGND VPWR VPWR sky130_fd_sc_hd__fill_1
XFILLER_0_1_617 VPWR VGND VPWR VGND sky130_ef_sc_hd__decap_12
XFILLER_0_21_200 VGND VGND VPWR VPWR sky130_fd_sc_hd__fill_1
XFILLER_0_21_233 VGND VGND VPWR VPWR sky130_fd_sc_hd__fill_1
XTAP_406 VGND VPWR sky130_fd_sc_hd__tapvpwrvgnd_1
XTAP_417 VGND VPWR sky130_fd_sc_hd__tapvpwrvgnd_1
XTAP_428 VGND VPWR sky130_fd_sc_hd__tapvpwrvgnd_1
XTAP_439 VGND VPWR sky130_fd_sc_hd__tapvpwrvgnd_1
XFILLER_0_28_56 VGND VGND VPWR VPWR sky130_fd_sc_hd__decap_4
XFILLER_0_88_277 VGND VGND VPWR VPWR sky130_fd_sc_hd__decap_6
X_5820_ _2611_ _2613_ _2618_ VGND VGND VPWR VPWR _2620_ sky130_fd_sc_hd__or3_1
X_5751_ _2555_ _2556_ VGND VGND VPWR VPWR _2557_ sky130_fd_sc_hd__xnor2_2
X_4702_ net87 _1732_ _1735_ _1746_ VGND VGND VPWR VPWR _0258_ sky130_fd_sc_hd__a22o_1
X_7421_ clknet_leaf_28_clk _0327_ net71 VGND VGND VPWR VPWR u_pe_array.g_pe_row\[2\].g_pe_col\[1\].u_pe.psum_out\[12\]
+ sky130_fd_sc_hd__dfrtp_1
X_5682_ net723 _2499_ _2491_ _2505_ VGND VGND VPWR VPWR _0479_ sky130_fd_sc_hd__a22o_1
XFILLER_0_72_656 VGND VGND VPWR VPWR sky130_fd_sc_hd__fill_2
XFILLER_0_72_645 VGND VGND VPWR VPWR sky130_fd_sc_hd__decap_8
XFILLER_0_44_325 VGND VGND VPWR VPWR sky130_fd_sc_hd__fill_2
XFILLER_0_72_667 VGND VGND VPWR VPWR sky130_fd_sc_hd__decap_8
XFILLER_0_4_433 VPWR VGND VPWR VGND sky130_ef_sc_hd__decap_12
X_4633_ u_pe_array.g_pe_row\[2\].g_pe_col\[3\].u_pe.psum_out\[8\] _1427_ VGND VGND
+ VPWR VPWR _1695_ sky130_fd_sc_hd__nand2_1
XFILLER_0_71_188 VGND VGND VPWR VPWR sky130_fd_sc_hd__decap_8
Xhold602 u_pe_array.act_from_up\[14\]\[2\] VGND VGND VPWR VPWR net676 sky130_fd_sc_hd__dlygate4sd3_1
X_4564_ net376 _1273_ _1631_ _1021_ VGND VGND VPWR VPWR _0235_ sky130_fd_sc_hd__a22o_1
X_7352_ clknet_leaf_7_clk _0258_ net945 VGND VGND VPWR VPWR u_pe_array.act_from_up\[14\]\[10\]
+ sky130_fd_sc_hd__dfrtp_1
Xhold624 u_pe_array.g_pe_row\[0\].g_pe_col\[0\].u_pe.psum_out\[1\] VGND VGND VPWR
+ VPWR net698 sky130_fd_sc_hd__dlygate4sd3_1
X_7283_ clknet_leaf_12_clk net205 net942 VGND VGND VPWR VPWR u_pe_array.g_pe_row\[3\].g_pe_col\[0\].u_pe.move_reg\[10\]
+ sky130_fd_sc_hd__dfrtp_1
Xhold613 u_pe_array.g_pe_row\[3\].g_pe_col\[0\].u_pe.psum_out\[1\] VGND VGND VPWR
+ VPWR net687 sky130_fd_sc_hd__dlygate4sd3_1
X_6303_ u_pe_array.g_pe_row\[0\].g_pe_col\[2\].u_pe.act_val\[3\] _2853_ _2987_ net344
+ VGND VGND VPWR VPWR _0618_ sky130_fd_sc_hd__a22o_1
XFILLER_0_8_77 VGND VGND VPWR VPWR sky130_fd_sc_hd__decap_6
XFILLER_0_4_477 VGND VGND VPWR VPWR sky130_fd_sc_hd__decap_3
Xhold635 u_pe_array.u_fifo2.buffer\[5\]\[2\] VGND VGND VPWR VPWR net709 sky130_fd_sc_hd__dlygate4sd3_1
XFILLER_0_40_553 VGND VGND VPWR VPWR sky130_fd_sc_hd__fill_1
X_6234_ u_pe_array.g_pe_row\[0\].g_pe_col\[3\].u_pe.psum_out\[8\] _2928_ VGND VGND
+ VPWR VPWR _2942_ sky130_fd_sc_hd__nor2_1
XFILLER_0_12_266 VPWR VGND VPWR VGND sky130_ef_sc_hd__decap_12
Xhold679 u_pe_array.u_fifo2.rd_ptr\[0\] VGND VGND VPWR VPWR net753 sky130_fd_sc_hd__dlygate4sd3_1
Xhold646 u_pe_array.u_fifo2.rd_ptr\[3\] VGND VGND VPWR VPWR net720 sky130_fd_sc_hd__dlygate4sd3_1
Xhold657 u_pe_array.g_pe_row\[3\].g_pe_col\[0\].u_pe.psum_out\[12\] VGND VGND VPWR
+ VPWR net731 sky130_fd_sc_hd__dlygate4sd3_1
X_4495_ _1592_ _1593_ VGND VGND VPWR VPWR _1594_ sky130_fd_sc_hd__xnor2_1
Xhold668 u_pe_array.g_pe_row\[3\].g_pe_col\[0\].u_pe.psum_out\[5\] VGND VGND VPWR
+ VPWR net742 sky130_fd_sc_hd__dlygate4sd3_1
XFILLER_0_110_474 VGND VGND VPWR VPWR sky130_fd_sc_hd__fill_2
X_6165_ _2877_ _2878_ net323 _1007_ VGND VGND VPWR VPWR _0589_ sky130_fd_sc_hd__a2bb2o_1
XTAP_962 VGND VPWR sky130_fd_sc_hd__tapvpwrvgnd_1
XTAP_951 VGND VPWR sky130_fd_sc_hd__tapvpwrvgnd_1
XTAP_940 VGND VPWR sky130_fd_sc_hd__tapvpwrvgnd_1
XFILLER_0_40_3 VPWR VGND VPWR VGND sky130_ef_sc_hd__decap_12
X_5116_ _2046_ _2043_ _2042_ VGND VGND VPWR VPWR _2059_ sky130_fd_sc_hd__a21o_1
XFILLER_0_85_73 VGND VGND VPWR VPWR sky130_fd_sc_hd__fill_1
XTAP_995 VGND VPWR sky130_fd_sc_hd__tapvpwrvgnd_1
XTAP_984 VGND VPWR sky130_fd_sc_hd__tapvpwrvgnd_1
X_6096_ _2839_ _2840_ VGND VGND VPWR VPWR _2841_ sky130_fd_sc_hd__xnor2_1
XTAP_973 VGND VPWR sky130_fd_sc_hd__tapvpwrvgnd_1
X_5047_ net362 _2006_ _2009_ _2011_ VGND VGND VPWR VPWR _0338_ sky130_fd_sc_hd__a22o_1
XFILLER_0_79_222 VGND VGND VPWR VPWR sky130_fd_sc_hd__fill_2
X_6998_ net765 _3347_ _3491_ VGND VGND VPWR VPWR _3492_ sky130_fd_sc_hd__mux2_1
X_5949_ _2320_ _2714_ _2715_ _2343_ net745 VGND VGND VPWR VPWR _0536_ sky130_fd_sc_hd__a32o_1
XFILLER_0_47_130 VGND VGND VPWR VPWR sky130_fd_sc_hd__decap_4
XFILLER_0_48_642 VGND VGND VPWR VPWR sky130_fd_sc_hd__fill_2
XFILLER_0_118_530 VGND VGND VPWR VPWR sky130_fd_sc_hd__fill_2
XFILLER_0_63_601 VGND VGND VPWR VPWR sky130_fd_sc_hd__decap_8
XFILLER_0_23_509 VGND VGND VPWR VPWR sky130_fd_sc_hd__fill_1
X_7619_ clknet_leaf_69_clk _0525_ net72 VGND VGND VPWR VPWR u_pe_array.act_from_left\[5\]\[5\]
+ sky130_fd_sc_hd__dfrtp_1
XFILLER_0_31_542 VGND VGND VPWR VPWR sky130_fd_sc_hd__fill_1
XFILLER_0_43_391 VGND VGND VPWR VPWR sky130_fd_sc_hd__fill_1
XFILLER_0_98_597 VPWR VGND VPWR VGND sky130_ef_sc_hd__decap_12
XFILLER_0_54_601 VGND VGND VPWR VPWR sky130_fd_sc_hd__fill_2
XFILLER_0_38_141 VPWR VGND VPWR VGND sky130_ef_sc_hd__decap_12
XFILLER_0_54_645 VGND VGND VPWR VPWR sky130_fd_sc_hd__decap_4
XFILLER_0_26_336 VPWR VGND VPWR VGND sky130_ef_sc_hd__decap_12
XFILLER_0_53_111 VGND VGND VPWR VPWR sky130_fd_sc_hd__fill_1
XFILLER_0_53_177 VPWR VGND VPWR VGND sky130_ef_sc_hd__decap_12
XFILLER_0_1_447 VGND VGND VPWR VPWR sky130_fd_sc_hd__fill_1
X_4280_ u_pe_array.g_pe_row\[3\].g_pe_col\[0\].u_pe.psum_out\[0\] _1108_ _1110_ _1429_
+ VGND VGND VPWR VPWR _1430_ sky130_fd_sc_hd__o211a_2
XFILLER_0_22_597 VGND VGND VPWR VPWR sky130_fd_sc_hd__decap_3
XTAP_247 VGND VPWR sky130_fd_sc_hd__tapvpwrvgnd_1
XTAP_269 VGND VPWR sky130_fd_sc_hd__tapvpwrvgnd_1
XTAP_258 VGND VPWR sky130_fd_sc_hd__tapvpwrvgnd_1
X_6921_ _3443_ VGND VGND VPWR VPWR _0780_ sky130_fd_sc_hd__clkbuf_1
XFILLER_0_71_20 VGND VGND VPWR VPWR sky130_fd_sc_hd__decap_6
X_6852_ _3404_ VGND VGND VPWR VPWR _0750_ sky130_fd_sc_hd__clkbuf_1
X_5803_ _2595_ _2598_ _2603_ VGND VGND VPWR VPWR _2605_ sky130_fd_sc_hd__or3_1
XFILLER_0_9_503 VGND VGND VPWR VPWR sky130_fd_sc_hd__fill_1
XFILLER_0_91_217 VGND VGND VPWR VPWR sky130_fd_sc_hd__decap_6
X_3995_ _1194_ _1197_ VGND VGND VPWR VPWR _1198_ sky130_fd_sc_hd__xnor2_1
X_6783_ _3359_ VGND VGND VPWR VPWR _0726_ sky130_fd_sc_hd__clkbuf_1
XFILLER_0_115_500 VGND VGND VPWR VPWR sky130_fd_sc_hd__decap_4
X_5734_ _2540_ _2541_ VGND VGND VPWR VPWR _2542_ sky130_fd_sc_hd__or2b_1
XFILLER_0_45_656 VGND VGND VPWR VPWR sky130_fd_sc_hd__fill_2
XFILLER_0_115_533 VPWR VGND VPWR VGND sky130_ef_sc_hd__decap_12
X_5665_ net283 _2143_ _2491_ _2496_ VGND VGND VPWR VPWR _0471_ sky130_fd_sc_hd__a22o_1
XFILLER_0_88_3 VPWR VGND VPWR VGND sky130_ef_sc_hd__decap_12
X_7404_ clknet_leaf_35_clk net307 net942 VGND VGND VPWR VPWR u_pe_array.g_pe_row\[2\].g_pe_col\[1\].u_pe.move_reg\[8\]
+ sky130_fd_sc_hd__dfrtp_1
X_4616_ _1677_ _1679_ VGND VGND VPWR VPWR _1680_ sky130_fd_sc_hd__xnor2_1
XFILLER_0_111_81 VPWR VGND VPWR VGND sky130_ef_sc_hd__decap_12
Xhold410 u_pe_array.act_from_right\[8\]\[3\] VGND VGND VPWR VPWR net484 sky130_fd_sc_hd__dlygate4sd3_1
X_7335_ clknet_leaf_1_clk _0241_ net944 VGND VGND VPWR VPWR u_pe_array.g_pe_row\[2\].g_pe_col\[3\].u_pe.psum_out\[8\]
+ sky130_fd_sc_hd__dfrtp_2
X_5596_ _2436_ _2439_ _2435_ VGND VGND VPWR VPWR _2441_ sky130_fd_sc_hd__a21oi_1
Xhold443 u_pe_array.g_pe_row\[2\].g_pe_col\[0\].u_pe.psum_out\[4\] VGND VGND VPWR
+ VPWR net517 sky130_fd_sc_hd__dlygate4sd3_1
Xhold421 u_pe_array.g_pe_row\[0\].g_pe_col\[3\].u_pe.move_reg\[11\] VGND VGND VPWR
+ VPWR net495 sky130_fd_sc_hd__dlygate4sd3_1
X_4547_ _1487_ _1615_ _1616_ _1356_ net445 VGND VGND VPWR VPWR _0233_ sky130_fd_sc_hd__a32o_1
Xhold454 u_pe_array.g_pe_row\[0\].g_pe_col\[2\].u_pe.psum_out\[4\] VGND VGND VPWR
+ VPWR net528 sky130_fd_sc_hd__dlygate4sd3_1
Xhold432 u_pe_array.act_from_up\[4\]\[1\] VGND VGND VPWR VPWR net506 sky130_fd_sc_hd__dlygate4sd3_1
Xhold465 u_pe_array.g_pe_row\[1\].g_pe_col\[3\].u_pe.move_reg\[9\] VGND VGND VPWR
+ VPWR net539 sky130_fd_sc_hd__dlygate4sd3_1
X_7266_ clknet_leaf_12_clk _0172_ net942 VGND VGND VPWR VPWR u_pe_array.act_from_left\[13\]\[6\]
+ sky130_fd_sc_hd__dfrtp_1
Xhold487 u_pe_array.u_fifo1.buffer\[0\]\[0\] VGND VGND VPWR VPWR net561 sky130_fd_sc_hd__dlygate4sd3_1
Xhold476 u_pe_array.g_pe_row\[1\].g_pe_col\[2\].u_pe.psum_out\[0\] VGND VGND VPWR
+ VPWR net550 sky130_fd_sc_hd__dlygate4sd3_1
X_4478_ u_pe_array.g_pe_row\[3\].g_pe_col\[0\].u_pe.psum_out\[10\] _1287_ VGND VGND
+ VPWR VPWR _1579_ sky130_fd_sc_hd__or2_1
X_6217_ _2915_ _2917_ VGND VGND VPWR VPWR _2926_ sky130_fd_sc_hd__nor2_1
Xhold498 u_fsm.v_cnt\[0\] VGND VGND VPWR VPWR net572 sky130_fd_sc_hd__dlygate4sd3_1
X_7197_ clknet_leaf_97_clk _0103_ net950 VGND VGND VPWR VPWR u_pe_array.g_pe_row\[3\].g_pe_col\[2\].u_pe.psum_out\[6\]
+ sky130_fd_sc_hd__dfrtp_2
X_6148_ u_pe_array.g_pe_row\[0\].g_pe_col\[3\].u_pe.act_val\[1\] u_pe_array.g_pe_row\[0\].g_pe_col\[3\].u_pe.w_out\[0\]
+ VGND VGND VPWR VPWR _2863_ sky130_fd_sc_hd__nand2_1
XTAP_770 VGND VPWR sky130_fd_sc_hd__tapvpwrvgnd_1
XFILLER_0_99_317 VGND VGND VPWR VPWR sky130_fd_sc_hd__decap_4
XTAP_781 VGND VPWR sky130_fd_sc_hd__tapvpwrvgnd_1
XTAP_792 VGND VPWR sky130_fd_sc_hd__tapvpwrvgnd_1
X_6079_ u_pe_array.g_pe_row\[1\].g_pe_col\[0\].u_pe.psum_out\[10\] _1865_ VGND VGND
+ VPWR VPWR _2826_ sky130_fd_sc_hd__or2_1
XFILLER_0_67_225 VGND VGND VPWR VPWR sky130_fd_sc_hd__decap_6
XFILLER_0_67_214 VGND VGND VPWR VPWR sky130_fd_sc_hd__decap_8
XFILLER_0_82_217 VPWR VGND VPWR VGND sky130_ef_sc_hd__decap_12
XFILLER_0_35_100 VGND VGND VPWR VPWR sky130_fd_sc_hd__decap_8
XFILLER_0_118_393 VGND VGND VPWR VPWR sky130_fd_sc_hd__fill_1
XFILLER_0_36_678 VGND VGND VPWR VPWR sky130_fd_sc_hd__fill_1
XFILLER_0_51_615 VGND VGND VPWR VPWR sky130_fd_sc_hd__fill_1
XFILLER_0_23_317 VGND VGND VPWR VPWR sky130_fd_sc_hd__fill_1
XFILLER_0_35_188 VGND VGND VPWR VPWR sky130_fd_sc_hd__fill_2
XFILLER_0_51_648 VGND VGND VPWR VPWR sky130_fd_sc_hd__fill_1
XFILLER_0_101_293 VGND VGND VPWR VPWR sky130_fd_sc_hd__fill_2
XFILLER_0_58_247 VGND VGND VPWR VPWR sky130_fd_sc_hd__fill_2
XFILLER_0_39_461 VPWR VGND VPWR VGND sky130_ef_sc_hd__decap_12
XFILLER_0_41_12 VGND VGND VPWR VPWR sky130_fd_sc_hd__fill_2
X_3780_ u_pe_array.g_pe_row\[3\].g_pe_col\[3\].u_pe.act_val\[5\] u_pe_array.g_pe_row\[3\].g_pe_col\[3\].u_pe.w_out\[0\]
+ VGND VGND VPWR VPWR _1035_ sky130_fd_sc_hd__nand2_1
XFILLER_0_6_517 VGND VGND VPWR VPWR sky130_fd_sc_hd__decap_6
XFILLER_0_54_464 VGND VGND VPWR VPWR sky130_fd_sc_hd__decap_3
XFILLER_0_26_155 VPWR VGND VPWR VGND sky130_ef_sc_hd__decap_12
XFILLER_0_109_393 VGND VGND VPWR VPWR sky130_fd_sc_hd__decap_3
XFILLER_0_81_272 VGND VGND VPWR VPWR sky130_fd_sc_hd__fill_1
XFILLER_0_54_497 VGND VGND VPWR VPWR sky130_fd_sc_hd__fill_2
XFILLER_0_54_475 VGND VGND VPWR VPWR sky130_fd_sc_hd__fill_1
XFILLER_0_14_328 VPWR VGND VPWR VGND sky130_ef_sc_hd__decap_12
X_5450_ net136 _1166_ _2300_ _1476_ VGND VGND VPWR VPWR _0433_ sky130_fd_sc_hd__a22o_1
XFILLER_0_2_701 VGND VGND VPWR VPWR sky130_fd_sc_hd__decap_4
XFILLER_0_41_125 VGND VGND VPWR VPWR sky130_fd_sc_hd__fill_1
X_4401_ u_pe_array.g_pe_row\[3\].g_pe_col\[0\].u_pe.psum_out\[3\] _1508_ VGND VGND
+ VPWR VPWR _1509_ sky130_fd_sc_hd__xor2_1
X_5381_ u_pe_array.g_pe_row\[1\].g_pe_col\[2\].u_pe.psum_out\[0\] _1108_ _1110_ _2271_
+ VGND VGND VPWR VPWR _2272_ sky130_fd_sc_hd__o211a_1
XFILLER_0_41_169 VGND VGND VPWR VPWR sky130_fd_sc_hd__decap_3
X_7120_ clknet_leaf_18_clk net468 net943 VGND VGND VPWR VPWR u_pe_array.act_from_down\[11\]\[9\]
+ sky130_fd_sc_hd__dfrtp_1
XFILLER_0_1_255 VGND VGND VPWR VPWR sky130_fd_sc_hd__fill_1
X_4332_ _1469_ VGND VGND VPWR VPWR _0165_ sky130_fd_sc_hd__clkbuf_1
X_4263_ u_pe_array.g_pe_row\[3\].g_pe_col\[1\].u_pe.psum_out\[11\] _1416_ _1407_ VGND
+ VGND VPWR VPWR _1417_ sky130_fd_sc_hd__mux2_1
X_7051_ u_pe_array.u_fifo1.wr_ptr\[0\] _3458_ _3513_ VGND VGND VPWR VPWR _3521_ sky130_fd_sc_hd__and3_2
XFILLER_0_66_53 VPWR VGND VPWR VGND sky130_ef_sc_hd__decap_12
XFILLER_0_10_589 VGND VGND VPWR VPWR sky130_fd_sc_hd__decap_4
X_6002_ u_pe_array.g_pe_row\[1\].g_pe_col\[0\].u_pe.act_val\[2\] u_pe_array.g_pe_row\[1\].g_pe_col\[0\].u_pe.w_out\[0\]
+ _2743_ VGND VGND VPWR VPWR _2756_ sky130_fd_sc_hd__and3_1
X_4194_ _1352_ _1353_ VGND VGND VPWR VPWR _1355_ sky130_fd_sc_hd__nand2_1
XFILLER_0_66_75 VGND VGND VPWR VPWR sky130_fd_sc_hd__decap_8
XFILLER_0_82_41 VPWR VGND VPWR VGND sky130_ef_sc_hd__decap_12
XFILLER_0_89_361 VGND VGND VPWR VPWR sky130_fd_sc_hd__decap_8
X_6904_ _0922_ net709 _3431_ VGND VGND VPWR VPWR _3434_ sky130_fd_sc_hd__mux2_1
X_7884_ clknet_leaf_18_clk _0789_ net943 VGND VGND VPWR VPWR u_pe_array.g_pe_row\[3\].g_pe_col\[3\].u_pe.w_out\[0\]
+ sky130_fd_sc_hd__dfrtp_4
XFILLER_0_49_225 VGND VGND VPWR VPWR sky130_fd_sc_hd__decap_6
X_6835_ net553 _0922_ _3392_ VGND VGND VPWR VPWR _3395_ sky130_fd_sc_hd__mux2_1
XFILLER_0_9_333 VGND VGND VPWR VPWR sky130_fd_sc_hd__decap_3
X_6766_ net583 _0986_ _3346_ _0978_ VGND VGND VPWR VPWR _0722_ sky130_fd_sc_hd__a22o_1
XFILLER_0_17_111 VGND VGND VPWR VPWR sky130_fd_sc_hd__fill_1
XFILLER_0_18_645 VGND VGND VPWR VPWR sky130_fd_sc_hd__decap_4
X_3978_ u_pe_array.g_pe_row\[3\].g_pe_col\[2\].u_pe.act_val\[1\] u_pe_array.g_pe_row\[3\].g_pe_col\[2\].u_pe.w_out\[0\]
+ _1180_ _1181_ VGND VGND VPWR VPWR _1183_ sky130_fd_sc_hd__a22o_1
X_5717_ _2524_ _2525_ VGND VGND VPWR VPWR _2526_ sky130_fd_sc_hd__xnor2_1
XFILLER_0_17_144 VGND VGND VPWR VPWR sky130_fd_sc_hd__decap_4
X_6697_ u_pe_array.g_pe_row\[0\].g_pe_col\[0\].u_pe.act_val\[5\] _2486_ u_pe_array.g_pe_row\[0\].g_pe_col\[0\].u_pe.psum_out\[5\]
+ VGND VGND VPWR VPWR _3285_ sky130_fd_sc_hd__a21oi_1
X_5648_ _2486_ u_pe_array.g_pe_row\[1\].g_pe_col\[0\].u_pe.w_out\[0\] _0931_ VGND
+ VGND VPWR VPWR _2487_ sky130_fd_sc_hd__mux2_1
XFILLER_0_72_294 VGND VGND VPWR VPWR sky130_fd_sc_hd__decap_4
XFILLER_0_5_561 VPWR VGND VPWR VGND sky130_ef_sc_hd__decap_12
XFILLER_0_33_659 VPWR VGND VPWR VGND sky130_ef_sc_hd__decap_12
XFILLER_0_20_309 VGND VGND VPWR VPWR sky130_fd_sc_hd__fill_1
X_5579_ _2411_ _2421_ _2425_ VGND VGND VPWR VPWR _2426_ sky130_fd_sc_hd__o21a_1
Xhold262 _0627_ VGND VGND VPWR VPWR net336 sky130_fd_sc_hd__dlygate4sd3_1
Xhold251 _0621_ VGND VGND VPWR VPWR net325 sky130_fd_sc_hd__dlygate4sd3_1
XFILLER_0_41_692 VPWR VGND VPWR VGND sky130_ef_sc_hd__decap_12
Xhold240 u_pe_array.g_pe_row\[2\].g_pe_col\[2\].u_pe.move_reg\[11\] VGND VGND VPWR
+ VPWR net314 sky130_fd_sc_hd__dlygate4sd3_1
X_7318_ clknet_leaf_3_clk net120 net945 VGND VGND VPWR VPWR u_pe_array.g_pe_row\[2\].g_pe_col\[3\].u_pe.act_val\[4\]
+ sky130_fd_sc_hd__dfrtp_2
Xhold295 _0649_ VGND VGND VPWR VPWR net369 sky130_fd_sc_hd__dlygate4sd3_1
Xhold284 _0191_ VGND VGND VPWR VPWR net358 sky130_fd_sc_hd__dlygate4sd3_1
X_7249_ clknet_leaf_4_clk _0155_ net69 VGND VGND VPWR VPWR net54 sky130_fd_sc_hd__dfrtp_1
Xhold273 u_pe_array.act_from_right\[13\]\[8\] VGND VGND VPWR VPWR net347 sky130_fd_sc_hd__dlygate4sd3_1
XTAP_1700 VGND VPWR sky130_fd_sc_hd__tapvpwrvgnd_1
XTAP_1733 VGND VPWR sky130_fd_sc_hd__tapvpwrvgnd_1
XTAP_1722 VGND VPWR sky130_fd_sc_hd__tapvpwrvgnd_1
XTAP_1711 VGND VPWR sky130_fd_sc_hd__tapvpwrvgnd_1
XFILLER_0_95_320 VGND VGND VPWR VPWR sky130_fd_sc_hd__decap_4
XTAP_1744 VGND VPWR sky130_fd_sc_hd__tapvpwrvgnd_1
XFILLER_0_11_15 VPWR VGND VPWR VGND sky130_ef_sc_hd__decap_12
XFILLER_0_36_464 VGND VGND VPWR VPWR sky130_fd_sc_hd__fill_2
XFILLER_0_63_272 VGND VGND VPWR VPWR sky130_fd_sc_hd__fill_1
XFILLER_0_24_626 VGND VGND VPWR VPWR sky130_fd_sc_hd__decap_6
XFILLER_0_32_681 VPWR VGND VPWR VGND sky130_ef_sc_hd__decap_12
Xinput8 h_in1[1] VGND VGND VPWR VPWR net8 sky130_fd_sc_hd__clkbuf_1
XFILLER_0_59_512 VGND VGND VPWR VPWR sky130_fd_sc_hd__decap_4
XFILLER_0_59_501 VGND VGND VPWR VPWR sky130_fd_sc_hd__decap_3
X_4950_ u_pe_array.g_pe_row\[2\].g_pe_col\[1\].u_pe.act_val\[4\] u_pe_array.g_pe_row\[2\].g_pe_col\[1\].u_pe.w_out\[0\]
+ _1919_ VGND VGND VPWR VPWR _1933_ sky130_fd_sc_hd__and3_1
XFILLER_0_98_191 VGND VGND VPWR VPWR sky130_fd_sc_hd__decap_4
XFILLER_0_52_11 VGND VGND VPWR VPWR sky130_fd_sc_hd__fill_2
X_4881_ u_pe_array.g_pe_row\[2\].g_pe_col\[1\].u_pe.act_val\[0\] _1749_ _1873_ net340
+ VGND VGND VPWR VPWR _0302_ sky130_fd_sc_hd__a22o_1
X_3901_ _1139_ VGND VGND VPWR VPWR _0064_ sky130_fd_sc_hd__clkbuf_1
X_3832_ _1073_ _1076_ _1081_ VGND VGND VPWR VPWR _1083_ sky130_fd_sc_hd__or3_1
XFILLER_0_86_397 VGND VGND VPWR VPWR sky130_fd_sc_hd__decap_8
X_6620_ net331 _1731_ _1734_ _3234_ VGND VGND VPWR VPWR _0688_ sky130_fd_sc_hd__a22o_1
X_6551_ _3175_ _3176_ _3178_ VGND VGND VPWR VPWR _3179_ sky130_fd_sc_hd__a21oi_1
XFILLER_0_61_209 VGND VGND VPWR VPWR sky130_fd_sc_hd__fill_1
XFILLER_0_6_325 VGND VGND VPWR VPWR sky130_fd_sc_hd__fill_1
XFILLER_0_116_138 VGND VGND VPWR VPWR sky130_fd_sc_hd__fill_2
X_3763_ _1009_ _1019_ VGND VGND VPWR VPWR _1020_ sky130_fd_sc_hd__xnor2_1
XFILLER_0_15_615 VGND VGND VPWR VPWR sky130_fd_sc_hd__fill_1
XFILLER_0_15_626 VGND VGND VPWR VPWR sky130_fd_sc_hd__decap_8
X_5502_ u_pe_array.act_from_up\[6\]\[3\] _2341_ VGND VGND VPWR VPWR _2364_ sky130_fd_sc_hd__or2_1
X_6482_ u_pe_array.g_pe_row\[0\].g_pe_col\[1\].u_pe.act_val\[0\] u_pe_array.g_pe_row\[0\].g_pe_col\[1\].u_pe.w_out\[0\]
+ u_pe_array.g_pe_row\[0\].g_pe_col\[1\].u_pe.psum_out\[0\] VGND VGND VPWR VPWR _3116_
+ sky130_fd_sc_hd__a21o_1
X_3694_ net389 _0949_ _0944_ _0965_ VGND VGND VPWR VPWR _0031_ sky130_fd_sc_hd__a22o_1
X_5433_ u_pe_array.g_pe_row\[1\].g_pe_col\[2\].u_pe.psum_out\[12\] _1112_ _1109_ _2311_
+ VGND VGND VPWR VPWR _2312_ sky130_fd_sc_hd__o211a_1
XFILLER_0_2_531 VGND VGND VPWR VPWR sky130_fd_sc_hd__fill_1
XFILLER_0_23_670 VGND VGND VPWR VPWR sky130_fd_sc_hd__fill_2
XFILLER_0_30_618 VGND VGND VPWR VPWR sky130_fd_sc_hd__decap_3
X_5364_ u_pe_array.g_pe_row\[1\].g_pe_col\[3\].u_pe.psum_out\[11\] _2164_ VGND VGND
+ VPWR VPWR _2259_ sky130_fd_sc_hd__and2_1
XFILLER_0_77_30 VPWR VGND VPWR VGND sky130_ef_sc_hd__decap_12
XFILLER_0_112_377 VPWR VGND VPWR VGND sky130_ef_sc_hd__decap_12
X_4315_ net845 _1456_ _1116_ VGND VGND VPWR VPWR _1457_ sky130_fd_sc_hd__mux2_1
X_7103_ clknet_leaf_87_clk _0009_ VGND VGND VPWR VPWR u_pe_array.u_fifo2.buffer\[8\]\[0\]
+ sky130_fd_sc_hd__dfxtp_1
X_5295_ u_pe_array.g_pe_row\[1\].g_pe_col\[3\].u_pe.act_val\[3\] _2164_ _2195_ _2196_
+ VGND VGND VPWR VPWR _2197_ sky130_fd_sc_hd__nor4_1
X_4246_ _1392_ _1399_ _1400_ _1401_ VGND VGND VPWR VPWR _1402_ sky130_fd_sc_hd__a31o_1
X_7034_ _3511_ VGND VGND VPWR VPWR _0825_ sky130_fd_sc_hd__clkbuf_1
XFILLER_0_93_51 VGND VGND VPWR VPWR sky130_fd_sc_hd__decap_4
X_4177_ _1322_ _1324_ VGND VGND VPWR VPWR _1339_ sky130_fd_sc_hd__nand2_1
XFILLER_0_96_117 VGND VGND VPWR VPWR sky130_fd_sc_hd__decap_3
XTAP_1029 VGND VPWR sky130_fd_sc_hd__tapvpwrvgnd_1
XTAP_1018 VGND VPWR sky130_fd_sc_hd__tapvpwrvgnd_1
XTAP_1007 VGND VPWR sky130_fd_sc_hd__tapvpwrvgnd_1
X_7936_ clknet_leaf_79_clk _0841_ VGND VGND VPWR VPWR u_pe_array.u_fifo1.buffer\[6\]\[2\]
+ sky130_fd_sc_hd__dfxtp_1
XFILLER_0_65_515 VGND VGND VPWR VPWR sky130_fd_sc_hd__decap_8
X_7867_ clknet_leaf_101_clk _0772_ VGND VGND VPWR VPWR u_pe_array.u_fifo2.buffer\[5\]\[1\]
+ sky130_fd_sc_hd__dfxtp_1
X_6818_ u_pe_array.u_fifo2.count\[0\] _3383_ VGND VGND VPWR VPWR _3384_ sky130_fd_sc_hd__nand2_1
XFILLER_0_107_105 VGND VGND VPWR VPWR sky130_fd_sc_hd__decap_6
X_7798_ clknet_leaf_50_clk net211 net947 VGND VGND VPWR VPWR u_pe_array.g_pe_row\[0\].g_pe_col\[0\].u_pe.move_reg\[6\]
+ sky130_fd_sc_hd__dfrtp_1
XFILLER_0_18_453 VGND VGND VPWR VPWR sky130_fd_sc_hd__fill_1
XFILLER_0_92_389 VPWR VGND VPWR VGND sky130_ef_sc_hd__decap_12
X_6749_ u_pe_array.g_pe_row\[0\].g_pe_col\[0\].u_pe.psum_out\[10\] _2488_ VGND VGND
+ VPWR VPWR _3332_ sky130_fd_sc_hd__or2_1
XFILLER_0_18_475 VGND VGND VPWR VPWR sky130_fd_sc_hd__fill_1
XFILLER_0_115_193 VPWR VGND VPWR VGND sky130_ef_sc_hd__decap_12
XFILLER_0_103_322 VPWR VGND VPWR VGND sky130_ef_sc_hd__decap_12
XFILLER_0_5_391 VGND VGND VPWR VPWR sky130_fd_sc_hd__fill_1
XFILLER_0_21_629 VGND VGND VPWR VPWR sky130_fd_sc_hd__fill_1
XFILLER_0_87_117 VGND VGND VPWR VPWR sky130_fd_sc_hd__fill_1
XFILLER_0_87_106 VGND VGND VPWR VPWR sky130_fd_sc_hd__decap_6
XTAP_1541 VGND VPWR sky130_fd_sc_hd__tapvpwrvgnd_1
XTAP_1530 VGND VPWR sky130_fd_sc_hd__tapvpwrvgnd_1
XFILLER_0_113_27 VPWR VGND VPWR VGND sky130_ef_sc_hd__decap_12
XTAP_1574 VGND VPWR sky130_fd_sc_hd__tapvpwrvgnd_1
XTAP_1585 VGND VPWR sky130_fd_sc_hd__tapvpwrvgnd_1
XTAP_1563 VGND VPWR sky130_fd_sc_hd__tapvpwrvgnd_1
XTAP_1552 VGND VPWR sky130_fd_sc_hd__tapvpwrvgnd_1
XFILLER_0_56_537 VGND VGND VPWR VPWR sky130_fd_sc_hd__fill_2
XFILLER_0_28_239 VPWR VGND VPWR VGND sky130_ef_sc_hd__decap_12
XPHY_70 VGND VGND VPWR VPWR sky130_fd_sc_hd__decap_3
XPHY_81 VGND VGND VPWR VPWR sky130_fd_sc_hd__decap_3
XPHY_92 VGND VGND VPWR VPWR sky130_fd_sc_hd__decap_3
XTAP_1596 VGND VPWR sky130_fd_sc_hd__tapvpwrvgnd_1
XFILLER_0_83_345 VGND VGND VPWR VPWR sky130_fd_sc_hd__fill_2
XFILLER_0_114_609 VPWR VGND VPWR VGND sky130_ef_sc_hd__decap_12
XFILLER_0_24_401 VGND VGND VPWR VPWR sky130_fd_sc_hd__decap_3
XFILLER_0_36_250 VGND VGND VPWR VPWR sky130_fd_sc_hd__fill_2
XFILLER_0_98_29 VPWR VGND VPWR VGND sky130_ef_sc_hd__decap_12
XFILLER_0_106_193 VGND VGND VPWR VPWR sky130_fd_sc_hd__decap_3
XFILLER_0_3_328 VGND VGND VPWR VPWR sky130_fd_sc_hd__decap_8
XFILLER_0_24_456 VGND VGND VPWR VPWR sky130_fd_sc_hd__fill_1
XFILLER_0_51_242 VGND VGND VPWR VPWR sky130_fd_sc_hd__fill_2
XFILLER_0_20_695 VGND VGND VPWR VPWR sky130_fd_sc_hd__decap_4
X_5080_ u_pe_array.g_pe_row\[2\].g_pe_col\[0\].u_pe.act_val\[2\] _1284_ VGND VGND
+ VPWR VPWR _2025_ sky130_fd_sc_hd__nand2_1
X_4100_ u_pe_array.g_pe_row\[3\].g_pe_col\[1\].u_pe.psum_out\[1\] u_pe_array.g_pe_row\[3\].g_pe_col\[1\].u_pe.act_val\[1\]
+ _0947_ VGND VGND VPWR VPWR _1290_ sky130_fd_sc_hd__mux2_1
X_4031_ u_pe_array.g_pe_row\[3\].g_pe_col\[2\].u_pe.act_val\[4\] _1230_ _1221_ _1219_
+ VGND VGND VPWR VPWR _1231_ sky130_fd_sc_hd__o22ai_1
XFILLER_0_79_629 VGND VGND VPWR VPWR sky130_fd_sc_hd__fill_2
X_5982_ u_pe_array.g_pe_row\[1\].g_pe_col\[0\].u_pe.psum_out\[1\] _2737_ VGND VGND
+ VPWR VPWR _2738_ sky130_fd_sc_hd__or2_1
X_4933_ net503 _1904_ _1917_ _1726_ VGND VGND VPWR VPWR _0318_ sky130_fd_sc_hd__a22o_1
XFILLER_0_87_673 VPWR VGND VPWR VGND sky130_ef_sc_hd__decap_12
XFILLER_0_86_150 VGND VGND VPWR VPWR sky130_fd_sc_hd__fill_2
X_7721_ clknet_leaf_62_clk net336 net74 VGND VGND VPWR VPWR u_pe_array.g_pe_row\[0\].g_pe_col\[2\].u_pe.move_reg\[12\]
+ sky130_fd_sc_hd__dfrtp_1
XANTENNA_13 net35 VGND VGND VPWR VPWR sky130_fd_sc_hd__diode_2
XFILLER_0_74_334 VGND VGND VPWR VPWR sky130_fd_sc_hd__decap_4
X_4864_ _0943_ VGND VGND VPWR VPWR _1873_ sky130_fd_sc_hd__clkbuf_8
X_7652_ clknet_leaf_66_clk _0558_ net72 VGND VGND VPWR VPWR u_pe_array.g_pe_row\[1\].g_pe_col\[0\].u_pe.psum_out\[12\]
+ sky130_fd_sc_hd__dfrtp_1
X_6603_ _3210_ _3215_ _3221_ _3224_ _3220_ VGND VGND VPWR VPWR _3225_ sky130_fd_sc_hd__a32o_1
X_3815_ _1050_ _1051_ _1065_ _1066_ VGND VGND VPWR VPWR _1067_ sky130_fd_sc_hd__a31o_1
X_7583_ clknet_leaf_66_clk net96 net946 VGND VGND VPWR VPWR u_pe_array.g_pe_row\[1\].g_pe_col\[1\].u_pe.move_reg\[10\]
+ sky130_fd_sc_hd__dfrtp_1
XFILLER_0_6_133 VGND VGND VPWR VPWR sky130_fd_sc_hd__decap_6
X_4795_ _1487_ _1816_ _1817_ _1803_ net486 VGND VGND VPWR VPWR _0280_ sky130_fd_sc_hd__a32o_1
X_6534_ u_pe_array.g_pe_row\[0\].g_pe_col\[1\].u_pe.act_val\[4\] u_pe_array.g_pe_row\[0\].g_pe_col\[1\].u_pe.w_out\[0\]
+ _3149_ VGND VGND VPWR VPWR _3163_ sky130_fd_sc_hd__and3_1
XFILLER_0_103_93 VPWR VGND VPWR VGND sky130_ef_sc_hd__decap_12
X_3746_ _0995_ _1001_ _1003_ VGND VGND VPWR VPWR _1004_ sky130_fd_sc_hd__a21o_1
XFILLER_0_6_177 VPWR VGND VPWR VGND sky130_ef_sc_hd__decap_12
X_6465_ u_pe_array.g_pe_row\[0\].g_pe_col\[1\].u_pe.psum_out\[11\] u_pe_array.g_pe_row\[0\].g_pe_col\[1\].u_pe.move_reg\[11\]
+ _3102_ VGND VGND VPWR VPWR _3114_ sky130_fd_sc_hd__mux2_1
X_3677_ u_pe_array.g_pe_row\[3\].g_pe_col\[3\].u_pe.psum_out\[7\] net487 _0947_ VGND
+ VGND VPWR VPWR _0956_ sky130_fd_sc_hd__mux2_1
X_5416_ u_pe_array.g_pe_row\[1\].g_pe_col\[2\].u_pe.move_reg\[8\] net62 VGND VGND
+ VPWR VPWR _2299_ sky130_fd_sc_hd__or2_1
XFILLER_0_2_350 VGND VGND VPWR VPWR sky130_fd_sc_hd__decap_4
XFILLER_0_15_489 VGND VGND VPWR VPWR sky130_fd_sc_hd__decap_8
XFILLER_0_30_415 VGND VGND VPWR VPWR sky130_fd_sc_hd__decap_4
XFILLER_0_113_697 VGND VGND VPWR VPWR sky130_fd_sc_hd__decap_8
XFILLER_0_100_325 VPWR VGND VPWR VGND sky130_ef_sc_hd__decap_12
X_6396_ _3038_ _3039_ _3050_ _3060_ VGND VGND VPWR VPWR _3063_ sky130_fd_sc_hd__or4_1
X_5347_ u_pe_array.g_pe_row\[1\].g_pe_col\[3\].u_pe.psum_out\[9\] _1426_ VGND VGND
+ VPWR VPWR _2244_ sky130_fd_sc_hd__nand2_1
XFILLER_0_11_673 VPWR VGND VPWR VGND sky130_ef_sc_hd__decap_12
X_5278_ _2171_ _2169_ _2179_ _2180_ VGND VGND VPWR VPWR _2182_ sky130_fd_sc_hd__a211o_1
X_4229_ _1033_ _1385_ _1386_ _1356_ net388 VGND VGND VPWR VPWR _0145_ sky130_fd_sc_hd__a32o_1
X_7017_ _3502_ VGND VGND VPWR VPWR _0817_ sky130_fd_sc_hd__clkbuf_1
XFILLER_0_69_139 VGND VGND VPWR VPWR sky130_fd_sc_hd__fill_2
X_7919_ clknet_leaf_77_clk _0824_ VGND VGND VPWR VPWR u_pe_array.u_fifo1.buffer\[3\]\[3\]
+ sky130_fd_sc_hd__dfxtp_1
XFILLER_0_104_642 VGND VGND VPWR VPWR sky130_fd_sc_hd__fill_2
XFILLER_0_33_286 VGND VGND VPWR VPWR sky130_fd_sc_hd__decap_6
XFILLER_0_108_27 VGND VGND VPWR VPWR sky130_fd_sc_hd__fill_1
XFILLER_0_69_640 VPWR VGND VPWR VGND sky130_ef_sc_hd__decap_12
XFILLER_0_69_673 VGND VGND VPWR VPWR sky130_fd_sc_hd__fill_1
XFILLER_0_33_57 VPWR VGND VPWR VGND sky130_ef_sc_hd__decap_12
XTAP_1393 VGND VPWR sky130_fd_sc_hd__tapvpwrvgnd_1
XTAP_1382 VGND VPWR sky130_fd_sc_hd__tapvpwrvgnd_1
XTAP_1371 VGND VPWR sky130_fd_sc_hd__tapvpwrvgnd_1
XTAP_1360 VGND VPWR sky130_fd_sc_hd__tapvpwrvgnd_1
XFILLER_0_84_643 VGND VGND VPWR VPWR sky130_fd_sc_hd__fill_1
XFILLER_0_83_131 VPWR VGND VPWR VGND sky130_ef_sc_hd__decap_12
XFILLER_0_56_356 VGND VGND VPWR VPWR sky130_fd_sc_hd__fill_1
XFILLER_0_71_337 VGND VGND VPWR VPWR sky130_fd_sc_hd__decap_8
Xinput22 v_in1[1] VGND VGND VPWR VPWR net22 sky130_fd_sc_hd__buf_1
Xinput11 h_in1[4] VGND VGND VPWR VPWR net11 sky130_fd_sc_hd__buf_1
X_3600_ u_fsm.state\[1\] _0854_ _0898_ VGND VGND VPWR VPWR _0899_ sky130_fd_sc_hd__nor3_1
X_4580_ _1487_ _1645_ _1646_ _1356_ net343 VGND VGND VPWR VPWR _0236_ sky130_fd_sc_hd__a32o_1
Xinput33 w_in_flat[6] VGND VGND VPWR VPWR net33 sky130_fd_sc_hd__buf_1
XFILLER_0_109_3 VPWR VGND VPWR VGND sky130_ef_sc_hd__decap_12
XFILLER_0_12_404 VGND VGND VPWR VPWR sky130_fd_sc_hd__fill_1
XFILLER_0_4_637 VGND VGND VPWR VPWR sky130_fd_sc_hd__decap_6
XFILLER_0_3_125 VPWR VGND VPWR VGND sky130_ef_sc_hd__decap_12
Xhold817 u_pe_array.g_pe_row\[0\].g_pe_col\[1\].u_pe.psum_out\[9\] VGND VGND VPWR
+ VPWR net891 sky130_fd_sc_hd__dlygate4sd3_1
Xhold828 u_pe_array.g_pe_row\[1\].g_pe_col\[0\].u_pe.psum_out\[9\] VGND VGND VPWR
+ VPWR net902 sky130_fd_sc_hd__dlygate4sd3_1
Xhold806 u_pe_array.u_fifo1.count\[2\] VGND VGND VPWR VPWR net880 sky130_fd_sc_hd__dlygate4sd3_1
XFILLER_0_12_426 VGND VGND VPWR VPWR sky130_fd_sc_hd__fill_1
XFILLER_0_3_169 VPWR VGND VPWR VGND sky130_ef_sc_hd__decap_12
X_6250_ u_pe_array.g_pe_row\[0\].g_pe_col\[3\].u_pe.psum_out\[10\] _1999_ VGND VGND
+ VPWR VPWR _2956_ sky130_fd_sc_hd__or2_1
Xhold839 u_pe_array.u_fifo2.count\[3\] VGND VGND VPWR VPWR net913 sky130_fd_sc_hd__dlygate4sd3_1
XFILLER_0_110_645 VPWR VGND VPWR VGND sky130_ef_sc_hd__decap_12
X_5201_ _0946_ VGND VGND VPWR VPWR _2133_ sky130_fd_sc_hd__clkbuf_16
X_6181_ u_pe_array.g_pe_row\[0\].g_pe_col\[3\].u_pe.act_val\[3\] _1999_ VGND VGND
+ VPWR VPWR _2893_ sky130_fd_sc_hd__and2b_1
X_5132_ _2072_ u_pe_array.g_pe_row\[2\].g_pe_col\[0\].u_pe.psum_out\[6\] _1286_ VGND
+ VGND VPWR VPWR _2073_ sky130_fd_sc_hd__nand3_2
XFILLER_0_20_481 VGND VGND VPWR VPWR sky130_fd_sc_hd__decap_3
XFILLER_0_20_492 VPWR VGND VPWR VGND sky130_ef_sc_hd__decap_12
XFILLER_0_42_7 VGND VGND VPWR VPWR sky130_fd_sc_hd__fill_1
X_5063_ u_pe_array.act_from_right\[8\]\[7\] _1750_ _1883_ net220 VGND VGND VPWR VPWR
+ _0350_ sky130_fd_sc_hd__a22o_1
XFILLER_0_79_415 VGND VGND VPWR VPWR sky130_fd_sc_hd__decap_3
X_4014_ _1214_ _1215_ VGND VGND VPWR VPWR _1216_ sky130_fd_sc_hd__or2_1
XFILLER_0_90_41 VPWR VGND VPWR VGND sky130_ef_sc_hd__decap_12
XFILLER_0_59_172 VPWR VGND VPWR VGND sky130_ef_sc_hd__decap_12
X_5965_ _2320_ _2728_ _2729_ _2343_ net791 VGND VGND VPWR VPWR _0538_ sky130_fd_sc_hd__a32o_1
X_4916_ _1895_ _1901_ VGND VGND VPWR VPWR _1902_ sky130_fd_sc_hd__nor2_1
XFILLER_0_90_74 VGND VGND VPWR VPWR sky130_fd_sc_hd__fill_2
XFILLER_0_75_643 VGND VGND VPWR VPWR sky130_fd_sc_hd__decap_6
X_7704_ clknet_leaf_74_clk _0610_ net72 VGND VGND VPWR VPWR u_pe_array.act_from_up\[6\]\[8\]
+ sky130_fd_sc_hd__dfrtp_1
X_5896_ _2646_ u_pe_array.act_from_left\[5\]\[5\] _1158_ VGND VGND VPWR VPWR _2674_
+ sky130_fd_sc_hd__mux2_1
XFILLER_0_90_602 VGND VGND VPWR VPWR sky130_fd_sc_hd__decap_4
X_7635_ clknet_leaf_62_clk net229 net74 VGND VGND VPWR VPWR u_pe_array.g_pe_row\[1\].g_pe_col\[0\].u_pe.move_reg\[8\]
+ sky130_fd_sc_hd__dfrtp_1
X_4847_ net700 _1273_ _1863_ _1726_ VGND VGND VPWR VPWR _0286_ sky130_fd_sc_hd__a22o_1
XFILLER_0_47_367 VGND VGND VPWR VPWR sky130_fd_sc_hd__decap_6
XFILLER_0_105_417 VGND VGND VPWR VPWR sky130_fd_sc_hd__fill_1
XFILLER_0_74_197 VPWR VGND VPWR VGND sky130_ef_sc_hd__decap_12
X_7566_ clknet_leaf_48_clk _0472_ net947 VGND VGND VPWR VPWR u_pe_array.act_from_down\[1\]\[6\]
+ sky130_fd_sc_hd__dfrtp_1
X_4778_ _1789_ _1792_ _1800_ VGND VGND VPWR VPWR _1802_ sky130_fd_sc_hd__o21ai_1
X_6517_ net417 _2586_ _3147_ _0978_ VGND VGND VPWR VPWR _0672_ sky130_fd_sc_hd__a22o_1
X_7497_ clknet_leaf_36_clk _0403_ net951 VGND VGND VPWR VPWR u_pe_array.g_pe_row\[1\].g_pe_col\[3\].u_pe.psum_out\[6\]
+ sky130_fd_sc_hd__dfrtp_1
X_3729_ u_pe_array.g_pe_row\[3\].g_pe_col\[3\].u_pe.w_out\[1\] VGND VGND VPWR VPWR
+ _0988_ sky130_fd_sc_hd__clkbuf_8
XFILLER_0_43_584 VGND VGND VPWR VPWR sky130_fd_sc_hd__fill_1
X_6448_ net242 _3101_ _2987_ _3105_ VGND VGND VPWR VPWR _0645_ sky130_fd_sc_hd__a22o_1
XFILLER_0_70_392 VGND VGND VPWR VPWR sky130_fd_sc_hd__decap_3
XFILLER_0_113_494 VGND VGND VPWR VPWR sky130_fd_sc_hd__fill_2
XFILLER_0_100_122 VGND VGND VPWR VPWR sky130_fd_sc_hd__decap_3
X_6379_ _3044_ _3045_ _3047_ VGND VGND VPWR VPWR _3048_ sky130_fd_sc_hd__and3_1
XFILLER_0_101_667 VGND VGND VPWR VPWR sky130_fd_sc_hd__decap_4
XFILLER_0_97_267 VGND VGND VPWR VPWR sky130_fd_sc_hd__decap_4
XFILLER_0_57_109 VGND VGND VPWR VPWR sky130_fd_sc_hd__decap_3
XFILLER_0_66_665 VGND VGND VPWR VPWR sky130_fd_sc_hd__fill_2
XFILLER_0_66_687 VPWR VGND VPWR VGND sky130_ef_sc_hd__decap_12
Xclkbuf_leaf_100_clk clknet_3_1__leaf_clk VGND VGND VPWR VPWR clknet_leaf_100_clk
+ sky130_fd_sc_hd__clkbuf_16
XFILLER_0_1_629 VPWR VGND VPWR VGND sky130_ef_sc_hd__decap_12
XFILLER_0_0_139 VGND VGND VPWR VPWR sky130_fd_sc_hd__fill_1
XTAP_418 VGND VPWR sky130_fd_sc_hd__tapvpwrvgnd_1
XTAP_429 VGND VPWR sky130_fd_sc_hd__tapvpwrvgnd_1
XTAP_407 VGND VPWR sky130_fd_sc_hd__tapvpwrvgnd_1
XFILLER_0_28_13 VGND VGND VPWR VPWR sky130_fd_sc_hd__decap_6
XFILLER_0_44_89 VGND VGND VPWR VPWR sky130_fd_sc_hd__fill_2
X_5750_ u_pe_array.g_pe_row\[1\].g_pe_col\[1\].u_pe.act_val\[5\] u_pe_array.g_pe_row\[1\].g_pe_col\[1\].u_pe.w_out\[0\]
+ VGND VGND VPWR VPWR _2556_ sky130_fd_sc_hd__nand2_1
XTAP_1190 VGND VPWR sky130_fd_sc_hd__tapvpwrvgnd_1
X_5681_ u_pe_array.act_from_right\[5\]\[0\] u_pe_array.act_from_left\[5\]\[0\] _0963_
+ VGND VGND VPWR VPWR _2505_ sky130_fd_sc_hd__mux2_1
XFILLER_0_29_389 VGND VGND VPWR VPWR sky130_fd_sc_hd__decap_3
X_4701_ u_pe_array.g_pe_row\[2\].g_pe_col\[2\].u_pe.psum_out\[10\] u_pe_array.g_pe_row\[2\].g_pe_col\[2\].u_pe.move_reg\[10\]
+ _1599_ VGND VGND VPWR VPWR _1746_ sky130_fd_sc_hd__mux2_1
X_7420_ clknet_leaf_29_clk _0326_ net71 VGND VGND VPWR VPWR u_pe_array.g_pe_row\[2\].g_pe_col\[1\].u_pe.psum_out\[11\]
+ sky130_fd_sc_hd__dfrtp_2
XFILLER_0_71_123 VGND VGND VPWR VPWR sky130_fd_sc_hd__decap_3
XFILLER_0_56_197 VGND VGND VPWR VPWR sky130_fd_sc_hd__fill_1
X_4632_ _1677_ _1687_ _1692_ _1693_ VGND VGND VPWR VPWR _1694_ sky130_fd_sc_hd__o31a_1
XFILLER_0_4_445 VGND VGND VPWR VPWR sky130_fd_sc_hd__decap_8
Xhold603 u_pe_array.u_fifo2.buffer\[4\]\[3\] VGND VGND VPWR VPWR net677 sky130_fd_sc_hd__dlygate4sd3_1
X_4563_ _1629_ _1630_ VGND VGND VPWR VPWR _1631_ sky130_fd_sc_hd__xor2_1
X_7351_ clknet_leaf_8_clk net430 net945 VGND VGND VPWR VPWR u_pe_array.act_from_up\[14\]\[9\]
+ sky130_fd_sc_hd__dfrtp_1
XFILLER_0_40_521 VGND VGND VPWR VPWR sky130_fd_sc_hd__decap_8
X_7282_ clknet_leaf_12_clk net217 net942 VGND VGND VPWR VPWR u_pe_array.g_pe_row\[3\].g_pe_col\[0\].u_pe.move_reg\[9\]
+ sky130_fd_sc_hd__dfrtp_1
X_6302_ _0943_ VGND VGND VPWR VPWR _2987_ sky130_fd_sc_hd__buf_6
Xhold614 u_pe_array.u_fifo2.wr_ptr\[2\] VGND VGND VPWR VPWR net688 sky130_fd_sc_hd__dlygate4sd3_1
XFILLER_0_12_234 VGND VGND VPWR VPWR sky130_fd_sc_hd__decap_6
Xhold625 u_pe_array.u_fifo2.buffer\[2\]\[2\] VGND VGND VPWR VPWR net699 sky130_fd_sc_hd__dlygate4sd3_1
Xhold636 u_pe_array.u_fifo2.buffer\[4\]\[1\] VGND VGND VPWR VPWR net710 sky130_fd_sc_hd__dlygate4sd3_1
X_4494_ u_pe_array.g_pe_row\[3\].g_pe_col\[0\].u_pe.psum_out\[12\] _1585_ VGND VGND
+ VPWR VPWR _1593_ sky130_fd_sc_hd__xnor2_1
XFILLER_0_100_83 VGND VGND VPWR VPWR sky130_fd_sc_hd__fill_1
Xhold647 u_pe_array.g_pe_row\[1\].g_pe_col\[3\].u_pe.psum_out\[8\] VGND VGND VPWR
+ VPWR net721 sky130_fd_sc_hd__dlygate4sd3_1
X_6233_ _2939_ _2940_ VGND VGND VPWR VPWR _2941_ sky130_fd_sc_hd__nand2_1
XFILLER_0_12_278 VGND VGND VPWR VPWR sky130_fd_sc_hd__fill_1
XFILLER_0_12_256 VGND VGND VPWR VPWR sky130_fd_sc_hd__decap_4
Xhold669 u_pe_array.u_fifo1.buffer\[1\]\[4\] VGND VGND VPWR VPWR net743 sky130_fd_sc_hd__dlygate4sd3_1
Xhold658 u_pe_array.g_pe_row\[0\].g_pe_col\[2\].u_pe.psum_out\[1\] VGND VGND VPWR
+ VPWR net732 sky130_fd_sc_hd__dlygate4sd3_1
XFILLER_0_40_565 VGND VGND VPWR VPWR sky130_fd_sc_hd__decap_3
XFILLER_0_40_587 VGND VGND VPWR VPWR sky130_fd_sc_hd__fill_1
XFILLER_0_110_453 VGND VGND VPWR VPWR sky130_fd_sc_hd__decap_8
XFILLER_0_0_673 VPWR VGND VPWR VGND sky130_ef_sc_hd__decap_12
X_6164_ _2870_ _2876_ _1003_ VGND VGND VPWR VPWR _2878_ sky130_fd_sc_hd__a21o_1
XTAP_952 VGND VPWR sky130_fd_sc_hd__tapvpwrvgnd_1
XTAP_941 VGND VPWR sky130_fd_sc_hd__tapvpwrvgnd_1
XTAP_930 VGND VPWR sky130_fd_sc_hd__tapvpwrvgnd_1
X_5115_ _2056_ _2057_ VGND VGND VPWR VPWR _2058_ sky130_fd_sc_hd__or2_1
XTAP_996 VGND VPWR sky130_fd_sc_hd__tapvpwrvgnd_1
X_6095_ u_pe_array.g_pe_row\[1\].g_pe_col\[0\].u_pe.psum_out\[12\] _2832_ VGND VGND
+ VPWR VPWR _2840_ sky130_fd_sc_hd__xnor2_1
XTAP_985 VGND VPWR sky130_fd_sc_hd__tapvpwrvgnd_1
XTAP_974 VGND VPWR sky130_fd_sc_hd__tapvpwrvgnd_1
XTAP_963 VGND VPWR sky130_fd_sc_hd__tapvpwrvgnd_1
XFILLER_0_109_81 VPWR VGND VPWR VGND sky130_ef_sc_hd__decap_12
X_5046_ u_pe_array.g_pe_row\[2\].g_pe_col\[0\].u_pe.psum_out\[8\] u_pe_array.g_pe_row\[2\].g_pe_col\[0\].u_pe.move_reg\[8\]
+ _1867_ VGND VGND VPWR VPWR _2011_ sky130_fd_sc_hd__mux2_1
XFILLER_0_33_3 VPWR VGND VPWR VGND sky130_ef_sc_hd__decap_12
XFILLER_0_79_201 VGND VGND VPWR VPWR sky130_fd_sc_hd__decap_6
X_6997_ u_pe_array.u_fifo1.wr_ptr\[0\] _3458_ _3483_ VGND VGND VPWR VPWR _3491_ sky130_fd_sc_hd__and3_2
XFILLER_0_75_440 VGND VGND VPWR VPWR sky130_fd_sc_hd__decap_8
X_5948_ u_pe_array.act_from_up\[4\]\[3\] _2341_ VGND VGND VPWR VPWR _2715_ sky130_fd_sc_hd__or2_1
XFILLER_0_48_632 VGND VGND VPWR VPWR sky130_fd_sc_hd__fill_2
XFILLER_0_48_665 VGND VGND VPWR VPWR sky130_fd_sc_hd__decap_3
XFILLER_0_48_698 VGND VGND VPWR VPWR sky130_fd_sc_hd__fill_2
XFILLER_0_90_421 VGND VGND VPWR VPWR sky130_fd_sc_hd__decap_4
XFILLER_0_35_326 VGND VGND VPWR VPWR sky130_fd_sc_hd__fill_2
X_5879_ u_pe_array.g_pe_row\[1\].g_pe_col\[0\].u_pe.psum_out\[11\] _1112_ _1109_ _2663_
+ VGND VGND VPWR VPWR _2664_ sky130_fd_sc_hd__o211a_2
XFILLER_0_105_225 VGND VGND VPWR VPWR sky130_fd_sc_hd__decap_3
XFILLER_0_105_214 VGND VGND VPWR VPWR sky130_fd_sc_hd__decap_8
X_7618_ clknet_leaf_95_clk _0524_ net948 VGND VGND VPWR VPWR u_pe_array.act_from_left\[5\]\[4\]
+ sky130_fd_sc_hd__dfrtp_1
XFILLER_0_16_595 VGND VGND VPWR VPWR sky130_fd_sc_hd__fill_2
X_7549_ clknet_leaf_92_clk _0455_ net951 VGND VGND VPWR VPWR u_pe_array.g_pe_row\[1\].g_pe_col\[2\].u_pe.psum_out\[4\]
+ sky130_fd_sc_hd__dfrtp_1
XFILLER_0_101_453 VGND VGND VPWR VPWR sky130_fd_sc_hd__fill_1
XFILLER_0_14_15 VPWR VGND VPWR VGND sky130_ef_sc_hd__decap_12
XFILLER_0_66_462 VPWR VGND VPWR VGND sky130_ef_sc_hd__decap_12
XFILLER_0_38_153 VGND VGND VPWR VPWR sky130_fd_sc_hd__decap_4
XFILLER_0_81_432 VGND VGND VPWR VPWR sky130_fd_sc_hd__fill_1
XFILLER_0_26_348 VGND VGND VPWR VPWR sky130_fd_sc_hd__decap_4
XFILLER_0_39_34 VGND VGND VPWR VPWR sky130_fd_sc_hd__fill_1
XTAP_248 VGND VPWR sky130_fd_sc_hd__tapvpwrvgnd_1
XTAP_259 VGND VPWR sky130_fd_sc_hd__tapvpwrvgnd_1
X_6920_ _0924_ net767 _3439_ VGND VGND VPWR VPWR _3443_ sky130_fd_sc_hd__mux2_1
X_6851_ net639 _0924_ _3400_ VGND VGND VPWR VPWR _3404_ sky130_fd_sc_hd__mux2_1
X_5802_ _2595_ _2598_ _2603_ VGND VGND VPWR VPWR _2604_ sky130_fd_sc_hd__o21ai_1
XFILLER_0_71_65 VGND VGND VPWR VPWR sky130_fd_sc_hd__decap_8
XFILLER_0_9_537 VGND VGND VPWR VPWR sky130_fd_sc_hd__fill_1
XFILLER_0_17_304 VGND VGND VPWR VPWR sky130_fd_sc_hd__fill_1
X_3994_ _1195_ _1196_ VGND VGND VPWR VPWR _1197_ sky130_fd_sc_hd__nor2_1
X_6782_ _3358_ net794 _3352_ VGND VGND VPWR VPWR _3359_ sky130_fd_sc_hd__mux2_1
X_5733_ _2537_ _2539_ VGND VGND VPWR VPWR _2541_ sky130_fd_sc_hd__nand2_1
XFILLER_0_17_337 VGND VGND VPWR VPWR sky130_fd_sc_hd__fill_2
XFILLER_0_44_123 VGND VGND VPWR VPWR sky130_fd_sc_hd__fill_1
X_5664_ u_pe_array.g_pe_row\[1\].g_pe_col\[1\].u_pe.psum_out\[5\] u_pe_array.g_pe_row\[1\].g_pe_col\[1\].u_pe.act_val\[5\]
+ _2133_ VGND VGND VPWR VPWR _2496_ sky130_fd_sc_hd__mux2_1
XFILLER_0_115_545 VPWR VGND VPWR VGND sky130_ef_sc_hd__decap_12
X_7403_ clknet_leaf_35_clk net76 net942 VGND VGND VPWR VPWR u_pe_array.g_pe_row\[2\].g_pe_col\[1\].u_pe.move_reg\[7\]
+ sky130_fd_sc_hd__dfrtp_1
XFILLER_0_60_649 VGND VGND VPWR VPWR sky130_fd_sc_hd__fill_1
X_4615_ _1678_ _1668_ _1666_ VGND VGND VPWR VPWR _1679_ sky130_fd_sc_hd__a21oi_1
X_5595_ net752 _1904_ _2440_ _1726_ VGND VGND VPWR VPWR _0457_ sky130_fd_sc_hd__a22o_1
Xhold411 _0346_ VGND VGND VPWR VPWR net485 sky130_fd_sc_hd__dlygate4sd3_1
Xhold400 u_pe_array.act_from_down\[3\]\[4\] VGND VGND VPWR VPWR net474 sky130_fd_sc_hd__buf_1
X_4546_ u_pe_array.g_pe_row\[2\].g_pe_col\[3\].u_pe.psum_out\[0\] u_pe_array.g_pe_row\[2\].g_pe_col\[3\].u_pe.act_val\[0\]
+ _1424_ VGND VGND VPWR VPWR _1616_ sky130_fd_sc_hd__nand3_1
X_7334_ clknet_leaf_3_clk _0240_ net944 VGND VGND VPWR VPWR u_pe_array.g_pe_row\[2\].g_pe_col\[3\].u_pe.psum_out\[7\]
+ sky130_fd_sc_hd__dfrtp_2
XFILLER_0_111_93 VPWR VGND VPWR VGND sky130_ef_sc_hd__decap_12
Xhold422 u_pe_array.act_from_down\[1\]\[2\] VGND VGND VPWR VPWR net496 sky130_fd_sc_hd__buf_1
Xhold444 u_pe_array.g_pe_row\[0\].g_pe_col\[0\].u_pe.psum_out\[5\] VGND VGND VPWR
+ VPWR net518 sky130_fd_sc_hd__dlygate4sd3_1
XFILLER_0_4_297 VGND VGND VPWR VPWR sky130_fd_sc_hd__fill_1
Xhold433 u_fsm.h_cnt\[0\] VGND VGND VPWR VPWR net507 sky130_fd_sc_hd__dlygate4sd3_1
XFILLER_0_40_340 VPWR VGND VPWR VGND sky130_ef_sc_hd__decap_12
Xhold455 u_pe_array.g_pe_row\[2\].g_pe_col\[0\].u_pe.psum_out\[3\] VGND VGND VPWR
+ VPWR net529 sky130_fd_sc_hd__dlygate4sd3_1
X_7265_ clknet_leaf_6_clk _0171_ net945 VGND VGND VPWR VPWR u_pe_array.act_from_left\[13\]\[5\]
+ sky130_fd_sc_hd__dfrtp_1
Xhold466 u_pe_array.g_pe_row\[2\].g_pe_col\[2\].u_pe.psum_out\[0\] VGND VGND VPWR
+ VPWR net540 sky130_fd_sc_hd__dlygate4sd3_1
Xhold477 u_pe_array.u_fifo2.buffer\[0\]\[0\] VGND VGND VPWR VPWR net551 sky130_fd_sc_hd__dlygate4sd3_1
X_4477_ u_pe_array.g_pe_row\[3\].g_pe_col\[0\].u_pe.psum_out\[10\] _1287_ VGND VGND
+ VPWR VPWR _1578_ sky130_fd_sc_hd__nand2_1
X_6216_ _2795_ _2924_ _2925_ _2621_ net711 VGND VGND VPWR VPWR _0593_ sky130_fd_sc_hd__a32o_1
Xhold499 _0006_ VGND VGND VPWR VPWR net573 sky130_fd_sc_hd__dlygate4sd3_1
Xhold488 u_pe_array.u_fifo1.buffer\[0\]\[2\] VGND VGND VPWR VPWR net562 sky130_fd_sc_hd__dlygate4sd3_1
X_7196_ clknet_leaf_97_clk _0102_ net950 VGND VGND VPWR VPWR u_pe_array.g_pe_row\[3\].g_pe_col\[2\].u_pe.psum_out\[5\]
+ sky130_fd_sc_hd__dfrtp_2
X_6147_ _2795_ _2860_ _2862_ _2621_ net466 VGND VGND VPWR VPWR _0587_ sky130_fd_sc_hd__a32o_1
XTAP_760 VGND VPWR sky130_fd_sc_hd__tapvpwrvgnd_1
XTAP_771 VGND VPWR sky130_fd_sc_hd__tapvpwrvgnd_1
XTAP_782 VGND VPWR sky130_fd_sc_hd__tapvpwrvgnd_1
XTAP_793 VGND VPWR sky130_fd_sc_hd__tapvpwrvgnd_1
X_6078_ u_pe_array.g_pe_row\[1\].g_pe_col\[0\].u_pe.psum_out\[10\] _1865_ VGND VGND
+ VPWR VPWR _2825_ sky130_fd_sc_hd__nand2_1
X_5029_ net855 _1732_ _1735_ _2001_ VGND VGND VPWR VPWR _0330_ sky130_fd_sc_hd__a22o_1
XFILLER_0_95_568 VGND VGND VPWR VPWR sky130_fd_sc_hd__decap_4
XFILLER_0_106_589 VPWR VGND VPWR VGND sky130_ef_sc_hd__decap_12
XFILLER_0_106_578 VGND VGND VPWR VPWR sky130_fd_sc_hd__fill_2
XFILLER_0_101_250 VPWR VGND VPWR VGND sky130_ef_sc_hd__decap_12
XFILLER_0_98_373 VGND VGND VPWR VPWR sky130_fd_sc_hd__decap_3
XFILLER_0_58_226 VGND VGND VPWR VPWR sky130_fd_sc_hd__fill_1
XFILLER_0_73_218 VGND VGND VPWR VPWR sky130_fd_sc_hd__fill_1
XFILLER_0_39_440 VGND VGND VPWR VPWR sky130_fd_sc_hd__decap_8
XFILLER_0_116_309 VPWR VGND VPWR VGND sky130_ef_sc_hd__decap_12
XFILLER_0_39_473 VGND VGND VPWR VPWR sky130_fd_sc_hd__decap_6
XFILLER_0_41_57 VGND VGND VPWR VPWR sky130_fd_sc_hd__decap_8
XFILLER_0_109_361 VGND VGND VPWR VPWR sky130_fd_sc_hd__decap_4
XFILLER_0_81_240 VGND VGND VPWR VPWR sky130_fd_sc_hd__fill_1
XFILLER_0_26_145 VGND VGND VPWR VPWR sky130_fd_sc_hd__fill_1
XFILLER_0_26_167 VGND VGND VPWR VPWR sky130_fd_sc_hd__fill_1
X_4400_ _1506_ _1507_ VGND VGND VPWR VPWR _1508_ sky130_fd_sc_hd__nand2_1
XFILLER_0_1_223 VGND VGND VPWR VPWR sky130_fd_sc_hd__fill_1
X_5380_ _2270_ _1112_ VGND VGND VPWR VPWR _2271_ sky130_fd_sc_hd__nand2_1
X_4331_ net839 _1468_ _1116_ VGND VGND VPWR VPWR _1469_ sky130_fd_sc_hd__mux2_1
X_4262_ _1414_ _1415_ VGND VGND VPWR VPWR _1416_ sky130_fd_sc_hd__or2_1
XFILLER_0_10_579 VGND VGND VPWR VPWR sky130_fd_sc_hd__decap_8
XFILLER_0_10_546 VGND VGND VPWR VPWR sky130_fd_sc_hd__decap_4
X_7050_ _3520_ VGND VGND VPWR VPWR _0832_ sky130_fd_sc_hd__clkbuf_1
XFILLER_0_5_57 VPWR VGND VPWR VGND sky130_ef_sc_hd__decap_12
X_6001_ u_pe_array.g_pe_row\[1\].g_pe_col\[0\].u_pe.psum_out\[3\] _2754_ VGND VGND
+ VPWR VPWR _2755_ sky130_fd_sc_hd__xor2_1
X_4193_ _1352_ _1353_ VGND VGND VPWR VPWR _1354_ sky130_fd_sc_hd__or2_1
XFILLER_0_66_65 VGND VGND VPWR VPWR sky130_fd_sc_hd__decap_6
XFILLER_0_82_53 VGND VGND VPWR VPWR sky130_fd_sc_hd__decap_8
XFILLER_0_77_513 VGND VGND VPWR VPWR sky130_fd_sc_hd__fill_1
X_6903_ _3433_ VGND VGND VPWR VPWR _0772_ sky130_fd_sc_hd__clkbuf_1
XFILLER_0_77_557 VGND VGND VPWR VPWR sky130_fd_sc_hd__decap_3
X_7883_ clknet_leaf_99_clk _0788_ VGND VGND VPWR VPWR u_pe_array.u_fifo2.buffer\[7\]\[5\]
+ sky130_fd_sc_hd__dfxtp_1
XFILLER_0_49_248 VGND VGND VPWR VPWR sky130_fd_sc_hd__fill_2
XFILLER_0_92_505 VGND VGND VPWR VPWR sky130_fd_sc_hd__fill_2
XFILLER_0_9_312 VGND VGND VPWR VPWR sky130_fd_sc_hd__decap_4
XFILLER_0_15_80 VGND VGND VPWR VPWR sky130_fd_sc_hd__fill_1
X_6834_ _3394_ VGND VGND VPWR VPWR _0742_ sky130_fd_sc_hd__clkbuf_1
X_6765_ _3344_ _3345_ VGND VGND VPWR VPWR _3346_ sky130_fd_sc_hd__xnor2_1
X_3977_ u_pe_array.g_pe_row\[3\].g_pe_col\[2\].u_pe.act_val\[1\] u_pe_array.g_pe_row\[3\].g_pe_col\[2\].u_pe.w_out\[0\]
+ _1180_ _1181_ VGND VGND VPWR VPWR _1182_ sky130_fd_sc_hd__nand4_1
X_5716_ u_pe_array.g_pe_row\[1\].g_pe_col\[1\].u_pe.act_val\[2\] u_pe_array.g_pe_row\[1\].g_pe_col\[1\].u_pe.w_out\[0\]
+ VGND VGND VPWR VPWR _2525_ sky130_fd_sc_hd__nand2_1
XFILLER_0_57_292 VGND VGND VPWR VPWR sky130_fd_sc_hd__decap_3
X_6696_ net565 _2586_ _3283_ _3284_ VGND VGND VPWR VPWR _0714_ sky130_fd_sc_hd__a22o_1
X_5647_ u_pe_array.g_pe_row\[0\].g_pe_col\[0\].u_pe.w_out\[0\] VGND VGND VPWR VPWR
+ _2486_ sky130_fd_sc_hd__clkbuf_4
XFILLER_0_5_573 VGND VGND VPWR VPWR sky130_fd_sc_hd__fill_2
X_5578_ _2422_ _2424_ VGND VGND VPWR VPWR _2425_ sky130_fd_sc_hd__xor2_1
Xhold230 _0545_ VGND VGND VPWR VPWR net304 sky130_fd_sc_hd__dlygate4sd3_1
Xhold252 u_pe_array.act_from_right\[2\]\[1\] VGND VGND VPWR VPWR net326 sky130_fd_sc_hd__dlygate4sd3_1
Xhold241 _0272_ VGND VGND VPWR VPWR net315 sky130_fd_sc_hd__dlygate4sd3_1
X_4529_ net457 _1605_ _1611_ _1613_ VGND VGND VPWR VPWR _0218_ sky130_fd_sc_hd__a22o_1
X_7317_ clknet_leaf_3_clk net322 net945 VGND VGND VPWR VPWR u_pe_array.g_pe_row\[2\].g_pe_col\[3\].u_pe.act_val\[3\]
+ sky130_fd_sc_hd__dfrtp_4
Xhold296 u_pe_array.g_pe_row\[1\].g_pe_col\[1\].u_pe.psum_out\[8\] VGND VGND VPWR
+ VPWR net370 sky130_fd_sc_hd__dlygate4sd3_1
X_7248_ clknet_leaf_24_clk _0154_ net70 VGND VGND VPWR VPWR net53 sky130_fd_sc_hd__dfrtp_1
Xhold285 u_pe_array.act_from_down\[1\]\[11\] VGND VGND VPWR VPWR net359 sky130_fd_sc_hd__dlygate4sd3_1
Xhold263 u_pe_array.act_from_down\[11\]\[10\] VGND VGND VPWR VPWR net337 sky130_fd_sc_hd__dlygate4sd3_1
Xhold274 _0133_ VGND VGND VPWR VPWR net348 sky130_fd_sc_hd__dlygate4sd3_1
X_7179_ clknet_leaf_103_clk _0085_ net944 VGND VGND VPWR VPWR u_pe_array.g_pe_row\[3\].g_pe_col\[2\].u_pe.act_val\[1\]
+ sky130_fd_sc_hd__dfrtp_2
XTAP_590 VGND VPWR sky130_fd_sc_hd__tapvpwrvgnd_1
XTAP_1734 VGND VPWR sky130_fd_sc_hd__tapvpwrvgnd_1
XTAP_1723 VGND VPWR sky130_fd_sc_hd__tapvpwrvgnd_1
XTAP_1712 VGND VPWR sky130_fd_sc_hd__tapvpwrvgnd_1
XTAP_1701 VGND VPWR sky130_fd_sc_hd__tapvpwrvgnd_1
XTAP_1745 VGND VPWR sky130_fd_sc_hd__tapvpwrvgnd_1
Xclkbuf_leaf_80_clk clknet_3_5__leaf_clk VGND VGND VPWR VPWR clknet_leaf_80_clk sky130_fd_sc_hd__clkbuf_16
XFILLER_0_36_421 VGND VGND VPWR VPWR sky130_fd_sc_hd__decap_4
XFILLER_0_48_270 VGND VGND VPWR VPWR sky130_fd_sc_hd__decap_8
XFILLER_0_63_240 VGND VGND VPWR VPWR sky130_fd_sc_hd__decap_3
XFILLER_0_102_29 VPWR VGND VPWR VGND sky130_ef_sc_hd__decap_12
XFILLER_0_11_27 VPWR VGND VPWR VGND sky130_ef_sc_hd__decap_12
XFILLER_0_23_104 VGND VGND VPWR VPWR sky130_fd_sc_hd__fill_1
XFILLER_0_24_616 VGND VGND VPWR VPWR sky130_fd_sc_hd__decap_6
XFILLER_0_32_693 VGND VGND VPWR VPWR sky130_fd_sc_hd__decap_3
XFILLER_0_102_581 VGND VGND VPWR VPWR sky130_fd_sc_hd__fill_1
XFILLER_0_36_13 VGND VGND VPWR VPWR sky130_fd_sc_hd__fill_2
Xinput9 h_in1[2] VGND VGND VPWR VPWR net9 sky130_fd_sc_hd__clkbuf_2
XFILLER_0_99_671 VGND VGND VPWR VPWR sky130_fd_sc_hd__fill_1
XFILLER_0_98_181 VGND VGND VPWR VPWR sky130_fd_sc_hd__fill_1
XFILLER_0_86_365 VGND VGND VPWR VPWR sky130_fd_sc_hd__decap_6
X_4880_ net454 _1749_ _1873_ _1881_ VGND VGND VPWR VPWR _0301_ sky130_fd_sc_hd__a22o_1
X_3900_ net381 _1138_ _1116_ VGND VGND VPWR VPWR _1139_ sky130_fd_sc_hd__mux2_1
Xclkbuf_leaf_71_clk clknet_3_4__leaf_clk VGND VGND VPWR VPWR clknet_leaf_71_clk sky130_fd_sc_hd__clkbuf_16
X_3831_ _1073_ _1076_ _1081_ VGND VGND VPWR VPWR _1082_ sky130_fd_sc_hd__o21ai_1
X_6550_ _3162_ _3164_ _3177_ VGND VGND VPWR VPWR _3178_ sky130_fd_sc_hd__a21oi_1
X_3762_ _1017_ _1018_ VGND VGND VPWR VPWR _1019_ sky130_fd_sc_hd__or2b_1
XFILLER_0_39_281 VPWR VGND VPWR VGND sky130_ef_sc_hd__decap_12
XFILLER_0_82_582 VGND VGND VPWR VPWR sky130_fd_sc_hd__decap_6
X_5501_ u_pe_array.u_fifo2.buffer\[8\]\[3\] _2322_ _2358_ _2362_ _0857_ VGND VGND
+ VPWR VPWR _2363_ sky130_fd_sc_hd__a221o_1
X_6481_ u_pe_array.act_from_down\[1\]\[12\] _0866_ _0940_ net281 VGND VGND VPWR VPWR
+ _0668_ sky130_fd_sc_hd__a22o_1
X_3693_ net8 u_pe_array.act_from_left\[15\]\[1\] _0963_ VGND VGND VPWR VPWR _0965_
+ sky130_fd_sc_hd__mux2_1
XFILLER_0_27_498 VGND VGND VPWR VPWR sky130_fd_sc_hd__decap_6
X_5432_ u_pe_array.g_pe_row\[1\].g_pe_col\[2\].u_pe.move_reg\[12\] net62 VGND VGND
+ VPWR VPWR _2311_ sky130_fd_sc_hd__or2_1
X_5363_ u_pe_array.g_pe_row\[1\].g_pe_col\[3\].u_pe.psum_out\[11\] _2164_ VGND VGND
+ VPWR VPWR _2258_ sky130_fd_sc_hd__nor2_1
XFILLER_0_112_389 VGND VGND VPWR VPWR sky130_fd_sc_hd__decap_8
XFILLER_0_77_42 VGND VGND VPWR VPWR sky130_fd_sc_hd__fill_1
X_4314_ u_pe_array.g_pe_row\[3\].g_pe_col\[0\].u_pe.psum_out\[8\] _1108_ _1110_ _1455_
+ VGND VGND VPWR VPWR _1456_ sky130_fd_sc_hd__o211a_2
XFILLER_0_10_343 VGND VGND VPWR VPWR sky130_fd_sc_hd__decap_4
XFILLER_0_10_332 VGND VGND VPWR VPWR sky130_fd_sc_hd__fill_2
XFILLER_0_2_587 VGND VGND VPWR VPWR sky130_fd_sc_hd__fill_1
X_7102_ clknet_leaf_83_clk _0008_ net948 VGND VGND VPWR VPWR u_fsm.v_cnt\[2\] sky130_fd_sc_hd__dfrtp_1
XFILLER_0_77_75 VGND VGND VPWR VPWR sky130_fd_sc_hd__fill_2
X_5294_ u_pe_array.g_pe_row\[1\].g_pe_col\[3\].u_pe.psum_out\[4\] u_pe_array.g_pe_row\[1\].g_pe_col\[3\].u_pe.act_val\[4\]
+ _1423_ VGND VGND VPWR VPWR _2196_ sky130_fd_sc_hd__and3_1
X_4245_ u_pe_array.g_pe_row\[3\].g_pe_col\[1\].u_pe.psum_out\[8\] u_pe_array.g_pe_row\[3\].g_pe_col\[1\].u_pe.psum_out\[9\]
+ _1106_ VGND VGND VPWR VPWR _1401_ sky130_fd_sc_hd__and3_1
X_7033_ net597 _3360_ _3506_ VGND VGND VPWR VPWR _3511_ sky130_fd_sc_hd__mux2_1
X_4176_ _1337_ VGND VGND VPWR VPWR _1338_ sky130_fd_sc_hd__inv_2
XFILLER_0_117_81 VPWR VGND VPWR VGND sky130_ef_sc_hd__decap_12
XTAP_1019 VGND VPWR sky130_fd_sc_hd__tapvpwrvgnd_1
XTAP_1008 VGND VPWR sky130_fd_sc_hd__tapvpwrvgnd_1
X_7935_ clknet_leaf_78_clk _0840_ VGND VGND VPWR VPWR u_pe_array.u_fifo1.buffer\[6\]\[1\]
+ sky130_fd_sc_hd__dfxtp_1
Xclkbuf_leaf_62_clk clknet_3_7__leaf_clk VGND VGND VPWR VPWR clknet_leaf_62_clk sky130_fd_sc_hd__clkbuf_16
X_7866_ clknet_leaf_102_clk _0771_ VGND VGND VPWR VPWR u_pe_array.u_fifo2.buffer\[5\]\[0\]
+ sky130_fd_sc_hd__dfxtp_1
XFILLER_0_92_313 VGND VGND VPWR VPWR sky130_fd_sc_hd__fill_1
XFILLER_0_77_376 VPWR VGND VPWR VGND sky130_ef_sc_hd__decap_12
X_6817_ _3380_ _3382_ VGND VGND VPWR VPWR _3383_ sky130_fd_sc_hd__or2_1
X_7797_ clknet_leaf_54_clk net247 net74 VGND VGND VPWR VPWR u_pe_array.g_pe_row\[0\].g_pe_col\[0\].u_pe.act_val\[5\]
+ sky130_fd_sc_hd__dfrtp_2
XFILLER_0_18_421 VGND VGND VPWR VPWR sky130_fd_sc_hd__decap_3
X_6748_ u_pe_array.g_pe_row\[0\].g_pe_col\[0\].u_pe.psum_out\[10\] _2488_ VGND VGND
+ VPWR VPWR _3331_ sky130_fd_sc_hd__nand2_1
XFILLER_0_61_700 VGND VGND VPWR VPWR sky130_fd_sc_hd__decap_4
X_6679_ _3267_ _3268_ _3257_ net940 VGND VGND VPWR VPWR _3269_ sky130_fd_sc_hd__a211oi_1
XFILLER_0_60_221 VGND VGND VPWR VPWR sky130_fd_sc_hd__decap_8
XFILLER_0_115_161 VGND VGND VPWR VPWR sky130_fd_sc_hd__decap_6
XFILLER_0_103_334 VGND VGND VPWR VPWR sky130_fd_sc_hd__fill_2
XFILLER_0_20_107 VPWR VGND VPWR VGND sky130_ef_sc_hd__decap_12
Xclkbuf_leaf_53_clk clknet_3_7__leaf_clk VGND VGND VPWR VPWR clknet_leaf_53_clk sky130_fd_sc_hd__clkbuf_16
XTAP_1542 VGND VPWR sky130_fd_sc_hd__tapvpwrvgnd_1
XTAP_1531 VGND VPWR sky130_fd_sc_hd__tapvpwrvgnd_1
XTAP_1520 VGND VPWR sky130_fd_sc_hd__tapvpwrvgnd_1
XFILLER_0_95_140 VGND VGND VPWR VPWR sky130_fd_sc_hd__decap_4
XTAP_1564 VGND VPWR sky130_fd_sc_hd__tapvpwrvgnd_1
XTAP_1575 VGND VPWR sky130_fd_sc_hd__tapvpwrvgnd_1
XTAP_1553 VGND VPWR sky130_fd_sc_hd__tapvpwrvgnd_1
XPHY_60 VGND VGND VPWR VPWR sky130_fd_sc_hd__decap_3
XPHY_71 VGND VGND VPWR VPWR sky130_fd_sc_hd__decap_3
XPHY_82 VGND VGND VPWR VPWR sky130_fd_sc_hd__decap_3
XFILLER_0_113_39 VPWR VGND VPWR VGND sky130_ef_sc_hd__decap_12
XTAP_1597 VGND VPWR sky130_fd_sc_hd__tapvpwrvgnd_1
XTAP_1586 VGND VPWR sky130_fd_sc_hd__tapvpwrvgnd_1
XPHY_93 VGND VGND VPWR VPWR sky130_fd_sc_hd__decap_3
XFILLER_0_107_673 VPWR VGND VPWR VGND sky130_ef_sc_hd__decap_12
XFILLER_0_64_582 VGND VGND VPWR VPWR sky130_fd_sc_hd__decap_6
XFILLER_0_36_273 VPWR VGND VPWR VGND sky130_ef_sc_hd__decap_12
XFILLER_0_12_608 VGND VGND VPWR VPWR sky130_fd_sc_hd__decap_6
XFILLER_0_51_298 VGND VGND VPWR VPWR sky130_fd_sc_hd__fill_2
X_4030_ u_pe_array.g_pe_row\[3\].g_pe_col\[2\].u_pe.psum_out\[5\] _0934_ VGND VGND
+ VPWR VPWR _1230_ sky130_fd_sc_hd__nand2_1
XFILLER_0_63_55 VGND VGND VPWR VPWR sky130_fd_sc_hd__fill_1
X_5981_ _2733_ _2736_ VGND VGND VPWR VPWR _2737_ sky130_fd_sc_hd__xnor2_1
X_4932_ _1906_ _1916_ VGND VGND VPWR VPWR _1917_ sky130_fd_sc_hd__xnor2_1
Xclkbuf_leaf_44_clk clknet_3_6__leaf_clk VGND VGND VPWR VPWR clknet_leaf_44_clk sky130_fd_sc_hd__clkbuf_16
X_7720_ clknet_leaf_61_clk net460 net74 VGND VGND VPWR VPWR u_pe_array.g_pe_row\[0\].g_pe_col\[2\].u_pe.move_reg\[11\]
+ sky130_fd_sc_hd__dfrtp_1
XFILLER_0_47_505 VGND VGND VPWR VPWR sky130_fd_sc_hd__decap_6
XFILLER_0_87_685 VPWR VGND VPWR VGND sky130_ef_sc_hd__decap_12
XFILLER_0_74_313 VGND VGND VPWR VPWR sky130_fd_sc_hd__fill_1
X_7651_ clknet_leaf_70_clk _0557_ net72 VGND VGND VPWR VPWR u_pe_array.g_pe_row\[1\].g_pe_col\[0\].u_pe.psum_out\[11\]
+ sky130_fd_sc_hd__dfrtp_1
X_6602_ u_pe_array.g_pe_row\[0\].g_pe_col\[1\].u_pe.psum_out\[9\] u_pe_array.g_pe_row\[0\].g_pe_col\[1\].u_pe.psum_out\[10\]
+ _2268_ VGND VGND VPWR VPWR _3224_ sky130_fd_sc_hd__o21a_1
X_4863_ net77 _1749_ _1611_ _1872_ VGND VGND VPWR VPWR _0293_ sky130_fd_sc_hd__a22o_1
XANTENNA_14 _1092_ VGND VGND VPWR VPWR sky130_fd_sc_hd__diode_2
XFILLER_0_74_346 VPWR VGND VPWR VGND sky130_ef_sc_hd__decap_12
XFILLER_0_7_602 VGND VGND VPWR VPWR sky130_fd_sc_hd__decap_4
X_3814_ _1053_ _1065_ VGND VGND VPWR VPWR _1066_ sky130_fd_sc_hd__and2_1
X_7582_ clknet_leaf_67_clk net317 net946 VGND VGND VPWR VPWR u_pe_array.g_pe_row\[1\].g_pe_col\[1\].u_pe.move_reg\[9\]
+ sky130_fd_sc_hd__dfrtp_1
X_4794_ _1810_ _1815_ VGND VGND VPWR VPWR _1817_ sky130_fd_sc_hd__nand2_1
X_6533_ u_pe_array.g_pe_row\[0\].g_pe_col\[1\].u_pe.psum_out\[5\] _3161_ VGND VGND
+ VPWR VPWR _3162_ sky130_fd_sc_hd__xnor2_2
XFILLER_0_104_109 VGND VGND VPWR VPWR sky130_fd_sc_hd__decap_6
X_3745_ _0879_ VGND VGND VPWR VPWR _1003_ sky130_fd_sc_hd__buf_12
XFILLER_0_70_530 VGND VGND VPWR VPWR sky130_fd_sc_hd__fill_2
XFILLER_0_15_446 VGND VGND VPWR VPWR sky130_fd_sc_hd__fill_2
X_6464_ net117 _3101_ _2987_ _3113_ VGND VGND VPWR VPWR _0653_ sky130_fd_sc_hd__a22o_1
XFILLER_0_12_92 VGND VGND VPWR VPWR sky130_fd_sc_hd__fill_2
XFILLER_0_6_189 VGND VGND VPWR VPWR sky130_fd_sc_hd__decap_6
XFILLER_0_42_232 VGND VGND VPWR VPWR sky130_fd_sc_hd__decap_3
X_5415_ _2298_ VGND VGND VPWR VPWR _0419_ sky130_fd_sc_hd__clkbuf_1
X_3676_ net349 _0949_ _0944_ _0955_ VGND VGND VPWR VPWR _0023_ sky130_fd_sc_hd__a22o_1
XFILLER_0_42_265 VGND VGND VPWR VPWR sky130_fd_sc_hd__fill_1
X_6395_ _2795_ _3061_ _3062_ _2621_ net806 VGND VGND VPWR VPWR _0635_ sky130_fd_sc_hd__a32o_1
XFILLER_0_11_641 VPWR VGND VPWR VGND sky130_ef_sc_hd__decap_12
XFILLER_0_112_197 VGND VGND VPWR VPWR sky130_fd_sc_hd__decap_4
XFILLER_0_100_337 VGND VGND VPWR VPWR sky130_fd_sc_hd__decap_8
X_5346_ _2240_ _2236_ _2226_ u_pe_array.g_pe_row\[1\].g_pe_col\[3\].u_pe.psum_out\[8\]
+ VGND VGND VPWR VPWR _2243_ sky130_fd_sc_hd__o2bb2a_1
XFILLER_0_11_685 VPWR VGND VPWR VGND sky130_ef_sc_hd__decap_12
X_5277_ _2179_ _2180_ _2171_ _2169_ VGND VGND VPWR VPWR _2181_ sky130_fd_sc_hd__o211ai_1
X_4228_ _1378_ _1384_ VGND VGND VPWR VPWR _1386_ sky130_fd_sc_hd__or2_1
X_7016_ net619 _3356_ _3499_ VGND VGND VPWR VPWR _3502_ sky130_fd_sc_hd__mux2_1
XFILLER_0_97_405 VGND VGND VPWR VPWR sky130_fd_sc_hd__fill_2
X_4159_ _1319_ _1321_ VGND VGND VPWR VPWR _1322_ sky130_fd_sc_hd__xnor2_1
XFILLER_0_78_663 VPWR VGND VPWR VGND sky130_ef_sc_hd__decap_12
X_7918_ clknet_leaf_81_clk _0823_ VGND VGND VPWR VPWR u_pe_array.u_fifo1.buffer\[3\]\[2\]
+ sky130_fd_sc_hd__dfxtp_1
Xclkbuf_leaf_35_clk clknet_3_3__leaf_clk VGND VGND VPWR VPWR clknet_leaf_35_clk sky130_fd_sc_hd__clkbuf_16
XFILLER_0_65_335 VGND VGND VPWR VPWR sky130_fd_sc_hd__fill_1
X_7849_ clknet_leaf_100_clk _0754_ VGND VGND VPWR VPWR u_pe_array.u_fifo2.buffer\[2\]\[1\]
+ sky130_fd_sc_hd__dfxtp_1
XFILLER_0_104_610 VGND VGND VPWR VPWR sky130_fd_sc_hd__fill_1
XFILLER_0_33_243 VGND VGND VPWR VPWR sky130_fd_sc_hd__fill_1
XFILLER_0_61_574 VGND VGND VPWR VPWR sky130_fd_sc_hd__fill_1
XFILLER_0_33_265 VGND VGND VPWR VPWR sky130_fd_sc_hd__decap_3
XFILLER_0_21_449 VGND VGND VPWR VPWR sky130_fd_sc_hd__fill_1
XFILLER_0_17_15 VPWR VGND VPWR VGND sky130_ef_sc_hd__decap_12
XFILLER_0_88_416 VGND VGND VPWR VPWR sky130_fd_sc_hd__decap_4
XFILLER_0_69_652 VGND VGND VPWR VPWR sky130_fd_sc_hd__fill_1
Xclkbuf_leaf_26_clk clknet_3_2__leaf_clk VGND VGND VPWR VPWR clknet_leaf_26_clk sky130_fd_sc_hd__clkbuf_16
XFILLER_0_96_471 VGND VGND VPWR VPWR sky130_fd_sc_hd__decap_4
XTAP_1350 VGND VPWR sky130_fd_sc_hd__tapvpwrvgnd_1
XTAP_1383 VGND VPWR sky130_fd_sc_hd__tapvpwrvgnd_1
XTAP_1372 VGND VPWR sky130_fd_sc_hd__tapvpwrvgnd_1
XTAP_1361 VGND VPWR sky130_fd_sc_hd__tapvpwrvgnd_1
XFILLER_0_68_195 VGND VGND VPWR VPWR sky130_fd_sc_hd__fill_1
XFILLER_0_33_69 VGND VGND VPWR VPWR sky130_fd_sc_hd__decap_4
XTAP_1394 VGND VPWR sky130_fd_sc_hd__tapvpwrvgnd_1
XFILLER_0_83_143 VPWR VGND VPWR VGND sky130_ef_sc_hd__decap_12
Xinput12 h_in1[5] VGND VGND VPWR VPWR net12 sky130_fd_sc_hd__clkbuf_1
XFILLER_0_107_481 VGND VGND VPWR VPWR sky130_fd_sc_hd__fill_1
Xinput34 w_in_flat[7] VGND VGND VPWR VPWR net34 sky130_fd_sc_hd__clkbuf_1
Xinput23 v_in1[2] VGND VGND VPWR VPWR net23 sky130_fd_sc_hd__clkbuf_1
Xhold807 u_pe_array.u_fifo1.count\[0\] VGND VGND VPWR VPWR net881 sky130_fd_sc_hd__dlygate4sd3_1
Xhold818 u_pe_array.u_fifo2.rd_ptr\[1\] VGND VGND VPWR VPWR net892 sky130_fd_sc_hd__dlygate4sd3_1
XFILLER_0_3_137 VPWR VGND VPWR VGND sky130_ef_sc_hd__decap_12
Xhold829 u_pe_array.act_from_left\[7\]\[5\] VGND VGND VPWR VPWR net903 sky130_fd_sc_hd__dlygate4sd3_1
XFILLER_0_110_657 VPWR VGND VPWR VGND sky130_ef_sc_hd__decap_12
X_6180_ _2880_ _2889_ _2888_ VGND VGND VPWR VPWR _2892_ sky130_fd_sc_hd__a21oi_1
X_5200_ _0943_ VGND VGND VPWR VPWR _2132_ sky130_fd_sc_hd__clkbuf_8
XFILLER_0_58_44 VGND VGND VPWR VPWR sky130_fd_sc_hd__fill_1
X_5131_ u_pe_array.g_pe_row\[2\].g_pe_col\[0\].u_pe.act_val\[5\] VGND VGND VPWR VPWR
+ _2072_ sky130_fd_sc_hd__inv_2
X_5062_ u_pe_array.act_from_right\[8\]\[6\] _1750_ _1883_ net277 VGND VGND VPWR VPWR
+ _0349_ sky130_fd_sc_hd__a22o_1
XFILLER_0_74_43 VGND VGND VPWR VPWR sky130_fd_sc_hd__fill_2
XFILLER_0_74_21 VGND VGND VPWR VPWR sky130_fd_sc_hd__fill_2
X_4013_ _1203_ _1200_ _1199_ VGND VGND VPWR VPWR _1215_ sky130_fd_sc_hd__a21o_1
XFILLER_0_90_53 VGND VGND VPWR VPWR sky130_fd_sc_hd__decap_8
Xclkbuf_leaf_17_clk clknet_3_2__leaf_clk VGND VGND VPWR VPWR clknet_leaf_17_clk sky130_fd_sc_hd__clkbuf_16
X_7703_ clknet_leaf_74_clk _0609_ net72 VGND VGND VPWR VPWR u_pe_array.act_from_up\[6\]\[7\]
+ sky130_fd_sc_hd__dfrtp_1
X_5964_ u_pe_array.act_from_up\[4\]\[5\] _2341_ VGND VGND VPWR VPWR _2729_ sky130_fd_sc_hd__or2_1
X_4915_ _1896_ _1900_ VGND VGND VPWR VPWR _1901_ sky130_fd_sc_hd__xor2_1
XFILLER_0_59_184 VGND VGND VPWR VPWR sky130_fd_sc_hd__decap_4
X_5895_ _2673_ VGND VGND VPWR VPWR _0524_ sky130_fd_sc_hd__clkbuf_1
XFILLER_0_117_223 VGND VGND VPWR VPWR sky130_fd_sc_hd__fill_1
X_7634_ clknet_leaf_66_clk net169 net946 VGND VGND VPWR VPWR u_pe_array.g_pe_row\[1\].g_pe_col\[0\].u_pe.move_reg\[7\]
+ sky130_fd_sc_hd__dfrtp_1
XFILLER_0_23_91 VGND VGND VPWR VPWR sky130_fd_sc_hd__fill_2
X_4846_ _1861_ _1862_ VGND VGND VPWR VPWR _1863_ sky130_fd_sc_hd__xnor2_1
X_7565_ clknet_leaf_47_clk _0471_ net73 VGND VGND VPWR VPWR u_pe_array.act_from_down\[1\]\[5\]
+ sky130_fd_sc_hd__dfrtp_1
XFILLER_0_28_571 VGND VGND VPWR VPWR sky130_fd_sc_hd__decap_3
X_6516_ _3136_ _3146_ VGND VGND VPWR VPWR _3147_ sky130_fd_sc_hd__xnor2_1
XFILLER_0_99_51 VGND VGND VPWR VPWR sky130_fd_sc_hd__decap_4
XFILLER_0_7_487 VGND VGND VPWR VPWR sky130_fd_sc_hd__fill_1
XFILLER_0_15_221 VGND VGND VPWR VPWR sky130_fd_sc_hd__decap_3
XFILLER_0_15_232 VPWR VGND VPWR VGND sky130_ef_sc_hd__decap_12
X_4777_ _1789_ _1792_ _1800_ VGND VGND VPWR VPWR _1801_ sky130_fd_sc_hd__or3_1
X_7496_ clknet_leaf_37_clk _0402_ net951 VGND VGND VPWR VPWR u_pe_array.g_pe_row\[1\].g_pe_col\[3\].u_pe.psum_out\[5\]
+ sky130_fd_sc_hd__dfrtp_1
XFILLER_0_70_360 VGND VGND VPWR VPWR sky130_fd_sc_hd__decap_4
X_3728_ u_pe_array.g_pe_row\[3\].g_pe_col\[3\].u_pe.act_val\[1\] u_pe_array.g_pe_row\[3\].g_pe_col\[3\].u_pe.w_out\[0\]
+ VGND VGND VPWR VPWR _0987_ sky130_fd_sc_hd__nand2_1
X_6447_ u_pe_array.g_pe_row\[0\].g_pe_col\[1\].u_pe.psum_out\[2\] u_pe_array.g_pe_row\[0\].g_pe_col\[1\].u_pe.act_val\[2\]
+ _3102_ VGND VGND VPWR VPWR _3105_ sky130_fd_sc_hd__mux2_1
XFILLER_0_101_602 VPWR VGND VPWR VGND sky130_ef_sc_hd__decap_12
XFILLER_0_3_671 VGND VGND VPWR VPWR sky130_fd_sc_hd__fill_1
X_3659_ u_pe_array.g_pe_row\[0\].g_pe_col\[0\].u_pe.psum_shift_en_d _0865_ VGND VGND
+ VPWR VPWR _0945_ sky130_fd_sc_hd__or2_1
X_6378_ u_pe_array.g_pe_row\[0\].g_pe_col\[2\].u_pe.act_val\[4\] _3046_ _3036_ _3034_
+ VGND VGND VPWR VPWR _3047_ sky130_fd_sc_hd__o22ai_2
XFILLER_0_100_145 VGND VGND VPWR VPWR sky130_fd_sc_hd__fill_1
X_5329_ _2226_ _2227_ VGND VGND VPWR VPWR _2228_ sky130_fd_sc_hd__and2_1
XFILLER_0_97_279 VGND VGND VPWR VPWR sky130_fd_sc_hd__fill_1
XFILLER_0_65_110 VGND VGND VPWR VPWR sky130_fd_sc_hd__fill_2
XFILLER_0_108_234 VGND VGND VPWR VPWR sky130_fd_sc_hd__fill_2
XFILLER_0_66_699 VGND VGND VPWR VPWR sky130_fd_sc_hd__fill_1
XFILLER_0_38_357 VGND VGND VPWR VPWR sky130_fd_sc_hd__decap_6
XFILLER_0_65_176 VGND VGND VPWR VPWR sky130_fd_sc_hd__fill_1
XFILLER_0_53_327 VGND VGND VPWR VPWR sky130_fd_sc_hd__fill_1
XFILLER_0_53_349 VGND VGND VPWR VPWR sky130_fd_sc_hd__fill_2
XFILLER_0_110_29 VPWR VGND VPWR VGND sky130_ef_sc_hd__decap_12
XFILLER_0_61_393 VGND VGND VPWR VPWR sky130_fd_sc_hd__decap_8
XTAP_419 VGND VPWR sky130_fd_sc_hd__tapvpwrvgnd_1
XTAP_408 VGND VPWR sky130_fd_sc_hd__tapvpwrvgnd_1
XFILLER_0_57_611 VGND VGND VPWR VPWR sky130_fd_sc_hd__decap_4
X_5680_ net416 _2499_ _2491_ _2504_ VGND VGND VPWR VPWR _0478_ sky130_fd_sc_hd__a22o_1
XTAP_1191 VGND VPWR sky130_fd_sc_hd__tapvpwrvgnd_1
XTAP_1180 VGND VPWR sky130_fd_sc_hd__tapvpwrvgnd_1
X_4700_ net429 _1732_ _1735_ _1745_ VGND VGND VPWR VPWR _0257_ sky130_fd_sc_hd__a22o_1
XFILLER_0_71_113 VGND VGND VPWR VPWR sky130_fd_sc_hd__fill_1
X_4631_ _1675_ _1685_ u_pe_array.g_pe_row\[2\].g_pe_col\[3\].u_pe.psum_out\[7\] _1671_
+ VGND VGND VPWR VPWR _1693_ sky130_fd_sc_hd__o2bb2a_1
XFILLER_0_44_349 VPWR VGND VPWR VGND sky130_ef_sc_hd__decap_12
X_7350_ clknet_leaf_0_clk _0256_ net950 VGND VGND VPWR VPWR u_pe_array.act_from_up\[14\]\[8\]
+ sky130_fd_sc_hd__dfrtp_1
X_4562_ _1620_ _1621_ VGND VGND VPWR VPWR _1630_ sky130_fd_sc_hd__and2_1
Xhold615 u_pe_array.g_pe_row\[2\].g_pe_col\[0\].u_pe.psum_out\[6\] VGND VGND VPWR
+ VPWR net689 sky130_fd_sc_hd__dlygate4sd3_1
X_7281_ clknet_leaf_38_clk net363 net942 VGND VGND VPWR VPWR u_pe_array.g_pe_row\[3\].g_pe_col\[0\].u_pe.move_reg\[8\]
+ sky130_fd_sc_hd__dfrtp_1
XFILLER_0_69_54 VGND VGND VPWR VPWR sky130_fd_sc_hd__fill_2
X_6301_ u_pe_array.g_pe_row\[0\].g_pe_col\[2\].u_pe.act_val\[2\] _2853_ _2847_ net218
+ VGND VGND VPWR VPWR _0617_ sky130_fd_sc_hd__a22o_1
Xhold626 u_pe_array.g_pe_row\[2\].g_pe_col\[2\].u_pe.psum_out\[12\] VGND VGND VPWR
+ VPWR net700 sky130_fd_sc_hd__dlygate4sd3_1
X_4493_ _1577_ _1582_ _1588_ _1591_ _1587_ VGND VGND VPWR VPWR _1592_ sky130_fd_sc_hd__a32o_1
Xhold604 u_pe_array.g_pe_row\[1\].g_pe_col\[2\].u_pe.psum_out\[10\] VGND VGND VPWR
+ VPWR net678 sky130_fd_sc_hd__dlygate4sd3_1
XFILLER_0_110_432 VGND VGND VPWR VPWR sky130_fd_sc_hd__fill_1
Xhold659 u_pe_array.g_pe_row\[2\].g_pe_col\[0\].u_pe.psum_out\[9\] VGND VGND VPWR
+ VPWR net733 sky130_fd_sc_hd__dlygate4sd3_1
Xhold648 u_pe_array.g_pe_row\[2\].g_pe_col\[1\].u_pe.psum_out\[9\] VGND VGND VPWR
+ VPWR net722 sky130_fd_sc_hd__dlygate4sd3_1
Xhold637 u_pe_array.g_pe_row\[0\].g_pe_col\[3\].u_pe.psum_out\[6\] VGND VGND VPWR
+ VPWR net711 sky130_fd_sc_hd__dlygate4sd3_1
X_6232_ u_pe_array.g_pe_row\[0\].g_pe_col\[3\].u_pe.psum_out\[8\] _1999_ VGND VGND
+ VPWR VPWR _2940_ sky130_fd_sc_hd__or2_1
Xclkbuf_leaf_6_clk clknet_3_0__leaf_clk VGND VGND VPWR VPWR clknet_leaf_6_clk sky130_fd_sc_hd__clkbuf_16
XFILLER_0_110_465 VGND VGND VPWR VPWR sky130_fd_sc_hd__fill_1
XFILLER_0_85_53 VGND VGND VPWR VPWR sky130_fd_sc_hd__decap_3
X_6163_ _2870_ _2876_ VGND VGND VPWR VPWR _2877_ sky130_fd_sc_hd__nor2_1
XTAP_953 VGND VPWR sky130_fd_sc_hd__tapvpwrvgnd_1
XTAP_942 VGND VPWR sky130_fd_sc_hd__tapvpwrvgnd_1
XTAP_931 VGND VPWR sky130_fd_sc_hd__tapvpwrvgnd_1
XFILLER_0_0_685 VGND VGND VPWR VPWR sky130_fd_sc_hd__decap_4
XTAP_920 VGND VPWR sky130_fd_sc_hd__tapvpwrvgnd_1
X_5114_ _2054_ _2055_ VGND VGND VPWR VPWR _2057_ sky130_fd_sc_hd__nor2_1
XTAP_986 VGND VPWR sky130_fd_sc_hd__tapvpwrvgnd_1
XTAP_975 VGND VPWR sky130_fd_sc_hd__tapvpwrvgnd_1
X_6094_ _2824_ _2829_ _2835_ _2838_ _2834_ VGND VGND VPWR VPWR _2839_ sky130_fd_sc_hd__a32o_1
XTAP_964 VGND VPWR sky130_fd_sc_hd__tapvpwrvgnd_1
XFILLER_0_109_93 VPWR VGND VPWR VGND sky130_ef_sc_hd__decap_12
X_5045_ net212 _2006_ _2009_ _2010_ VGND VGND VPWR VPWR _0337_ sky130_fd_sc_hd__a22o_1
XTAP_997 VGND VPWR sky130_fd_sc_hd__tapvpwrvgnd_1
XFILLER_0_26_3 VGND VGND VPWR VPWR sky130_fd_sc_hd__decap_3
XFILLER_0_94_227 VPWR VGND VPWR VGND sky130_ef_sc_hd__decap_12
X_6996_ _3490_ VGND VGND VPWR VPWR _0808_ sky130_fd_sc_hd__clkbuf_1
X_5947_ u_pe_array.u_fifo1.buffer\[8\]\[3\] _2676_ _2709_ _2713_ _0857_ VGND VGND
+ VPWR VPWR _2714_ sky130_fd_sc_hd__a221o_1
XFILLER_0_47_154 VGND VGND VPWR VPWR sky130_fd_sc_hd__decap_6
X_5878_ u_pe_array.g_pe_row\[1\].g_pe_col\[0\].u_pe.move_reg\[11\] net62 VGND VGND
+ VPWR VPWR _2663_ sky130_fd_sc_hd__or2_1
X_7617_ clknet_leaf_39_clk _0523_ net947 VGND VGND VPWR VPWR u_pe_array.act_from_left\[5\]\[3\]
+ sky130_fd_sc_hd__dfrtp_1
XFILLER_0_63_625 VGND VGND VPWR VPWR sky130_fd_sc_hd__decap_3
XFILLER_0_118_587 VGND VGND VPWR VPWR sky130_fd_sc_hd__fill_1
XFILLER_0_118_576 VGND VGND VPWR VPWR sky130_fd_sc_hd__fill_1
X_4829_ u_pe_array.g_pe_row\[2\].g_pe_col\[2\].u_pe.psum_out\[10\] _0933_ VGND VGND
+ VPWR VPWR _1848_ sky130_fd_sc_hd__or2_1
XFILLER_0_16_585 VGND VGND VPWR VPWR sky130_fd_sc_hd__decap_3
XFILLER_0_31_500 VGND VGND VPWR VPWR sky130_fd_sc_hd__decap_4
X_7548_ clknet_leaf_92_clk _0454_ net948 VGND VGND VPWR VPWR u_pe_array.g_pe_row\[1\].g_pe_col\[2\].u_pe.psum_out\[3\]
+ sky130_fd_sc_hd__dfrtp_1
XFILLER_0_43_360 VGND VGND VPWR VPWR sky130_fd_sc_hd__fill_2
X_7479_ clknet_leaf_65_clk net850 net946 VGND VGND VPWR VPWR u_pe_array.g_pe_row\[1\].g_pe_col\[3\].u_pe.act_val\[1\]
+ sky130_fd_sc_hd__dfrtp_2
XFILLER_0_43_393 VGND VGND VPWR VPWR sky130_fd_sc_hd__decap_4
XFILLER_0_101_443 VGND VGND VPWR VPWR sky130_fd_sc_hd__decap_4
XFILLER_0_14_27 VGND VGND VPWR VPWR sky130_fd_sc_hd__fill_1
XFILLER_0_14_49 VGND VGND VPWR VPWR sky130_fd_sc_hd__decap_3
XPHY_230 VGND VGND VPWR VPWR sky130_fd_sc_hd__decap_3
XFILLER_0_66_452 VGND VGND VPWR VPWR sky130_fd_sc_hd__decap_6
XFILLER_0_109_543 VGND VGND VPWR VPWR sky130_fd_sc_hd__decap_4
XFILLER_0_66_474 VGND VGND VPWR VPWR sky130_fd_sc_hd__fill_2
XFILLER_0_30_15 VPWR VGND VPWR VGND sky130_ef_sc_hd__decap_12
XFILLER_0_61_190 VPWR VGND VPWR VGND sky130_ef_sc_hd__decap_12
XFILLER_0_1_405 VPWR VGND VPWR VGND sky130_ef_sc_hd__decap_12
XFILLER_0_22_544 VGND VGND VPWR VPWR sky130_fd_sc_hd__decap_6
XFILLER_0_104_281 VGND VGND VPWR VPWR sky130_fd_sc_hd__decap_3
XFILLER_0_1_449 VPWR VGND VPWR VGND sky130_ef_sc_hd__decap_12
XTAP_238 VGND VPWR sky130_fd_sc_hd__tapvpwrvgnd_1
XTAP_249 VGND VPWR sky130_fd_sc_hd__tapvpwrvgnd_1
Xhold1 u_pe_array.act_from_down\[9\]\[7\] VGND VGND VPWR VPWR net75 sky130_fd_sc_hd__dlygate4sd3_1
XFILLER_0_55_78 VGND VGND VPWR VPWR sky130_fd_sc_hd__decap_3
XFILLER_0_55_45 VGND VGND VPWR VPWR sky130_fd_sc_hd__decap_8
XFILLER_0_55_89 VGND VGND VPWR VPWR sky130_fd_sc_hd__fill_2
XFILLER_0_71_11 VGND VGND VPWR VPWR sky130_fd_sc_hd__fill_1
X_6850_ _3403_ VGND VGND VPWR VPWR _0749_ sky130_fd_sc_hd__clkbuf_1
X_5801_ _2592_ _2600_ _2601_ _2602_ VGND VGND VPWR VPWR _2603_ sky130_fd_sc_hd__a31o_1
XFILLER_0_71_55 VGND VGND VPWR VPWR sky130_fd_sc_hd__fill_1
XFILLER_0_9_505 VGND VGND VPWR VPWR sky130_fd_sc_hd__decap_6
X_6781_ u_pe_array.act_from_up\[12\]\[3\] _0869_ _0854_ VGND VGND VPWR VPWR _3358_
+ sky130_fd_sc_hd__and3_4
X_5732_ _2537_ _2539_ VGND VGND VPWR VPWR _2540_ sky130_fd_sc_hd__nor2_1
X_3993_ _1122_ u_pe_array.g_pe_row\[3\].g_pe_col\[2\].u_pe.psum_out\[3\] _0934_ VGND
+ VGND VPWR VPWR _1196_ sky130_fd_sc_hd__and3_1
XFILLER_0_45_636 VPWR VGND VPWR VGND sky130_ef_sc_hd__decap_12
X_5663_ net253 _2143_ _2491_ _2495_ VGND VGND VPWR VPWR _0470_ sky130_fd_sc_hd__a22o_1
XFILLER_0_84_293 VGND VGND VPWR VPWR sky130_fd_sc_hd__decap_6
XFILLER_0_45_669 VGND VGND VPWR VPWR sky130_fd_sc_hd__decap_3
XFILLER_0_115_557 VGND VGND VPWR VPWR sky130_fd_sc_hd__decap_3
X_7402_ clknet_leaf_15_clk net227 net942 VGND VGND VPWR VPWR u_pe_array.g_pe_row\[2\].g_pe_col\[1\].u_pe.move_reg\[6\]
+ sky130_fd_sc_hd__dfrtp_1
XFILLER_0_72_477 VGND VGND VPWR VPWR sky130_fd_sc_hd__decap_3
XFILLER_0_4_232 VPWR VGND VPWR VGND sky130_ef_sc_hd__decap_12
XFILLER_0_4_221 VGND VGND VPWR VPWR sky130_fd_sc_hd__decap_8
X_4614_ _1665_ VGND VGND VPWR VPWR _1678_ sky130_fd_sc_hd__inv_2
X_5594_ _2437_ _2439_ VGND VGND VPWR VPWR _2440_ sky130_fd_sc_hd__xnor2_1
XFILLER_0_115_568 VGND VGND VPWR VPWR sky130_fd_sc_hd__decap_6
Xhold401 _0578_ VGND VGND VPWR VPWR net475 sky130_fd_sc_hd__dlygate4sd3_1
XFILLER_0_25_393 VGND VGND VPWR VPWR sky130_fd_sc_hd__decap_3
X_4545_ u_pe_array.g_pe_row\[2\].g_pe_col\[3\].u_pe.act_val\[0\] _1424_ u_pe_array.g_pe_row\[2\].g_pe_col\[3\].u_pe.psum_out\[0\]
+ VGND VGND VPWR VPWR _1615_ sky130_fd_sc_hd__a21o_1
X_7333_ clknet_leaf_3_clk _0239_ net944 VGND VGND VPWR VPWR u_pe_array.g_pe_row\[2\].g_pe_col\[3\].u_pe.psum_out\[6\]
+ sky130_fd_sc_hd__dfrtp_1
Xhold434 u_pe_array.g_pe_row\[0\].g_pe_col\[0\].u_pe.move_reg\[7\] VGND VGND VPWR
+ VPWR net508 sky130_fd_sc_hd__dlygate4sd3_1
Xhold423 u_pe_array.g_pe_row\[0\].g_pe_col\[3\].u_pe.move_reg\[12\] VGND VGND VPWR
+ VPWR net497 sky130_fd_sc_hd__dlygate4sd3_1
Xhold445 u_pe_array.act_from_down\[3\]\[6\] VGND VGND VPWR VPWR net519 sky130_fd_sc_hd__dlygate4sd3_1
Xhold412 u_pe_array.g_pe_row\[2\].g_pe_col\[2\].u_pe.psum_out\[6\] VGND VGND VPWR
+ VPWR net486 sky130_fd_sc_hd__dlygate4sd3_1
XFILLER_0_40_352 VGND VGND VPWR VPWR sky130_fd_sc_hd__fill_1
Xhold456 u_pe_array.act_from_down\[3\]\[7\] VGND VGND VPWR VPWR net530 sky130_fd_sc_hd__dlygate4sd3_1
Xhold467 u_pe_array.g_pe_row\[1\].g_pe_col\[3\].u_pe.psum_out\[2\] VGND VGND VPWR
+ VPWR net541 sky130_fd_sc_hd__dlygate4sd3_1
X_7264_ clknet_leaf_5_clk _0170_ net945 VGND VGND VPWR VPWR u_pe_array.act_from_left\[13\]\[4\]
+ sky130_fd_sc_hd__dfrtp_1
Xhold478 u_pe_array.u_fifo1.buffer\[0\]\[4\] VGND VGND VPWR VPWR net552 sky130_fd_sc_hd__dlygate4sd3_1
X_4476_ _1570_ _1571_ _1576_ _1573_ _1568_ VGND VGND VPWR VPWR _1577_ sky130_fd_sc_hd__a32o_1
XFILLER_0_110_262 VGND VGND VPWR VPWR sky130_fd_sc_hd__decap_8
XFILLER_0_110_251 VGND VGND VPWR VPWR sky130_fd_sc_hd__fill_1
XFILLER_0_96_85 VGND VGND VPWR VPWR sky130_fd_sc_hd__fill_1
X_6215_ _2918_ _2923_ VGND VGND VPWR VPWR _2925_ sky130_fd_sc_hd__nand2_1
X_7195_ clknet_leaf_103_clk _0101_ net950 VGND VGND VPWR VPWR u_pe_array.g_pe_row\[3\].g_pe_col\[2\].u_pe.psum_out\[4\]
+ sky130_fd_sc_hd__dfrtp_1
Xhold489 u_pe_array.u_fifo2.buffer\[0\]\[3\] VGND VGND VPWR VPWR net563 sky130_fd_sc_hd__dlygate4sd3_1
X_6146_ _2861_ VGND VGND VPWR VPWR _2862_ sky130_fd_sc_hd__inv_2
XTAP_750 VGND VPWR sky130_fd_sc_hd__tapvpwrvgnd_1
XTAP_761 VGND VPWR sky130_fd_sc_hd__tapvpwrvgnd_1
XTAP_772 VGND VPWR sky130_fd_sc_hd__tapvpwrvgnd_1
XTAP_783 VGND VPWR sky130_fd_sc_hd__tapvpwrvgnd_1
XTAP_794 VGND VPWR sky130_fd_sc_hd__tapvpwrvgnd_1
X_6077_ _2817_ _2818_ _2823_ _2820_ _2815_ VGND VGND VPWR VPWR _2824_ sky130_fd_sc_hd__a32o_1
X_5028_ u_pe_array.g_pe_row\[2\].g_pe_col\[0\].u_pe.psum_out\[0\] u_pe_array.g_pe_row\[2\].g_pe_col\[0\].u_pe.act_val\[0\]
+ _1867_ VGND VGND VPWR VPWR _2001_ sky130_fd_sc_hd__mux2_1
XFILLER_0_95_503 VGND VGND VPWR VPWR sky130_fd_sc_hd__fill_1
X_6979_ u_pe_array.u_fifo1.count\[3\] _3478_ VGND VGND VPWR VPWR _3480_ sky130_fd_sc_hd__nand2_1
XFILLER_0_118_384 VGND VGND VPWR VPWR sky130_fd_sc_hd__decap_8
XFILLER_0_118_373 VGND VGND VPWR VPWR sky130_fd_sc_hd__decap_3
XFILLER_0_118_362 VGND VGND VPWR VPWR sky130_fd_sc_hd__fill_2
XFILLER_0_106_513 VGND VGND VPWR VPWR sky130_fd_sc_hd__fill_1
XFILLER_0_75_293 VGND VGND VPWR VPWR sky130_fd_sc_hd__fill_2
XFILLER_0_8_582 VGND VGND VPWR VPWR sky130_fd_sc_hd__decap_6
XFILLER_0_51_617 VGND VGND VPWR VPWR sky130_fd_sc_hd__fill_1
XFILLER_0_106_568 VGND VGND VPWR VPWR sky130_fd_sc_hd__fill_2
XFILLER_0_101_262 VGND VGND VPWR VPWR sky130_fd_sc_hd__decap_6
XFILLER_0_98_396 VGND VGND VPWR VPWR sky130_fd_sc_hd__fill_2
XFILLER_0_54_400 VGND VGND VPWR VPWR sky130_fd_sc_hd__decap_8
XFILLER_0_41_105 VGND VGND VPWR VPWR sky130_fd_sc_hd__decap_6
XFILLER_0_112_549 VGND VGND VPWR VPWR sky130_fd_sc_hd__fill_1
XFILLER_0_112_527 VGND VGND VPWR VPWR sky130_fd_sc_hd__decap_4
XFILLER_0_22_341 VGND VGND VPWR VPWR sky130_fd_sc_hd__fill_2
X_4330_ u_pe_array.g_pe_row\[3\].g_pe_col\[0\].u_pe.psum_out\[12\] _1108_ _1110_ _1467_
+ VGND VGND VPWR VPWR _1468_ sky130_fd_sc_hd__o211a_2
X_4261_ _1106_ u_pe_array.g_pe_row\[3\].g_pe_col\[1\].u_pe.psum_out\[11\] VGND VGND
+ VPWR VPWR _1415_ sky130_fd_sc_hd__and2b_1
XFILLER_0_1_279 VGND VGND VPWR VPWR sky130_fd_sc_hd__fill_1
XFILLER_0_5_69 VPWR VGND VPWR VGND sky130_ef_sc_hd__decap_12
X_6000_ _2752_ _2753_ VGND VGND VPWR VPWR _2754_ sky130_fd_sc_hd__nand2_1
X_4192_ _1340_ _1337_ _1336_ VGND VGND VPWR VPWR _1353_ sky130_fd_sc_hd__a21o_1
X_6902_ _0920_ net605 _3431_ VGND VGND VPWR VPWR _3433_ sky130_fd_sc_hd__mux2_1
X_7882_ clknet_leaf_98_clk _0787_ VGND VGND VPWR VPWR u_pe_array.u_fifo2.buffer\[7\]\[4\]
+ sky130_fd_sc_hd__dfxtp_1
X_6833_ net547 _0920_ _3392_ VGND VGND VPWR VPWR _3394_ sky130_fd_sc_hd__mux2_1
XFILLER_0_106_83 VGND VGND VPWR VPWR sky130_fd_sc_hd__fill_1
X_6764_ u_pe_array.g_pe_row\[0\].g_pe_col\[0\].u_pe.psum_out\[12\] _3338_ VGND VGND
+ VPWR VPWR _3345_ sky130_fd_sc_hd__xnor2_1
XFILLER_0_17_102 VGND VGND VPWR VPWR sky130_fd_sc_hd__decap_4
X_3976_ _1177_ _1178_ _1179_ VGND VGND VPWR VPWR _1181_ sky130_fd_sc_hd__or3_1
X_5715_ u_pe_array.g_pe_row\[1\].g_pe_col\[1\].u_pe.act_val\[1\] _1728_ VGND VGND
+ VPWR VPWR _2524_ sky130_fd_sc_hd__and2b_1
X_6695_ _3275_ _3282_ _0977_ VGND VGND VPWR VPWR _3284_ sky130_fd_sc_hd__o21a_1
XFILLER_0_85_591 VGND VGND VPWR VPWR sky130_fd_sc_hd__decap_8
XFILLER_0_93_3 VPWR VGND VPWR VGND sky130_ef_sc_hd__decap_12
XFILLER_0_33_617 VGND VGND VPWR VPWR sky130_fd_sc_hd__fill_2
X_5646_ net727 _1904_ _2485_ _1726_ VGND VGND VPWR VPWR _0463_ sky130_fd_sc_hd__a22o_1
XFILLER_0_103_505 VGND VGND VPWR VPWR sky130_fd_sc_hd__decap_8
XFILLER_0_32_138 VGND VGND VPWR VPWR sky130_fd_sc_hd__fill_2
Xhold220 _0313_ VGND VGND VPWR VPWR net294 sky130_fd_sc_hd__dlygate4sd3_1
X_5577_ u_pe_array.g_pe_row\[1\].g_pe_col\[2\].u_pe.psum_out\[5\] _2423_ VGND VGND
+ VPWR VPWR _2424_ sky130_fd_sc_hd__xnor2_1
Xhold231 u_pe_array.act_from_down\[1\]\[6\] VGND VGND VPWR VPWR net305 sky130_fd_sc_hd__dlygate4sd3_1
Xhold242 u_pe_array.act_from_right\[5\]\[9\] VGND VGND VPWR VPWR net316 sky130_fd_sc_hd__dlygate4sd3_1
Xhold253 _0616_ VGND VGND VPWR VPWR net327 sky130_fd_sc_hd__dlygate4sd3_1
X_7316_ clknet_leaf_3_clk net163 net944 VGND VGND VPWR VPWR u_pe_array.g_pe_row\[2\].g_pe_col\[3\].u_pe.act_val\[2\]
+ sky130_fd_sc_hd__dfrtp_4
X_4528_ u_pe_array.g_pe_row\[2\].g_pe_col\[3\].u_pe.psum_out\[11\] u_pe_array.g_pe_row\[2\].g_pe_col\[3\].u_pe.move_reg\[11\]
+ _1599_ VGND VGND VPWR VPWR _1613_ sky130_fd_sc_hd__mux2_1
Xhold264 _0230_ VGND VGND VPWR VPWR net338 sky130_fd_sc_hd__dlygate4sd3_1
Xhold286 u_pe_array.act_from_down\[11\]\[8\] VGND VGND VPWR VPWR net360 sky130_fd_sc_hd__dlygate4sd3_1
Xhold275 u_pe_array.act_from_down\[11\]\[6\] VGND VGND VPWR VPWR net349 sky130_fd_sc_hd__dlygate4sd3_1
X_7247_ clknet_leaf_79_clk _0153_ net948 VGND VGND VPWR VPWR net49 sky130_fd_sc_hd__dfrtp_1
X_4459_ u_pe_array.g_pe_row\[3\].g_pe_col\[0\].u_pe.psum_out\[8\] _1287_ VGND VGND
+ VPWR VPWR _1562_ sky130_fd_sc_hd__nand2_1
Xhold297 u_pe_array.act_from_right\[10\]\[6\] VGND VGND VPWR VPWR net371 sky130_fd_sc_hd__dlygate4sd3_1
X_7178_ clknet_leaf_9_clk _0084_ net945 VGND VGND VPWR VPWR u_pe_array.g_pe_row\[3\].g_pe_col\[2\].u_pe.act_val\[0\]
+ sky130_fd_sc_hd__dfrtp_4
XFILLER_0_99_116 VGND VGND VPWR VPWR sky130_fd_sc_hd__decap_6
X_6129_ u_pe_array.g_pe_row\[0\].g_pe_col\[3\].u_pe.psum_out\[12\] net497 _2844_ VGND
+ VGND VPWR VPWR _2859_ sky130_fd_sc_hd__mux2_1
XTAP_591 VGND VPWR sky130_fd_sc_hd__tapvpwrvgnd_1
XTAP_580 VGND VPWR sky130_fd_sc_hd__tapvpwrvgnd_1
XTAP_1724 VGND VPWR sky130_fd_sc_hd__tapvpwrvgnd_1
XTAP_1713 VGND VPWR sky130_fd_sc_hd__tapvpwrvgnd_1
XTAP_1702 VGND VPWR sky130_fd_sc_hd__tapvpwrvgnd_1
XFILLER_0_95_333 VGND VGND VPWR VPWR sky130_fd_sc_hd__decap_3
XTAP_1746 VGND VPWR sky130_fd_sc_hd__tapvpwrvgnd_1
XTAP_1735 VGND VPWR sky130_fd_sc_hd__tapvpwrvgnd_1
XFILLER_0_118_181 VPWR VGND VPWR VGND sky130_ef_sc_hd__decap_12
XFILLER_0_91_550 VGND VGND VPWR VPWR sky130_fd_sc_hd__fill_1
XFILLER_0_63_252 VGND VGND VPWR VPWR sky130_fd_sc_hd__decap_8
XFILLER_0_11_39 VPWR VGND VPWR VGND sky130_ef_sc_hd__decap_12
XFILLER_0_36_477 VGND VGND VPWR VPWR sky130_fd_sc_hd__fill_1
XFILLER_0_36_488 VGND VGND VPWR VPWR sky130_fd_sc_hd__decap_3
XFILLER_0_63_296 VGND VGND VPWR VPWR sky130_fd_sc_hd__fill_1
XFILLER_0_51_425 VGND VGND VPWR VPWR sky130_fd_sc_hd__fill_2
X_3830_ _1070_ _1078_ _1079_ _1080_ VGND VGND VPWR VPWR _1081_ sky130_fd_sc_hd__a31o_1
XFILLER_0_116_118 VPWR VGND VPWR VGND sky130_ef_sc_hd__decap_12
X_3761_ _1014_ _1016_ VGND VGND VPWR VPWR _1018_ sky130_fd_sc_hd__nand2_1
XFILLER_0_39_293 VPWR VGND VPWR VGND sky130_ef_sc_hd__decap_12
X_5500_ u_pe_array.u_fifo2.buffer\[4\]\[3\] net68 _2359_ _2361_ VGND VGND VPWR VPWR
+ _2362_ sky130_fd_sc_hd__a211o_1
X_6480_ u_pe_array.act_from_down\[1\]\[11\] _0866_ _0940_ net265 VGND VGND VPWR VPWR
+ _0667_ sky130_fd_sc_hd__a22o_1
X_3692_ u_pe_array.g_pe_row\[3\].g_pe_col\[3\].u_pe.act_val\[0\] _0949_ _0944_ _0964_
+ VGND VGND VPWR VPWR _0030_ sky130_fd_sc_hd__a22o_1
XFILLER_0_14_138 VGND VGND VPWR VPWR sky130_fd_sc_hd__fill_2
XFILLER_0_14_127 VGND VGND VPWR VPWR sky130_fd_sc_hd__fill_1
X_5431_ _2310_ VGND VGND VPWR VPWR _0423_ sky130_fd_sc_hd__clkbuf_1
XFILLER_0_2_533 VPWR VGND VPWR VGND sky130_ef_sc_hd__decap_12
X_5362_ u_pe_array.g_pe_row\[1\].g_pe_col\[3\].u_pe.psum_out\[10\] _2244_ _2250_ _2254_
+ VGND VGND VPWR VPWR _2257_ sky130_fd_sc_hd__a2bb2o_1
X_4313_ u_pe_array.g_pe_row\[3\].g_pe_col\[0\].u_pe.move_reg\[8\] net62 VGND VGND
+ VPWR VPWR _1455_ sky130_fd_sc_hd__or2_1
X_7101_ clknet_leaf_83_clk _0007_ net948 VGND VGND VPWR VPWR u_fsm.v_cnt\[1\] sky130_fd_sc_hd__dfrtp_1
X_5293_ u_pe_array.g_pe_row\[1\].g_pe_col\[3\].u_pe.act_val\[4\] _1423_ u_pe_array.g_pe_row\[1\].g_pe_col\[3\].u_pe.psum_out\[4\]
+ VGND VGND VPWR VPWR _2195_ sky130_fd_sc_hd__a21oi_1
X_7032_ _3510_ VGND VGND VPWR VPWR _0824_ sky130_fd_sc_hd__clkbuf_1
X_4244_ u_pe_array.g_pe_row\[3\].g_pe_col\[1\].u_pe.psum_out\[9\] _1106_ VGND VGND
+ VPWR VPWR _1400_ sky130_fd_sc_hd__or2_1
X_4175_ _1328_ _1329_ _1335_ VGND VGND VPWR VPWR _1337_ sky130_fd_sc_hd__o21ai_1
XFILLER_0_117_93 VPWR VGND VPWR VGND sky130_ef_sc_hd__decap_12
XTAP_1009 VGND VPWR sky130_fd_sc_hd__tapvpwrvgnd_1
X_7934_ clknet_leaf_77_clk _0839_ VGND VGND VPWR VPWR u_pe_array.u_fifo1.buffer\[6\]\[0\]
+ sky130_fd_sc_hd__dfxtp_1
XFILLER_0_77_366 VGND VGND VPWR VPWR sky130_fd_sc_hd__fill_2
X_7865_ clknet_leaf_99_clk _0770_ VGND VGND VPWR VPWR u_pe_array.u_fifo2.buffer\[4\]\[5\]
+ sky130_fd_sc_hd__dfxtp_1
X_7796_ clknet_leaf_54_clk _0701_ net74 VGND VGND VPWR VPWR u_pe_array.g_pe_row\[0\].g_pe_col\[0\].u_pe.act_val\[4\]
+ sky130_fd_sc_hd__dfrtp_4
XFILLER_0_77_388 VGND VGND VPWR VPWR sky130_fd_sc_hd__fill_1
X_6816_ u_pe_array.u_fifo2.count\[1\] _0913_ _3381_ _2341_ VGND VGND VPWR VPWR _3382_
+ sky130_fd_sc_hd__and4bb_1
X_6747_ _3316_ _3320_ _3327_ _3329_ VGND VGND VPWR VPWR _3330_ sky130_fd_sc_hd__a31o_1
X_3959_ net726 _1167_ _1169_ _1173_ VGND VGND VPWR VPWR _0088_ sky130_fd_sc_hd__a22o_1
XFILLER_0_18_477 VPWR VGND VPWR VGND sky130_ef_sc_hd__decap_12
XFILLER_0_42_90 VGND VGND VPWR VPWR sky130_fd_sc_hd__fill_1
X_6678_ u_pe_array.g_pe_row\[0\].g_pe_col\[0\].u_pe.act_val\[2\] _3246_ _3265_ _3266_
+ VGND VGND VPWR VPWR _3268_ sky130_fd_sc_hd__o22ai_2
X_5629_ u_pe_array.g_pe_row\[1\].g_pe_col\[2\].u_pe.psum_out\[10\] _1597_ VGND VGND
+ VPWR VPWR _2471_ sky130_fd_sc_hd__or2_1
XFILLER_0_13_160 VGND VGND VPWR VPWR sky130_fd_sc_hd__decap_8
XTAP_1532 VGND VPWR sky130_fd_sc_hd__tapvpwrvgnd_1
XTAP_1521 VGND VPWR sky130_fd_sc_hd__tapvpwrvgnd_1
XTAP_1510 VGND VPWR sky130_fd_sc_hd__tapvpwrvgnd_1
XTAP_1565 VGND VPWR sky130_fd_sc_hd__tapvpwrvgnd_1
XTAP_1576 VGND VPWR sky130_fd_sc_hd__tapvpwrvgnd_1
XTAP_1554 VGND VPWR sky130_fd_sc_hd__tapvpwrvgnd_1
XTAP_1543 VGND VPWR sky130_fd_sc_hd__tapvpwrvgnd_1
XFILLER_0_56_528 VGND VGND VPWR VPWR sky130_fd_sc_hd__fill_1
XPHY_50 VGND VGND VPWR VPWR sky130_fd_sc_hd__decap_3
XPHY_61 VGND VGND VPWR VPWR sky130_fd_sc_hd__decap_3
XPHY_72 VGND VGND VPWR VPWR sky130_fd_sc_hd__decap_3
XPHY_83 VGND VGND VPWR VPWR sky130_fd_sc_hd__decap_3
XTAP_1598 VGND VPWR sky130_fd_sc_hd__tapvpwrvgnd_1
XTAP_1587 VGND VPWR sky130_fd_sc_hd__tapvpwrvgnd_1
XFILLER_0_22_27 VGND VGND VPWR VPWR sky130_fd_sc_hd__fill_1
XFILLER_0_22_49 VGND VGND VPWR VPWR sky130_fd_sc_hd__decap_6
XPHY_94 VGND VGND VPWR VPWR sky130_fd_sc_hd__decap_3
XFILLER_0_49_591 VGND VGND VPWR VPWR sky130_fd_sc_hd__decap_4
XFILLER_0_52_701 VGND VGND VPWR VPWR sky130_fd_sc_hd__decap_4
XFILLER_0_118_9 VPWR VGND VPWR VGND sky130_ef_sc_hd__decap_12
XFILLER_0_107_641 VPWR VGND VPWR VGND sky130_ef_sc_hd__decap_12
XFILLER_0_91_391 VGND VGND VPWR VPWR sky130_fd_sc_hd__fill_1
XFILLER_0_36_285 VGND VGND VPWR VPWR sky130_fd_sc_hd__decap_8
XFILLER_0_36_296 VGND VGND VPWR VPWR sky130_fd_sc_hd__decap_3
XFILLER_0_107_685 VPWR VGND VPWR VGND sky130_ef_sc_hd__decap_12
XFILLER_0_106_184 VGND VGND VPWR VPWR sky130_fd_sc_hd__decap_4
XFILLER_0_24_447 VGND VGND VPWR VPWR sky130_fd_sc_hd__decap_4
XFILLER_0_51_255 VGND VGND VPWR VPWR sky130_fd_sc_hd__decap_4
XFILLER_0_51_277 VGND VGND VPWR VPWR sky130_fd_sc_hd__decap_3
XFILLER_0_20_642 VGND VGND VPWR VPWR sky130_fd_sc_hd__fill_2
XFILLER_0_102_390 VGND VGND VPWR VPWR sky130_fd_sc_hd__decap_4
XFILLER_0_20_653 VGND VGND VPWR VPWR sky130_fd_sc_hd__decap_4
XFILLER_0_47_57 VPWR VGND VPWR VGND sky130_ef_sc_hd__decap_12
XFILLER_0_2_15 VPWR VGND VPWR VGND sky130_ef_sc_hd__decap_12
XFILLER_0_63_23 VGND VGND VPWR VPWR sky130_fd_sc_hd__fill_1
X_5980_ _2734_ _2735_ VGND VGND VPWR VPWR _2736_ sky130_fd_sc_hd__xor2_1
X_4931_ _1914_ _1915_ VGND VGND VPWR VPWR _1916_ sky130_fd_sc_hd__or2b_1
XFILLER_0_87_642 VPWR VGND VPWR VGND sky130_ef_sc_hd__decap_12
XFILLER_0_59_344 VGND VGND VPWR VPWR sky130_fd_sc_hd__decap_8
X_4862_ u_pe_array.g_pe_row\[2\].g_pe_col\[1\].u_pe.psum_out\[4\] u_pe_array.g_pe_row\[2\].g_pe_col\[1\].u_pe.act_val\[4\]
+ _1867_ VGND VGND VPWR VPWR _1872_ sky130_fd_sc_hd__mux2_1
XFILLER_0_87_697 VGND VGND VPWR VPWR sky130_fd_sc_hd__decap_8
XFILLER_0_74_303 VGND VGND VPWR VPWR sky130_fd_sc_hd__decap_4
X_7650_ clknet_leaf_66_clk _0556_ net72 VGND VGND VPWR VPWR u_pe_array.g_pe_row\[1\].g_pe_col\[0\].u_pe.psum_out\[10\]
+ sky130_fd_sc_hd__dfrtp_2
X_6601_ _1092_ _3222_ _3223_ _1005_ net604 VGND VGND VPWR VPWR _0680_ sky130_fd_sc_hd__a32o_1
X_3813_ _1049_ _1062_ VGND VGND VPWR VPWR _1065_ sky130_fd_sc_hd__and2b_1
XFILLER_0_74_358 VGND VGND VPWR VPWR sky130_fd_sc_hd__decap_6
XANTENNA_15 _1443_ VGND VGND VPWR VPWR sky130_fd_sc_hd__diode_2
XFILLER_0_103_51 VGND VGND VPWR VPWR sky130_fd_sc_hd__decap_4
X_7581_ clknet_leaf_67_clk net82 net72 VGND VGND VPWR VPWR u_pe_array.g_pe_row\[1\].g_pe_col\[1\].u_pe.move_reg\[8\]
+ sky130_fd_sc_hd__dfrtp_1
XFILLER_0_55_561 VPWR VGND VPWR VGND sky130_ef_sc_hd__decap_12
X_4793_ _1810_ _1815_ VGND VGND VPWR VPWR _1816_ sky130_fd_sc_hd__or2_1
X_6532_ _3159_ _3160_ VGND VGND VPWR VPWR _3161_ sky130_fd_sc_hd__xnor2_2
X_3744_ _0995_ _1001_ VGND VGND VPWR VPWR _1002_ sky130_fd_sc_hd__nor2_1
X_6463_ u_pe_array.g_pe_row\[0\].g_pe_col\[1\].u_pe.psum_out\[10\] net244 _3102_ VGND
+ VGND VPWR VPWR _3113_ sky130_fd_sc_hd__mux2_1
X_3675_ u_pe_array.g_pe_row\[3\].g_pe_col\[3\].u_pe.psum_out\[6\] u_pe_array.g_pe_row\[3\].g_pe_col\[3\].u_pe.move_reg\[6\]
+ _0947_ VGND VGND VPWR VPWR _0955_ sky130_fd_sc_hd__mux2_1
XFILLER_0_112_121 VPWR VGND VPWR VGND sky130_ef_sc_hd__decap_12
X_5414_ net269 _2297_ _2273_ VGND VGND VPWR VPWR _2298_ sky130_fd_sc_hd__mux2_1
X_6394_ _3054_ _3060_ VGND VGND VPWR VPWR _3062_ sky130_fd_sc_hd__or2_1
XFILLER_0_112_187 VGND VGND VPWR VPWR sky130_fd_sc_hd__decap_8
XFILLER_0_100_349 VGND VGND VPWR VPWR sky130_fd_sc_hd__decap_6
X_5345_ _2233_ _2241_ _2242_ _2173_ net721 VGND VGND VPWR VPWR _0405_ sky130_fd_sc_hd__a32o_1
XFILLER_0_56_3 VGND VGND VPWR VPWR sky130_fd_sc_hd__decap_4
XFILLER_0_11_653 VPWR VGND VPWR VGND sky130_ef_sc_hd__decap_12
XFILLER_0_10_141 VGND VGND VPWR VPWR sky130_fd_sc_hd__fill_1
X_5276_ net67 _2178_ _2174_ _2167_ VGND VGND VPWR VPWR _2180_ sky130_fd_sc_hd__o211a_1
XFILLER_0_11_697 VGND VGND VPWR VPWR sky130_fd_sc_hd__decap_8
X_4227_ _1378_ _1384_ VGND VGND VPWR VPWR _1385_ sky130_fd_sc_hd__nand2_1
X_7015_ _3501_ VGND VGND VPWR VPWR _0816_ sky130_fd_sc_hd__clkbuf_1
X_4158_ u_pe_array.g_pe_row\[3\].g_pe_col\[1\].u_pe.psum_out\[2\] _1320_ VGND VGND
+ VPWR VPWR _1321_ sky130_fd_sc_hd__xnor2_1
X_4089_ _1281_ _1282_ VGND VGND VPWR VPWR _1283_ sky130_fd_sc_hd__xnor2_1
X_7917_ clknet_leaf_77_clk _0822_ VGND VGND VPWR VPWR u_pe_array.u_fifo1.buffer\[3\]\[1\]
+ sky130_fd_sc_hd__dfxtp_1
XFILLER_0_78_675 VGND VGND VPWR VPWR sky130_fd_sc_hd__fill_2
XFILLER_0_38_517 VGND VGND VPWR VPWR sky130_fd_sc_hd__decap_6
X_7848_ clknet_leaf_100_clk _0753_ VGND VGND VPWR VPWR u_pe_array.u_fifo2.buffer\[2\]\[0\]
+ sky130_fd_sc_hd__dfxtp_1
XFILLER_0_34_701 VGND VGND VPWR VPWR sky130_fd_sc_hd__decap_4
XFILLER_0_46_561 VGND VGND VPWR VPWR sky130_fd_sc_hd__decap_6
X_7779_ clknet_leaf_73_clk _0685_ net13 VGND VGND VPWR VPWR u_pe_array.act_from_up\[4\]\[1\]
+ sky130_fd_sc_hd__dfrtp_1
XFILLER_0_73_380 VPWR VGND VPWR VGND sky130_ef_sc_hd__decap_12
XFILLER_0_116_471 VGND VGND VPWR VPWR sky130_fd_sc_hd__decap_4
XFILLER_0_104_633 VGND VGND VPWR VPWR sky130_fd_sc_hd__fill_1
XFILLER_0_104_699 VGND VGND VPWR VPWR sky130_fd_sc_hd__fill_1
XFILLER_0_108_29 VPWR VGND VPWR VGND sky130_ef_sc_hd__decap_12
XFILLER_0_17_27 VPWR VGND VPWR VGND sky130_ef_sc_hd__decap_12
XFILLER_0_69_664 VGND VGND VPWR VPWR sky130_fd_sc_hd__fill_1
XFILLER_0_33_15 VGND VGND VPWR VPWR sky130_fd_sc_hd__fill_1
XTAP_1340 VGND VPWR sky130_fd_sc_hd__tapvpwrvgnd_1
XFILLER_0_68_141 VGND VGND VPWR VPWR sky130_fd_sc_hd__fill_2
XTAP_1384 VGND VPWR sky130_fd_sc_hd__tapvpwrvgnd_1
XTAP_1373 VGND VPWR sky130_fd_sc_hd__tapvpwrvgnd_1
XTAP_1362 VGND VPWR sky130_fd_sc_hd__tapvpwrvgnd_1
XTAP_1351 VGND VPWR sky130_fd_sc_hd__tapvpwrvgnd_1
XFILLER_0_84_645 VGND VGND VPWR VPWR sky130_fd_sc_hd__decap_3
XTAP_1395 VGND VPWR sky130_fd_sc_hd__tapvpwrvgnd_1
XFILLER_0_83_155 VGND VGND VPWR VPWR sky130_fd_sc_hd__decap_4
XFILLER_0_37_561 VGND VGND VPWR VPWR sky130_fd_sc_hd__fill_1
Xinput13 rst_n VGND VGND VPWR VPWR net13 sky130_fd_sc_hd__buf_12
XFILLER_0_114_419 VGND VGND VPWR VPWR sky130_fd_sc_hd__fill_1
Xinput24 v_in1[3] VGND VGND VPWR VPWR net24 sky130_fd_sc_hd__clkbuf_2
XFILLER_0_3_105 VGND VGND VPWR VPWR sky130_fd_sc_hd__decap_6
Xhold808 u_pe_array.act_from_left\[15\]\[3\] VGND VGND VPWR VPWR net882 sky130_fd_sc_hd__dlygate4sd3_1
XFILLER_0_12_417 VGND VGND VPWR VPWR sky130_fd_sc_hd__decap_3
XFILLER_0_3_149 VPWR VGND VPWR VGND sky130_ef_sc_hd__decap_12
Xhold819 u_pe_array.g_pe_row\[0\].g_pe_col\[2\].u_pe.psum_out\[8\] VGND VGND VPWR
+ VPWR net893 sky130_fd_sc_hd__dlygate4sd3_1
XFILLER_0_52_586 VGND VGND VPWR VPWR sky130_fd_sc_hd__fill_2
XFILLER_0_58_23 VGND VGND VPWR VPWR sky130_fd_sc_hd__decap_4
XFILLER_0_20_461 VPWR VGND VPWR VGND sky130_ef_sc_hd__decap_12
XFILLER_0_110_669 VPWR VGND VPWR VGND sky130_ef_sc_hd__decap_12
X_5130_ net768 _1904_ _2071_ _1726_ VGND VGND VPWR VPWR _0361_ sky130_fd_sc_hd__a22o_1
X_5061_ u_pe_array.g_pe_row\[2\].g_pe_col\[0\].u_pe.act_val\[5\] _1882_ _1873_ net383
+ VGND VGND VPWR VPWR _0348_ sky130_fd_sc_hd__a22o_1
XFILLER_0_74_11 VGND VGND VPWR VPWR sky130_fd_sc_hd__fill_1
X_4012_ _1212_ _1213_ VGND VGND VPWR VPWR _1214_ sky130_fd_sc_hd__or2_1
XFILLER_0_74_55 VPWR VGND VPWR VGND sky130_ef_sc_hd__decap_12
X_5963_ u_pe_array.u_fifo1.buffer\[8\]\[5\] _2676_ _2723_ _2727_ _0857_ VGND VGND
+ VPWR VPWR _2728_ sky130_fd_sc_hd__a221o_1
X_4914_ u_pe_array.g_pe_row\[2\].g_pe_col\[1\].u_pe.psum_out\[2\] _1899_ VGND VGND
+ VPWR VPWR _1900_ sky130_fd_sc_hd__xnor2_1
X_7702_ clknet_leaf_74_clk _0608_ net72 VGND VGND VPWR VPWR u_pe_array.act_from_up\[6\]\[6\]
+ sky130_fd_sc_hd__dfrtp_1
XFILLER_0_75_634 VGND VGND VPWR VPWR sky130_fd_sc_hd__fill_1
XFILLER_0_74_111 VPWR VGND VPWR VGND sky130_ef_sc_hd__decap_12
X_5894_ _2642_ net884 _1158_ VGND VGND VPWR VPWR _2673_ sky130_fd_sc_hd__mux2_1
XFILLER_0_114_83 VGND VGND VPWR VPWR sky130_fd_sc_hd__fill_1
XFILLER_0_74_166 VPWR VGND VPWR VGND sky130_ef_sc_hd__decap_12
X_7633_ clknet_leaf_62_clk net298 net946 VGND VGND VPWR VPWR u_pe_array.g_pe_row\[1\].g_pe_col\[0\].u_pe.move_reg\[6\]
+ sky130_fd_sc_hd__dfrtp_1
XFILLER_0_16_701 VGND VGND VPWR VPWR sky130_fd_sc_hd__decap_4
X_4845_ u_pe_array.g_pe_row\[2\].g_pe_col\[2\].u_pe.psum_out\[12\] _1854_ VGND VGND
+ VPWR VPWR _1862_ sky130_fd_sc_hd__xnor2_1
X_7564_ clknet_leaf_47_clk _0470_ net73 VGND VGND VPWR VPWR u_pe_array.act_from_down\[1\]\[4\]
+ sky130_fd_sc_hd__dfrtp_1
XFILLER_0_90_626 VGND VGND VPWR VPWR sky130_fd_sc_hd__fill_2
X_4776_ _1797_ _1799_ VGND VGND VPWR VPWR _1800_ sky130_fd_sc_hd__xor2_1
XFILLER_0_117_279 VGND VGND VPWR VPWR sky130_fd_sc_hd__fill_1
X_6515_ _3144_ _3145_ VGND VGND VPWR VPWR _3146_ sky130_fd_sc_hd__or2b_1
X_3727_ _0978_ _0979_ _0981_ _0986_ net513 VGND VGND VPWR VPWR _0043_ sky130_fd_sc_hd__a32o_1
XFILLER_0_15_244 VGND VGND VPWR VPWR sky130_fd_sc_hd__decap_4
X_7495_ clknet_leaf_40_clk _0401_ net947 VGND VGND VPWR VPWR u_pe_array.g_pe_row\[1\].g_pe_col\[3\].u_pe.psum_out\[4\]
+ sky130_fd_sc_hd__dfrtp_1
XFILLER_0_70_350 VGND VGND VPWR VPWR sky130_fd_sc_hd__decap_4
X_6446_ net279 _3101_ _2987_ _3104_ VGND VGND VPWR VPWR _0644_ sky130_fd_sc_hd__a22o_1
XFILLER_0_101_614 VGND VGND VPWR VPWR sky130_fd_sc_hd__fill_2
X_3658_ _0943_ VGND VGND VPWR VPWR _0944_ sky130_fd_sc_hd__clkbuf_8
X_3589_ net693 _0863_ VGND VGND VPWR VPWR _0892_ sky130_fd_sc_hd__nand2_1
X_6377_ u_pe_array.g_pe_row\[0\].g_pe_col\[2\].u_pe.psum_out\[5\] _2130_ VGND VGND
+ VPWR VPWR _3046_ sky130_fd_sc_hd__nand2_1
X_5328_ u_pe_array.g_pe_row\[1\].g_pe_col\[3\].u_pe.psum_out\[7\] _1426_ VGND VGND
+ VPWR VPWR _2227_ sky130_fd_sc_hd__or2_1
X_5259_ _1426_ VGND VGND VPWR VPWR _2164_ sky130_fd_sc_hd__clkinv_4
XFILLER_0_108_213 VPWR VGND VPWR VGND sky130_ef_sc_hd__decap_12
XFILLER_0_19_561 VGND VGND VPWR VPWR sky130_fd_sc_hd__decap_6
XFILLER_0_81_626 VGND VGND VPWR VPWR sky130_fd_sc_hd__fill_2
XFILLER_0_81_659 VGND VGND VPWR VPWR sky130_fd_sc_hd__decap_8
XFILLER_0_34_531 VGND VGND VPWR VPWR sky130_fd_sc_hd__fill_1
XFILLER_0_104_474 VGND VGND VPWR VPWR sky130_fd_sc_hd__fill_2
XFILLER_0_1_609 VGND VGND VPWR VPWR sky130_fd_sc_hd__decap_6
XTAP_409 VGND VPWR sky130_fd_sc_hd__tapvpwrvgnd_1
XFILLER_0_28_26 VGND VGND VPWR VPWR sky130_fd_sc_hd__fill_2
XFILLER_0_28_37 VGND VGND VPWR VPWR sky130_fd_sc_hd__fill_2
XFILLER_0_44_25 VGND VGND VPWR VPWR sky130_fd_sc_hd__decap_3
XFILLER_0_96_280 VPWR VGND VPWR VGND sky130_ef_sc_hd__decap_12
XFILLER_0_84_431 VPWR VGND VPWR VGND sky130_ef_sc_hd__decap_12
XTAP_1192 VGND VPWR sky130_fd_sc_hd__tapvpwrvgnd_1
XTAP_1181 VGND VPWR sky130_fd_sc_hd__tapvpwrvgnd_1
XTAP_1170 VGND VPWR sky130_fd_sc_hd__tapvpwrvgnd_1
XFILLER_0_60_24 VGND VGND VPWR VPWR sky130_fd_sc_hd__decap_4
XFILLER_0_29_358 VGND VGND VPWR VPWR sky130_fd_sc_hd__fill_2
XFILLER_0_72_626 VPWR VGND VPWR VGND sky130_ef_sc_hd__decap_12
X_4630_ _1654_ _1665_ _1666_ VGND VGND VPWR VPWR _1692_ sky130_fd_sc_hd__o21bai_1
XFILLER_0_44_317 VGND VGND VPWR VPWR sky130_fd_sc_hd__decap_8
XFILLER_0_114_3 VPWR VGND VPWR VGND sky130_ef_sc_hd__decap_12
XFILLER_0_37_380 VGND VGND VPWR VPWR sky130_fd_sc_hd__decap_3
XFILLER_0_37_391 VGND VGND VPWR VPWR sky130_fd_sc_hd__fill_1
XFILLER_0_71_169 VGND VGND VPWR VPWR sky130_fd_sc_hd__fill_2
X_6300_ u_pe_array.g_pe_row\[0\].g_pe_col\[2\].u_pe.act_val\[1\] _2853_ _2847_ net326
+ VGND VGND VPWR VPWR _0616_ sky130_fd_sc_hd__a22o_1
XFILLER_0_12_203 VPWR VGND VPWR VGND sky130_ef_sc_hd__decap_12
XFILLER_0_25_575 VGND VGND VPWR VPWR sky130_fd_sc_hd__decap_6
X_4561_ _1626_ _1628_ VGND VGND VPWR VPWR _1629_ sky130_fd_sc_hd__xnor2_1
Xhold627 u_pe_array.g_pe_row\[0\].g_pe_col\[0\].u_pe.psum_out\[7\] VGND VGND VPWR
+ VPWR net701 sky130_fd_sc_hd__dlygate4sd3_1
Xhold616 u_pe_array.g_pe_row\[2\].g_pe_col\[1\].u_pe.psum_out\[1\] VGND VGND VPWR
+ VPWR net690 sky130_fd_sc_hd__dlygate4sd3_1
Xhold605 u_pe_array.g_pe_row\[3\].g_pe_col\[3\].u_pe.psum_out\[12\] VGND VGND VPWR
+ VPWR net679 sky130_fd_sc_hd__dlygate4sd3_1
X_7280_ clknet_leaf_13_clk net213 net942 VGND VGND VPWR VPWR u_pe_array.g_pe_row\[3\].g_pe_col\[0\].u_pe.move_reg\[7\]
+ sky130_fd_sc_hd__dfrtp_1
X_4492_ u_pe_array.g_pe_row\[3\].g_pe_col\[0\].u_pe.psum_out\[9\] u_pe_array.g_pe_row\[3\].g_pe_col\[0\].u_pe.psum_out\[10\]
+ _1287_ VGND VGND VPWR VPWR _1591_ sky130_fd_sc_hd__o21a_1
XFILLER_0_52_394 VPWR VGND VPWR VGND sky130_ef_sc_hd__decap_12
Xhold649 u_pe_array.g_pe_row\[1\].g_pe_col\[1\].u_pe.act_val\[0\] VGND VGND VPWR VPWR
+ net723 sky130_fd_sc_hd__dlygate4sd3_1
XFILLER_0_100_41 VPWR VGND VPWR VGND sky130_ef_sc_hd__decap_12
X_6231_ u_pe_array.g_pe_row\[0\].g_pe_col\[3\].u_pe.psum_out\[8\] _1999_ VGND VGND
+ VPWR VPWR _2939_ sky130_fd_sc_hd__nand2_1
Xhold638 u_pe_array.u_fifo2.buffer\[7\]\[2\] VGND VGND VPWR VPWR net712 sky130_fd_sc_hd__dlygate4sd3_1
XFILLER_0_100_85 VPWR VGND VPWR VGND sky130_ef_sc_hd__decap_12
X_6162_ _2871_ _2875_ VGND VGND VPWR VPWR _2876_ sky130_fd_sc_hd__xor2_1
XTAP_910 VGND VPWR sky130_fd_sc_hd__tapvpwrvgnd_1
XFILLER_0_110_477 VGND VGND VPWR VPWR sky130_fd_sc_hd__decap_3
X_5113_ _2054_ _2055_ VGND VGND VPWR VPWR _2056_ sky130_fd_sc_hd__and2_1
XTAP_943 VGND VPWR sky130_fd_sc_hd__tapvpwrvgnd_1
XTAP_932 VGND VPWR sky130_fd_sc_hd__tapvpwrvgnd_1
XTAP_921 VGND VPWR sky130_fd_sc_hd__tapvpwrvgnd_1
XTAP_987 VGND VPWR sky130_fd_sc_hd__tapvpwrvgnd_1
XTAP_976 VGND VPWR sky130_fd_sc_hd__tapvpwrvgnd_1
X_6093_ u_pe_array.g_pe_row\[1\].g_pe_col\[0\].u_pe.psum_out\[9\] u_pe_array.g_pe_row\[1\].g_pe_col\[0\].u_pe.psum_out\[10\]
+ _1865_ VGND VGND VPWR VPWR _2838_ sky130_fd_sc_hd__o21a_1
XTAP_965 VGND VPWR sky130_fd_sc_hd__tapvpwrvgnd_1
XTAP_954 VGND VPWR sky130_fd_sc_hd__tapvpwrvgnd_1
X_5044_ u_pe_array.g_pe_row\[2\].g_pe_col\[0\].u_pe.psum_out\[7\] net480 _1867_ VGND
+ VGND VPWR VPWR _2010_ sky130_fd_sc_hd__mux2_1
XTAP_998 VGND VPWR sky130_fd_sc_hd__tapvpwrvgnd_1
XFILLER_0_18_92 VGND VGND VPWR VPWR sky130_fd_sc_hd__decap_6
XFILLER_0_19_3 VPWR VGND VPWR VGND sky130_ef_sc_hd__decap_12
X_6995_ net535 _3362_ _3484_ VGND VGND VPWR VPWR _3490_ sky130_fd_sc_hd__mux2_1
XFILLER_0_75_431 VGND VGND VPWR VPWR sky130_fd_sc_hd__fill_2
X_5946_ u_pe_array.u_fifo1.buffer\[4\]\[3\] _2680_ _2710_ _2712_ VGND VGND VPWR VPWR
+ _2713_ sky130_fd_sc_hd__a211o_1
XFILLER_0_48_623 VGND VGND VPWR VPWR sky130_fd_sc_hd__fill_1
XFILLER_0_118_533 VGND VGND VPWR VPWR sky130_fd_sc_hd__fill_2
XFILLER_0_118_500 VGND VGND VPWR VPWR sky130_fd_sc_hd__decap_4
X_5877_ _2662_ VGND VGND VPWR VPWR _0517_ sky130_fd_sc_hd__clkbuf_1
XFILLER_0_48_678 VPWR VGND VPWR VGND sky130_ef_sc_hd__decap_12
X_7616_ clknet_leaf_38_clk _0522_ net951 VGND VGND VPWR VPWR u_pe_array.act_from_left\[5\]\[2\]
+ sky130_fd_sc_hd__dfrtp_1
XFILLER_0_63_648 VGND VGND VPWR VPWR sky130_fd_sc_hd__decap_4
X_4828_ u_pe_array.g_pe_row\[2\].g_pe_col\[2\].u_pe.psum_out\[10\] _0933_ VGND VGND
+ VPWR VPWR _1847_ sky130_fd_sc_hd__nand2_1
XFILLER_0_90_445 VGND VGND VPWR VPWR sky130_fd_sc_hd__decap_8
XFILLER_0_62_147 VGND VGND VPWR VPWR sky130_fd_sc_hd__fill_1
XFILLER_0_47_199 VGND VGND VPWR VPWR sky130_fd_sc_hd__fill_2
X_4759_ u_pe_array.g_pe_row\[2\].g_pe_col\[2\].u_pe.act_val\[3\] _0933_ VGND VGND
+ VPWR VPWR _1784_ sky130_fd_sc_hd__and2b_1
X_7547_ clknet_leaf_92_clk _0453_ net949 VGND VGND VPWR VPWR u_pe_array.g_pe_row\[1\].g_pe_col\[2\].u_pe.psum_out\[2\]
+ sky130_fd_sc_hd__dfrtp_1
X_7478_ clknet_leaf_39_clk _0384_ net947 VGND VGND VPWR VPWR u_pe_array.g_pe_row\[1\].g_pe_col\[3\].u_pe.act_val\[0\]
+ sky130_fd_sc_hd__dfrtp_1
XFILLER_0_101_422 VGND VGND VPWR VPWR sky130_fd_sc_hd__fill_1
XFILLER_0_31_578 VGND VGND VPWR VPWR sky130_fd_sc_hd__decap_3
X_6429_ u_pe_array.g_pe_row\[0\].g_pe_col\[2\].u_pe.psum_out\[11\] _3092_ _3083_ VGND
+ VGND VPWR VPWR _3093_ sky130_fd_sc_hd__mux2_1
XFILLER_0_98_501 VGND VGND VPWR VPWR sky130_fd_sc_hd__decap_8
XFILLER_0_105_19 VPWR VGND VPWR VGND sky130_ef_sc_hd__decap_12
XFILLER_0_98_589 VGND VGND VPWR VPWR sky130_fd_sc_hd__decap_3
XFILLER_0_39_623 VGND VGND VPWR VPWR sky130_fd_sc_hd__decap_3
XPHY_231 VGND VGND VPWR VPWR sky130_fd_sc_hd__decap_3
XPHY_220 VGND VGND VPWR VPWR sky130_fd_sc_hd__decap_3
XFILLER_0_81_423 VGND VGND VPWR VPWR sky130_fd_sc_hd__fill_1
XFILLER_0_54_637 VGND VGND VPWR VPWR sky130_fd_sc_hd__decap_6
XFILLER_0_30_27 VGND VGND VPWR VPWR sky130_fd_sc_hd__fill_1
XFILLER_0_53_147 VGND VGND VPWR VPWR sky130_fd_sc_hd__fill_1
XFILLER_0_81_478 VGND VGND VPWR VPWR sky130_fd_sc_hd__decap_6
XFILLER_0_53_169 VGND VGND VPWR VPWR sky130_fd_sc_hd__fill_1
XFILLER_0_1_417 VPWR VGND VPWR VGND sky130_ef_sc_hd__decap_12
XFILLER_0_22_589 VGND VGND VPWR VPWR sky130_fd_sc_hd__decap_8
XTAP_239 VGND VPWR sky130_fd_sc_hd__tapvpwrvgnd_1
Xhold2 _0309_ VGND VGND VPWR VPWR net76 sky130_fd_sc_hd__dlygate4sd3_1
XFILLER_0_55_57 VGND VGND VPWR VPWR sky130_fd_sc_hd__fill_1
X_5800_ u_pe_array.g_pe_row\[1\].g_pe_col\[1\].u_pe.psum_out\[8\] u_pe_array.g_pe_row\[1\].g_pe_col\[1\].u_pe.psum_out\[9\]
+ _1728_ VGND VGND VPWR VPWR _2602_ sky130_fd_sc_hd__and3_1
X_3992_ _1122_ _0934_ u_pe_array.g_pe_row\[3\].g_pe_col\[2\].u_pe.psum_out\[3\] VGND
+ VGND VPWR VPWR _1195_ sky130_fd_sc_hd__a21oi_1
X_6780_ _3357_ VGND VGND VPWR VPWR _0725_ sky130_fd_sc_hd__clkbuf_1
X_5731_ u_pe_array.g_pe_row\[1\].g_pe_col\[1\].u_pe.psum_out\[2\] _2526_ _2538_ VGND
+ VGND VPWR VPWR _2539_ sky130_fd_sc_hd__a21oi_1
XFILLER_0_69_291 VPWR VGND VPWR VGND sky130_ef_sc_hd__decap_12
XFILLER_0_44_103 VPWR VGND VPWR VGND sky130_ef_sc_hd__decap_12
XFILLER_0_45_615 VGND VGND VPWR VPWR sky130_fd_sc_hd__fill_1
X_5662_ u_pe_array.g_pe_row\[1\].g_pe_col\[1\].u_pe.psum_out\[4\] u_pe_array.g_pe_row\[1\].g_pe_col\[1\].u_pe.act_val\[4\]
+ _2133_ VGND VGND VPWR VPWR _2495_ sky130_fd_sc_hd__mux2_1
XFILLER_0_45_648 VGND VGND VPWR VPWR sky130_fd_sc_hd__decap_8
X_7401_ clknet_leaf_28_clk net92 net942 VGND VGND VPWR VPWR u_pe_array.g_pe_row\[2\].g_pe_col\[1\].u_pe.act_val\[5\]
+ sky130_fd_sc_hd__dfrtp_2
X_4613_ _1675_ _1676_ VGND VGND VPWR VPWR _1677_ sky130_fd_sc_hd__or2b_1
X_5593_ _2438_ _2429_ _2427_ VGND VGND VPWR VPWR _2439_ sky130_fd_sc_hd__a21oi_1
XFILLER_0_111_51 VGND VGND VPWR VPWR sky130_fd_sc_hd__decap_4
Xhold402 u_pe_array.g_pe_row\[3\].g_pe_col\[1\].u_pe.psum_out\[1\] VGND VGND VPWR
+ VPWR net476 sky130_fd_sc_hd__dlygate4sd3_1
X_4544_ net310 _1310_ _1483_ u_pe_array.g_pe_row\[2\].g_pe_col\[3\].u_pe.move_reg\[12\]
+ VGND VGND VPWR VPWR _0232_ sky130_fd_sc_hd__a22o_1
XFILLER_0_4_244 VGND VGND VPWR VPWR sky130_fd_sc_hd__decap_8
X_7332_ clknet_leaf_2_clk _0238_ net944 VGND VGND VPWR VPWR u_pe_array.g_pe_row\[2\].g_pe_col\[3\].u_pe.psum_out\[5\]
+ sky130_fd_sc_hd__dfrtp_1
Xhold435 u_pe_array.g_pe_row\[1\].g_pe_col\[3\].u_pe.move_reg\[11\] VGND VGND VPWR
+ VPWR net509 sky130_fd_sc_hd__dlygate4sd3_1
Xhold413 u_pe_array.g_pe_row\[3\].g_pe_col\[3\].u_pe.move_reg\[7\] VGND VGND VPWR
+ VPWR net487 sky130_fd_sc_hd__dlygate4sd3_1
Xhold424 u_pe_array.act_from_down\[9\]\[12\] VGND VGND VPWR VPWR net498 sky130_fd_sc_hd__dlygate4sd3_1
X_7263_ clknet_leaf_5_clk _0169_ net945 VGND VGND VPWR VPWR u_pe_array.act_from_left\[13\]\[3\]
+ sky130_fd_sc_hd__dfrtp_1
XFILLER_0_20_71 VPWR VGND VPWR VGND sky130_ef_sc_hd__decap_12
X_6214_ _2918_ _2923_ VGND VGND VPWR VPWR _2924_ sky130_fd_sc_hd__or2_1
Xhold457 _0378_ VGND VGND VPWR VPWR net531 sky130_fd_sc_hd__dlygate4sd3_1
Xhold446 _0377_ VGND VGND VPWR VPWR net520 sky130_fd_sc_hd__dlygate4sd3_1
XFILLER_0_40_397 VGND VGND VPWR VPWR sky130_fd_sc_hd__decap_4
Xhold468 u_pe_array.g_pe_row\[0\].g_pe_col\[2\].u_pe.psum_out\[0\] VGND VGND VPWR
+ VPWR net542 sky130_fd_sc_hd__dlygate4sd3_1
X_4475_ u_pe_array.g_pe_row\[3\].g_pe_col\[0\].u_pe.psum_out\[7\] u_pe_array.g_pe_row\[3\].g_pe_col\[0\].u_pe.psum_out\[8\]
+ _1287_ VGND VGND VPWR VPWR _1576_ sky130_fd_sc_hd__o21a_1
Xhold479 u_pe_array.u_fifo2.buffer\[0\]\[2\] VGND VGND VPWR VPWR net553 sky130_fd_sc_hd__dlygate4sd3_1
XFILLER_0_0_461 VPWR VGND VPWR VGND sky130_ef_sc_hd__decap_12
X_7194_ clknet_leaf_103_clk _0100_ net950 VGND VGND VPWR VPWR u_pe_array.g_pe_row\[3\].g_pe_col\[2\].u_pe.psum_out\[3\]
+ sky130_fd_sc_hd__dfrtp_1
X_6145_ u_pe_array.g_pe_row\[0\].g_pe_col\[3\].u_pe.psum_out\[0\] u_pe_array.g_pe_row\[0\].g_pe_col\[3\].u_pe.act_val\[0\]
+ u_pe_array.g_pe_row\[0\].g_pe_col\[3\].u_pe.w_out\[0\] VGND VGND VPWR VPWR _2861_
+ sky130_fd_sc_hd__and3_1
XTAP_751 VGND VPWR sky130_fd_sc_hd__tapvpwrvgnd_1
XTAP_740 VGND VPWR sky130_fd_sc_hd__tapvpwrvgnd_1
X_6076_ u_pe_array.g_pe_row\[1\].g_pe_col\[0\].u_pe.psum_out\[7\] u_pe_array.g_pe_row\[1\].g_pe_col\[0\].u_pe.psum_out\[8\]
+ _1865_ VGND VGND VPWR VPWR _2823_ sky130_fd_sc_hd__o21a_1
XTAP_762 VGND VPWR sky130_fd_sc_hd__tapvpwrvgnd_1
XTAP_773 VGND VPWR sky130_fd_sc_hd__tapvpwrvgnd_1
XTAP_784 VGND VPWR sky130_fd_sc_hd__tapvpwrvgnd_1
XTAP_795 VGND VPWR sky130_fd_sc_hd__tapvpwrvgnd_1
X_5027_ _2000_ VGND VGND VPWR VPWR _0329_ sky130_fd_sc_hd__clkbuf_1
XFILLER_0_95_559 VGND VGND VPWR VPWR sky130_fd_sc_hd__fill_1
X_6978_ _3475_ _3478_ _3479_ _3471_ net880 VGND VGND VPWR VPWR _0801_ sky130_fd_sc_hd__a32o_1
XFILLER_0_75_261 VGND VGND VPWR VPWR sky130_fd_sc_hd__decap_3
X_5929_ u_pe_array.u_fifo1.buffer\[3\]\[1\] _2685_ _2686_ u_pe_array.u_fifo1.buffer\[2\]\[1\]
+ _2697_ VGND VGND VPWR VPWR _2698_ sky130_fd_sc_hd__a221o_1
XFILLER_0_48_475 VGND VGND VPWR VPWR sky130_fd_sc_hd__fill_1
XFILLER_0_118_352 VGND VGND VPWR VPWR sky130_fd_sc_hd__fill_2
XFILLER_0_90_242 VGND VGND VPWR VPWR sky130_fd_sc_hd__fill_2
XFILLER_0_90_275 VGND VGND VPWR VPWR sky130_fd_sc_hd__decap_4
XFILLER_0_90_253 VGND VGND VPWR VPWR sky130_fd_sc_hd__decap_6
XFILLER_0_35_169 VGND VGND VPWR VPWR sky130_fd_sc_hd__decap_3
XFILLER_0_44_681 VPWR VGND VPWR VGND sky130_ef_sc_hd__decap_12
XFILLER_0_31_386 VGND VGND VPWR VPWR sky130_fd_sc_hd__decap_6
XFILLER_0_8_3 VPWR VGND VPWR VGND sky130_ef_sc_hd__decap_12
XFILLER_0_116_29 VPWR VGND VPWR VGND sky130_ef_sc_hd__decap_12
XFILLER_0_86_515 VGND VGND VPWR VPWR sky130_fd_sc_hd__decap_4
XFILLER_0_109_341 VGND VGND VPWR VPWR sky130_fd_sc_hd__fill_1
XFILLER_0_41_48 VGND VGND VPWR VPWR sky130_fd_sc_hd__decap_8
XFILLER_0_42_618 VPWR VGND VPWR VGND sky130_ef_sc_hd__decap_12
XFILLER_0_112_517 VGND VGND VPWR VPWR sky130_fd_sc_hd__decap_4
XFILLER_0_1_225 VPWR VGND VPWR VGND sky130_ef_sc_hd__decap_12
XFILLER_0_22_353 VGND VGND VPWR VPWR sky130_fd_sc_hd__decap_8
XFILLER_0_34_191 VGND VGND VPWR VPWR sky130_fd_sc_hd__decap_4
X_4260_ u_pe_array.g_pe_row\[3\].g_pe_col\[1\].u_pe.psum_out\[11\] _1106_ VGND VGND
+ VPWR VPWR _1414_ sky130_fd_sc_hd__and2b_1
XFILLER_0_5_15 VPWR VGND VPWR VGND sky130_ef_sc_hd__decap_12
XFILLER_0_22_397 VGND VGND VPWR VPWR sky130_fd_sc_hd__fill_2
X_4191_ _1350_ _1351_ VGND VGND VPWR VPWR _1352_ sky130_fd_sc_hd__or2_1
XFILLER_0_66_23 VGND VGND VPWR VPWR sky130_fd_sc_hd__decap_4
X_6901_ _3432_ VGND VGND VPWR VPWR _0771_ sky130_fd_sc_hd__clkbuf_1
X_7881_ clknet_leaf_98_clk _0786_ VGND VGND VPWR VPWR u_pe_array.u_fifo2.buffer\[7\]\[3\]
+ sky130_fd_sc_hd__dfxtp_1
X_6832_ _3393_ VGND VGND VPWR VPWR _0741_ sky130_fd_sc_hd__clkbuf_1
X_6763_ _3330_ _3334_ _3341_ _3343_ _3340_ VGND VGND VPWR VPWR _3344_ sky130_fd_sc_hd__a32o_1
XFILLER_0_57_272 VGND VGND VPWR VPWR sky130_fd_sc_hd__fill_1
XFILLER_0_9_358 VGND VGND VPWR VPWR sky130_fd_sc_hd__fill_1
X_3975_ _1178_ _1179_ _1177_ VGND VGND VPWR VPWR _1180_ sky130_fd_sc_hd__o21ai_1
X_5714_ u_pe_array.g_pe_row\[1\].g_pe_col\[1\].u_pe.act_val\[0\] _2515_ _1728_ VGND
+ VGND VPWR VPWR _2523_ sky130_fd_sc_hd__a21bo_1
X_6694_ _3275_ _3282_ VGND VGND VPWR VPWR _3283_ sky130_fd_sc_hd__nand2_1
XFILLER_0_72_253 VGND VGND VPWR VPWR sky130_fd_sc_hd__decap_6
X_5645_ _2483_ _2484_ VGND VGND VPWR VPWR _2485_ sky130_fd_sc_hd__xnor2_1
XFILLER_0_86_3 VPWR VGND VPWR VGND sky130_ef_sc_hd__decap_12
Xhold210 _0661_ VGND VGND VPWR VPWR net284 sky130_fd_sc_hd__dlygate4sd3_1
X_5576_ u_pe_array.g_pe_row\[1\].g_pe_col\[2\].u_pe.act_val\[4\] _1597_ VGND VGND
+ VPWR VPWR _2423_ sky130_fd_sc_hd__and2b_1
Xhold232 u_pe_array.g_pe_row\[2\].g_pe_col\[1\].u_pe.move_reg\[8\] VGND VGND VPWR
+ VPWR net306 sky130_fd_sc_hd__dlygate4sd3_1
Xhold221 u_pe_array.g_pe_row\[2\].g_pe_col\[1\].u_pe.move_reg\[9\] VGND VGND VPWR
+ VPWR net295 sky130_fd_sc_hd__dlygate4sd3_1
Xhold243 _0488_ VGND VGND VPWR VPWR net317 sky130_fd_sc_hd__dlygate4sd3_1
XFILLER_0_41_673 VPWR VGND VPWR VGND sky130_ef_sc_hd__decap_12
X_4527_ net392 _1605_ _1611_ _1612_ VGND VGND VPWR VPWR _0217_ sky130_fd_sc_hd__a22o_1
X_7315_ clknet_leaf_3_clk net126 net944 VGND VGND VPWR VPWR u_pe_array.g_pe_row\[2\].g_pe_col\[3\].u_pe.act_val\[1\]
+ sky130_fd_sc_hd__dfrtp_4
Xhold254 u_pe_array.g_pe_row\[2\].g_pe_col\[0\].u_pe.move_reg\[8\] VGND VGND VPWR
+ VPWR net328 sky130_fd_sc_hd__dlygate4sd3_1
X_7246_ clknet_leaf_16_clk _0152_ net943 VGND VGND VPWR VPWR u_pe_array.g_pe_row\[2\].g_pe_col\[3\].u_pe.w_out\[1\]
+ sky130_fd_sc_hd__dfrtp_1
Xhold287 _0025_ VGND VGND VPWR VPWR net361 sky130_fd_sc_hd__dlygate4sd3_1
Xhold276 _0023_ VGND VGND VPWR VPWR net350 sky130_fd_sc_hd__dlygate4sd3_1
X_4458_ _1560_ _1536_ _1549_ _1553_ VGND VGND VPWR VPWR _1561_ sky130_fd_sc_hd__a22o_1
Xhold265 u_pe_array.g_pe_row\[2\].g_pe_col\[3\].u_pe.psum_out\[4\] VGND VGND VPWR
+ VPWR net339 sky130_fd_sc_hd__dlygate4sd3_1
X_7177_ clknet_leaf_9_clk _0083_ net945 VGND VGND VPWR VPWR u_pe_array.act_from_left\[15\]\[12\]
+ sky130_fd_sc_hd__dfrtp_1
Xhold298 _0213_ VGND VGND VPWR VPWR net372 sky130_fd_sc_hd__dlygate4sd3_1
X_6128_ net459 _2853_ _2847_ _2858_ VGND VGND VPWR VPWR _0572_ sky130_fd_sc_hd__a22o_1
X_4389_ u_pe_array.g_pe_row\[3\].g_pe_col\[0\].u_pe.act_val\[2\] u_pe_array.g_pe_row\[3\].g_pe_col\[0\].u_pe.w_out\[0\]
+ VGND VGND VPWR VPWR _1498_ sky130_fd_sc_hd__nand2_1
XTAP_570 VGND VPWR sky130_fd_sc_hd__tapvpwrvgnd_1
XTAP_592 VGND VPWR sky130_fd_sc_hd__tapvpwrvgnd_1
XTAP_581 VGND VPWR sky130_fd_sc_hd__tapvpwrvgnd_1
X_6059_ _2807_ _2782_ _2796_ _2800_ VGND VGND VPWR VPWR _2808_ sky130_fd_sc_hd__a22o_1
XTAP_1725 VGND VPWR sky130_fd_sc_hd__tapvpwrvgnd_1
XTAP_1714 VGND VPWR sky130_fd_sc_hd__tapvpwrvgnd_1
XTAP_1703 VGND VPWR sky130_fd_sc_hd__tapvpwrvgnd_1
XTAP_1747 VGND VPWR sky130_fd_sc_hd__tapvpwrvgnd_1
XTAP_1736 VGND VPWR sky130_fd_sc_hd__tapvpwrvgnd_1
XFILLER_0_36_401 VPWR VGND VPWR VGND sky130_ef_sc_hd__decap_12
XFILLER_0_48_294 VGND VGND VPWR VPWR sky130_fd_sc_hd__fill_1
XFILLER_0_118_193 VGND VGND VPWR VPWR sky130_fd_sc_hd__decap_3
XFILLER_0_23_139 VGND VGND VPWR VPWR sky130_fd_sc_hd__decap_3
XFILLER_0_31_194 VGND VGND VPWR VPWR sky130_fd_sc_hd__fill_1
XFILLER_0_36_26 VGND VGND VPWR VPWR sky130_fd_sc_hd__fill_2
XFILLER_0_99_673 VPWR VGND VPWR VGND sky130_ef_sc_hd__decap_12
XFILLER_0_59_537 VGND VGND VPWR VPWR sky130_fd_sc_hd__fill_1
XFILLER_0_59_559 VGND VGND VPWR VPWR sky130_fd_sc_hd__fill_1
X_3760_ _1014_ _1016_ VGND VGND VPWR VPWR _1017_ sky130_fd_sc_hd__nor2_1
XFILLER_0_109_160 VGND VGND VPWR VPWR sky130_fd_sc_hd__decap_4
XFILLER_0_54_253 VGND VGND VPWR VPWR sky130_fd_sc_hd__decap_3
XFILLER_0_27_456 VGND VGND VPWR VPWR sky130_fd_sc_hd__fill_1
X_5430_ net187 _2309_ _2273_ VGND VGND VPWR VPWR _2310_ sky130_fd_sc_hd__mux2_1
X_3691_ net7 u_pe_array.act_from_left\[15\]\[0\] _0963_ VGND VGND VPWR VPWR _0964_
+ sky130_fd_sc_hd__mux2_1
XFILLER_0_42_437 VGND VGND VPWR VPWR sky130_fd_sc_hd__decap_4
XFILLER_0_2_501 VPWR VGND VPWR VGND sky130_ef_sc_hd__decap_12
X_5361_ _2233_ _2255_ _2256_ _2173_ net762 VGND VGND VPWR VPWR _0407_ sky130_fd_sc_hd__a32o_1
XFILLER_0_2_545 VPWR VGND VPWR VGND sky130_ef_sc_hd__decap_12
XFILLER_0_23_673 VPWR VGND VPWR VGND sky130_ef_sc_hd__decap_12
X_4312_ _1454_ VGND VGND VPWR VPWR _0160_ sky130_fd_sc_hd__clkbuf_1
XFILLER_0_100_509 VGND VGND VPWR VPWR sky130_fd_sc_hd__decap_6
X_5292_ _2183_ _2182_ _2193_ _2188_ VGND VGND VPWR VPWR _2194_ sky130_fd_sc_hd__a31o_1
XFILLER_0_2_589 VPWR VGND VPWR VGND sky130_ef_sc_hd__decap_12
X_7100_ clknet_leaf_83_clk net573 net948 VGND VGND VPWR VPWR u_fsm.v_cnt\[0\] sky130_fd_sc_hd__dfrtp_1
X_4243_ u_pe_array.g_pe_row\[3\].g_pe_col\[1\].u_pe.psum_out\[9\] _1106_ VGND VGND
+ VPWR VPWR _1399_ sky130_fd_sc_hd__nand2_1
XFILLER_0_77_66 VGND VGND VPWR VPWR sky130_fd_sc_hd__decap_4
X_7031_ net659 _3358_ _3506_ VGND VGND VPWR VPWR _3510_ sky130_fd_sc_hd__mux2_1
X_4174_ _1328_ _1329_ _1335_ VGND VGND VPWR VPWR _1336_ sky130_fd_sc_hd__nor3_1
X_7933_ clknet_leaf_78_clk _0838_ VGND VGND VPWR VPWR u_pe_array.u_fifo1.buffer\[5\]\[5\]
+ sky130_fd_sc_hd__dfxtp_1
X_7864_ clknet_leaf_99_clk _0769_ VGND VGND VPWR VPWR u_pe_array.u_fifo2.buffer\[4\]\[4\]
+ sky130_fd_sc_hd__dfxtp_1
X_7795_ clknet_leaf_53_clk net320 net74 VGND VGND VPWR VPWR u_pe_array.g_pe_row\[0\].g_pe_col\[0\].u_pe.act_val\[3\]
+ sky130_fd_sc_hd__dfrtp_2
XFILLER_0_92_304 VGND VGND VPWR VPWR sky130_fd_sc_hd__decap_4
X_6815_ u_pe_array.u_fifo2.count\[2\] VGND VGND VPWR VPWR _3381_ sky130_fd_sc_hd__inv_2
XFILLER_0_9_111 VGND VGND VPWR VPWR sky130_fd_sc_hd__fill_1
X_6746_ u_pe_array.g_pe_row\[0\].g_pe_col\[0\].u_pe.psum_out\[7\] u_pe_array.g_pe_row\[0\].g_pe_col\[0\].u_pe.psum_out\[8\]
+ _2488_ _3324_ _3325_ VGND VGND VPWR VPWR _3329_ sky130_fd_sc_hd__o2111a_1
XFILLER_0_92_348 VGND VGND VPWR VPWR sky130_fd_sc_hd__fill_1
X_3958_ net25 net578 _0857_ VGND VGND VPWR VPWR _1173_ sky130_fd_sc_hd__mux2_1
XFILLER_0_18_467 VGND VGND VPWR VPWR sky130_fd_sc_hd__decap_8
X_6677_ u_pe_array.g_pe_row\[0\].g_pe_col\[0\].u_pe.act_val\[2\] _3246_ _3265_ _3266_
+ VGND VGND VPWR VPWR _3267_ sky130_fd_sc_hd__or4_1
XFILLER_0_18_489 VPWR VGND VPWR VGND sky130_ef_sc_hd__decap_12
X_3889_ u_pe_array.g_pe_row\[3\].g_pe_col\[2\].u_pe.act_val\[4\] _1118_ VGND VGND
+ VPWR VPWR _1130_ sky130_fd_sc_hd__or2_1
XFILLER_0_45_297 VGND VGND VPWR VPWR sky130_fd_sc_hd__fill_1
X_5628_ u_pe_array.g_pe_row\[1\].g_pe_col\[2\].u_pe.psum_out\[10\] _1597_ VGND VGND
+ VPWR VPWR _2470_ sky130_fd_sc_hd__nand2_1
XFILLER_0_13_150 VGND VGND VPWR VPWR sky130_fd_sc_hd__decap_3
X_5559_ _2406_ _2402_ _2404_ VGND VGND VPWR VPWR _2408_ sky130_fd_sc_hd__or3_1
XFILLER_0_103_369 VGND VGND VPWR VPWR sky130_fd_sc_hd__decap_3
XFILLER_0_111_380 VGND VGND VPWR VPWR sky130_fd_sc_hd__fill_2
XFILLER_0_111_391 VGND VGND VPWR VPWR sky130_fd_sc_hd__fill_1
X_7229_ clknet_leaf_13_clk net166 net942 VGND VGND VPWR VPWR u_pe_array.g_pe_row\[3\].g_pe_col\[1\].u_pe.move_reg\[10\]
+ sky130_fd_sc_hd__dfrtp_1
XTAP_1533 VGND VPWR sky130_fd_sc_hd__tapvpwrvgnd_1
XTAP_1522 VGND VPWR sky130_fd_sc_hd__tapvpwrvgnd_1
XTAP_1511 VGND VPWR sky130_fd_sc_hd__tapvpwrvgnd_1
XTAP_1500 VGND VPWR sky130_fd_sc_hd__tapvpwrvgnd_1
XFILLER_0_96_665 VGND VGND VPWR VPWR sky130_fd_sc_hd__decap_4
XFILLER_0_96_643 VGND VGND VPWR VPWR sky130_fd_sc_hd__fill_1
XPHY_40 VGND VGND VPWR VPWR sky130_fd_sc_hd__decap_3
XTAP_1566 VGND VPWR sky130_fd_sc_hd__tapvpwrvgnd_1
XTAP_1555 VGND VPWR sky130_fd_sc_hd__tapvpwrvgnd_1
XTAP_1544 VGND VPWR sky130_fd_sc_hd__tapvpwrvgnd_1
XPHY_51 VGND VGND VPWR VPWR sky130_fd_sc_hd__decap_3
XPHY_62 VGND VGND VPWR VPWR sky130_fd_sc_hd__decap_3
XPHY_73 VGND VGND VPWR VPWR sky130_fd_sc_hd__decap_3
XTAP_1599 VGND VPWR sky130_fd_sc_hd__tapvpwrvgnd_1
XTAP_1588 VGND VPWR sky130_fd_sc_hd__tapvpwrvgnd_1
XTAP_1577 VGND VPWR sky130_fd_sc_hd__tapvpwrvgnd_1
XPHY_84 VGND VGND VPWR VPWR sky130_fd_sc_hd__decap_3
XPHY_95 VGND VGND VPWR VPWR sky130_fd_sc_hd__decap_3
XFILLER_0_107_653 VPWR VGND VPWR VGND sky130_ef_sc_hd__decap_12
XFILLER_0_107_697 VGND VGND VPWR VPWR sky130_fd_sc_hd__decap_4
XFILLER_0_20_632 VGND VGND VPWR VPWR sky130_fd_sc_hd__decap_6
XFILLER_0_47_69 VGND VGND VPWR VPWR sky130_fd_sc_hd__decap_4
XFILLER_0_2_27 VGND VGND VPWR VPWR sky130_fd_sc_hd__fill_1
XFILLER_0_99_481 VGND VGND VPWR VPWR sky130_fd_sc_hd__decap_6
XFILLER_0_63_57 VGND VGND VPWR VPWR sky130_fd_sc_hd__decap_3
X_4930_ _1911_ _1913_ VGND VGND VPWR VPWR _1915_ sky130_fd_sc_hd__nand2_1
XFILLER_0_87_654 VPWR VGND VPWR VGND sky130_ef_sc_hd__decap_12
X_4861_ net484 _1749_ _1611_ _1871_ VGND VGND VPWR VPWR _0292_ sky130_fd_sc_hd__a22o_1
X_6600_ _3214_ _3216_ _3221_ VGND VGND VPWR VPWR _3223_ sky130_fd_sc_hd__or3_1
X_3812_ _1033_ _1063_ _1064_ _0986_ net935 VGND VGND VPWR VPWR _0050_ sky130_fd_sc_hd__a32o_1
XFILLER_0_7_615 VGND VGND VPWR VPWR sky130_fd_sc_hd__fill_1
X_7580_ clknet_leaf_67_clk net270 net946 VGND VGND VPWR VPWR u_pe_array.g_pe_row\[1\].g_pe_col\[1\].u_pe.move_reg\[7\]
+ sky130_fd_sc_hd__dfrtp_1
XANTENNA_16 _2664_ VGND VGND VPWR VPWR sky130_fd_sc_hd__diode_2
X_4792_ _1811_ _1812_ _1814_ VGND VGND VPWR VPWR _1815_ sky130_fd_sc_hd__a21oi_1
X_6531_ u_pe_array.g_pe_row\[0\].g_pe_col\[1\].u_pe.act_val\[5\] u_pe_array.g_pe_row\[0\].g_pe_col\[1\].u_pe.w_out\[0\]
+ VGND VGND VPWR VPWR _3160_ sky130_fd_sc_hd__nand2_1
X_3743_ _0996_ _1000_ VGND VGND VPWR VPWR _1001_ sky130_fd_sc_hd__xor2_1
XFILLER_0_55_573 VPWR VGND VPWR VGND sky130_ef_sc_hd__decap_12
XFILLER_0_27_275 VGND VGND VPWR VPWR sky130_fd_sc_hd__decap_4
X_6462_ net137 _3101_ _2987_ _3112_ VGND VGND VPWR VPWR _0652_ sky130_fd_sc_hd__a22o_1
X_3674_ net155 _0949_ _0944_ _0954_ VGND VGND VPWR VPWR _0022_ sky130_fd_sc_hd__a22o_1
XFILLER_0_112_133 VGND VGND VPWR VPWR sky130_fd_sc_hd__decap_6
XFILLER_0_88_43 VGND VGND VPWR VPWR sky130_fd_sc_hd__decap_3
X_5413_ u_pe_array.g_pe_row\[1\].g_pe_col\[2\].u_pe.psum_out\[7\] _1108_ _1110_ _2296_
+ VGND VGND VPWR VPWR _2297_ sky130_fd_sc_hd__o211a_1
X_6393_ _3054_ _3060_ VGND VGND VPWR VPWR _3061_ sky130_fd_sc_hd__nand2_1
X_5344_ _2236_ _2240_ VGND VGND VPWR VPWR _2242_ sky130_fd_sc_hd__nand2_1
XFILLER_0_11_610 VGND VGND VPWR VPWR sky130_fd_sc_hd__decap_6
XFILLER_0_11_665 VGND VGND VPWR VPWR sky130_fd_sc_hd__decap_6
XFILLER_0_2_386 VPWR VGND VPWR VGND sky130_ef_sc_hd__decap_12
X_5275_ _2174_ _2167_ net67 _2178_ VGND VGND VPWR VPWR _2179_ sky130_fd_sc_hd__a211oi_2
X_4226_ _1379_ _1383_ _1368_ VGND VGND VPWR VPWR _1384_ sky130_fd_sc_hd__mux2_1
XFILLER_0_10_197 VGND VGND VPWR VPWR sky130_fd_sc_hd__decap_6
X_7014_ net601 _3354_ _3499_ VGND VGND VPWR VPWR _3501_ sky130_fd_sc_hd__mux2_1
XFILLER_0_49_3 VPWR VGND VPWR VGND sky130_ef_sc_hd__decap_12
X_4157_ u_pe_array.g_pe_row\[3\].g_pe_col\[1\].u_pe.act_val\[1\] _1106_ VGND VGND
+ VPWR VPWR _1320_ sky130_fd_sc_hd__or2b_1
XFILLER_0_97_429 VGND VGND VPWR VPWR sky130_fd_sc_hd__decap_8
XFILLER_0_97_418 VGND VGND VPWR VPWR sky130_fd_sc_hd__fill_2
X_4088_ u_pe_array.g_pe_row\[3\].g_pe_col\[2\].u_pe.psum_out\[12\] _1275_ VGND VGND
+ VPWR VPWR _1282_ sky130_fd_sc_hd__xnor2_1
X_7916_ clknet_leaf_77_clk _0821_ VGND VGND VPWR VPWR u_pe_array.u_fifo1.buffer\[3\]\[0\]
+ sky130_fd_sc_hd__dfxtp_1
XFILLER_0_77_142 VGND VGND VPWR VPWR sky130_fd_sc_hd__fill_1
X_7847_ clknet_leaf_99_clk _0752_ VGND VGND VPWR VPWR u_pe_array.u_fifo2.buffer\[1\]\[5\]
+ sky130_fd_sc_hd__dfxtp_1
XFILLER_0_93_635 VGND VGND VPWR VPWR sky130_fd_sc_hd__decap_4
XFILLER_0_65_337 VPWR VGND VPWR VGND sky130_ef_sc_hd__decap_12
XFILLER_0_80_307 VGND VGND VPWR VPWR sky130_fd_sc_hd__fill_1
X_7778_ clknet_leaf_73_clk _0684_ net13 VGND VGND VPWR VPWR u_pe_array.act_from_up\[4\]\[0\]
+ sky130_fd_sc_hd__dfrtp_1
X_6729_ _3301_ _3311_ VGND VGND VPWR VPWR _3314_ sky130_fd_sc_hd__or2b_1
XFILLER_0_46_573 VGND VGND VPWR VPWR sky130_fd_sc_hd__decap_8
XFILLER_0_104_623 VGND VGND VPWR VPWR sky130_fd_sc_hd__fill_2
XFILLER_0_61_554 VGND VGND VPWR VPWR sky130_fd_sc_hd__decap_6
XFILLER_0_104_645 VPWR VGND VPWR VGND sky130_ef_sc_hd__decap_12
XFILLER_0_103_111 VGND VGND VPWR VPWR sky130_fd_sc_hd__fill_1
XFILLER_0_103_166 VGND VGND VPWR VPWR sky130_fd_sc_hd__fill_2
XFILLER_0_103_177 VPWR VGND VPWR VGND sky130_ef_sc_hd__decap_12
XFILLER_0_17_39 VPWR VGND VPWR VGND sky130_ef_sc_hd__decap_12
XFILLER_0_88_429 VGND VGND VPWR VPWR sky130_fd_sc_hd__decap_3
XTAP_1341 VGND VPWR sky130_fd_sc_hd__tapvpwrvgnd_1
XTAP_1330 VGND VPWR sky130_fd_sc_hd__tapvpwrvgnd_1
XFILLER_0_84_613 VGND VGND VPWR VPWR sky130_fd_sc_hd__fill_1
XFILLER_0_68_164 VGND VGND VPWR VPWR sky130_fd_sc_hd__decap_6
XTAP_1374 VGND VPWR sky130_fd_sc_hd__tapvpwrvgnd_1
XTAP_1363 VGND VPWR sky130_fd_sc_hd__tapvpwrvgnd_1
XTAP_1352 VGND VPWR sky130_fd_sc_hd__tapvpwrvgnd_1
XFILLER_0_84_635 VGND VGND VPWR VPWR sky130_fd_sc_hd__fill_1
XFILLER_0_56_348 VGND VGND VPWR VPWR sky130_fd_sc_hd__decap_8
XTAP_1396 VGND VPWR sky130_fd_sc_hd__tapvpwrvgnd_1
XTAP_1385 VGND VPWR sky130_fd_sc_hd__tapvpwrvgnd_1
XFILLER_0_25_702 VGND VGND VPWR VPWR sky130_fd_sc_hd__decap_3
XFILLER_0_24_212 VGND VGND VPWR VPWR sky130_fd_sc_hd__decap_4
Xinput25 v_in1[4] VGND VGND VPWR VPWR net25 sky130_fd_sc_hd__buf_1
Xinput14 start VGND VGND VPWR VPWR net14 sky130_fd_sc_hd__clkbuf_2
Xclkbuf_leaf_103_clk clknet_3_1__leaf_clk VGND VGND VPWR VPWR clknet_leaf_103_clk
+ sky130_fd_sc_hd__clkbuf_16
Xhold809 u_pe_array.g_pe_row\[1\].g_pe_col\[0\].u_pe.psum_out\[8\] VGND VGND VPWR
+ VPWR net883 sky130_fd_sc_hd__dlygate4sd3_1
XFILLER_0_58_68 VGND VGND VPWR VPWR sky130_fd_sc_hd__decap_4
XFILLER_0_20_473 VGND VGND VPWR VPWR sky130_fd_sc_hd__decap_3
X_5060_ u_pe_array.g_pe_row\[2\].g_pe_col\[0\].u_pe.act_val\[4\] _1882_ _1873_ net77
+ VGND VGND VPWR VPWR _0347_ sky130_fd_sc_hd__a22o_1
X_4011_ _1210_ _1211_ VGND VGND VPWR VPWR _1213_ sky130_fd_sc_hd__nor2_1
XFILLER_0_74_67 VGND VGND VPWR VPWR sky130_fd_sc_hd__decap_4
X_5962_ u_pe_array.u_fifo1.buffer\[4\]\[5\] _2680_ _2724_ _2726_ VGND VGND VPWR VPWR
+ _2727_ sky130_fd_sc_hd__a211o_1
X_4913_ _1897_ _1898_ VGND VGND VPWR VPWR _1899_ sky130_fd_sc_hd__xnor2_1
XFILLER_0_75_613 VGND VGND VPWR VPWR sky130_fd_sc_hd__decap_3
XFILLER_0_59_142 VGND VGND VPWR VPWR sky130_fd_sc_hd__fill_1
X_7701_ clknet_leaf_75_clk _0607_ net949 VGND VGND VPWR VPWR u_pe_array.act_from_up\[6\]\[5\]
+ sky130_fd_sc_hd__dfrtp_1
XFILLER_0_74_123 VPWR VGND VPWR VGND sky130_ef_sc_hd__decap_12
X_5893_ _2672_ VGND VGND VPWR VPWR _0523_ sky130_fd_sc_hd__clkbuf_1
XFILLER_0_47_326 VGND VGND VPWR VPWR sky130_fd_sc_hd__fill_1
XFILLER_0_47_337 VGND VGND VPWR VPWR sky130_fd_sc_hd__decap_4
XFILLER_0_117_225 VPWR VGND VPWR VGND sky130_ef_sc_hd__decap_12
XFILLER_0_75_668 VGND VGND VPWR VPWR sky130_fd_sc_hd__decap_4
XFILLER_0_62_307 VGND VGND VPWR VPWR sky130_fd_sc_hd__fill_1
XFILLER_0_23_82 VGND VGND VPWR VPWR sky130_fd_sc_hd__decap_6
XFILLER_0_28_551 VGND VGND VPWR VPWR sky130_fd_sc_hd__fill_1
X_4844_ _1846_ _1851_ _1857_ _1860_ _1856_ VGND VGND VPWR VPWR _1861_ sky130_fd_sc_hd__a32o_1
X_7632_ clknet_leaf_73_clk _0538_ net949 VGND VGND VPWR VPWR u_pe_array.g_pe_row\[1\].g_pe_col\[0\].u_pe.act_val\[5\]
+ sky130_fd_sc_hd__dfrtp_1
X_7563_ clknet_leaf_47_clk _0469_ net73 VGND VGND VPWR VPWR u_pe_array.act_from_down\[1\]\[3\]
+ sky130_fd_sc_hd__dfrtp_1
XFILLER_0_90_638 VGND VGND VPWR VPWR sky130_fd_sc_hd__decap_6
XFILLER_0_74_178 VPWR VGND VPWR VGND sky130_ef_sc_hd__decap_12
X_4775_ u_pe_array.g_pe_row\[2\].g_pe_col\[2\].u_pe.psum_out\[4\] _1786_ _1798_ VGND
+ VGND VPWR VPWR _1799_ sky130_fd_sc_hd__a21oi_2
XFILLER_0_15_201 VPWR VGND VPWR VGND sky130_ef_sc_hd__decap_12
X_6514_ _3141_ _3143_ VGND VGND VPWR VPWR _3145_ sky130_fd_sc_hd__nand2_1
X_3726_ _0985_ VGND VGND VPWR VPWR _0986_ sky130_fd_sc_hd__buf_8
X_7494_ clknet_leaf_40_clk _0400_ net947 VGND VGND VPWR VPWR u_pe_array.g_pe_row\[1\].g_pe_col\[3\].u_pe.psum_out\[3\]
+ sky130_fd_sc_hd__dfrtp_1
X_6445_ u_pe_array.g_pe_row\[0\].g_pe_col\[1\].u_pe.psum_out\[1\] u_pe_array.g_pe_row\[0\].g_pe_col\[1\].u_pe.act_val\[1\]
+ _3102_ VGND VGND VPWR VPWR _3104_ sky130_fd_sc_hd__mux2_1
XFILLER_0_3_673 VPWR VGND VPWR VGND sky130_ef_sc_hd__decap_12
X_3657_ _0942_ VGND VGND VPWR VPWR _0943_ sky130_fd_sc_hd__buf_6
XFILLER_0_113_486 VGND VGND VPWR VPWR sky130_fd_sc_hd__decap_8
X_3588_ _0891_ VGND VGND VPWR VPWR _0002_ sky130_fd_sc_hd__clkbuf_1
X_6376_ _3043_ _2130_ u_pe_array.g_pe_row\[0\].g_pe_col\[2\].u_pe.psum_out\[6\] VGND
+ VGND VPWR VPWR _3045_ sky130_fd_sc_hd__a21o_1
X_5327_ u_pe_array.g_pe_row\[1\].g_pe_col\[3\].u_pe.psum_out\[7\] _1426_ VGND VGND
+ VPWR VPWR _2226_ sky130_fd_sc_hd__nand2_1
X_5258_ _1884_ _2161_ _2163_ _1803_ net515 VGND VGND VPWR VPWR _0397_ sky130_fd_sc_hd__a32o_1
X_5189_ u_pe_array.g_pe_row\[2\].g_pe_col\[0\].u_pe.psum_out\[9\] u_pe_array.g_pe_row\[2\].g_pe_col\[0\].u_pe.psum_out\[10\]
+ _1286_ VGND VGND VPWR VPWR _2124_ sky130_fd_sc_hd__o21a_1
X_4209_ _1367_ u_pe_array.g_pe_row\[3\].g_pe_col\[1\].u_pe.psum_out\[6\] _1106_ VGND
+ VGND VPWR VPWR _1368_ sky130_fd_sc_hd__nand3_2
XFILLER_0_3_81 VPWR VGND VPWR VGND sky130_ef_sc_hd__decap_12
XFILLER_0_38_337 VGND VGND VPWR VPWR sky130_fd_sc_hd__decap_3
XFILLER_0_108_225 VGND VGND VPWR VPWR sky130_fd_sc_hd__decap_4
XFILLER_0_108_247 VGND VGND VPWR VPWR sky130_fd_sc_hd__fill_2
XFILLER_0_0_109 VGND VGND VPWR VPWR sky130_fd_sc_hd__decap_3
XFILLER_0_104_486 VGND VGND VPWR VPWR sky130_fd_sc_hd__fill_1
XFILLER_0_69_462 VGND VGND VPWR VPWR sky130_fd_sc_hd__fill_1
XFILLER_0_69_440 VGND VGND VPWR VPWR sky130_fd_sc_hd__fill_1
XFILLER_0_96_270 VGND VGND VPWR VPWR sky130_fd_sc_hd__fill_2
XFILLER_0_84_421 VGND VGND VPWR VPWR sky130_fd_sc_hd__decap_4
XFILLER_0_69_484 VGND VGND VPWR VPWR sky130_fd_sc_hd__decap_6
XFILLER_0_29_326 VGND VGND VPWR VPWR sky130_fd_sc_hd__decap_3
XFILLER_0_29_337 VGND VGND VPWR VPWR sky130_fd_sc_hd__decap_4
XFILLER_0_96_292 VPWR VGND VPWR VGND sky130_ef_sc_hd__decap_12
XFILLER_0_84_443 VGND VGND VPWR VPWR sky130_fd_sc_hd__decap_6
XTAP_1182 VGND VPWR sky130_fd_sc_hd__tapvpwrvgnd_1
XTAP_1160 VGND VPWR sky130_fd_sc_hd__tapvpwrvgnd_1
XTAP_1171 VGND VPWR sky130_fd_sc_hd__tapvpwrvgnd_1
XFILLER_0_57_668 VGND VGND VPWR VPWR sky130_fd_sc_hd__decap_4
XTAP_1193 VGND VPWR sky130_fd_sc_hd__tapvpwrvgnd_1
XFILLER_0_72_638 VGND VGND VPWR VPWR sky130_fd_sc_hd__decap_6
XFILLER_0_72_616 VGND VGND VPWR VPWR sky130_fd_sc_hd__fill_2
XFILLER_0_4_404 VGND VGND VPWR VPWR sky130_fd_sc_hd__fill_2
X_4560_ _1627_ u_pe_array.g_pe_row\[2\].g_pe_col\[3\].u_pe.psum_out\[1\] _1427_ VGND
+ VGND VPWR VPWR _1628_ sky130_fd_sc_hd__o21a_1
XFILLER_0_107_3 VPWR VGND VPWR VGND sky130_ef_sc_hd__decap_12
XFILLER_0_8_15 VPWR VGND VPWR VGND sky130_ef_sc_hd__decap_12
XFILLER_0_69_45 VGND VGND VPWR VPWR sky130_fd_sc_hd__decap_6
Xhold606 u_pe_array.u_fifo2.buffer\[4\]\[2\] VGND VGND VPWR VPWR net680 sky130_fd_sc_hd__dlygate4sd3_1
XFILLER_0_12_215 VPWR VGND VPWR VGND sky130_ef_sc_hd__decap_12
Xhold617 u_pe_array.u_fifo2.buffer\[5\]\[0\] VGND VGND VPWR VPWR net691 sky130_fd_sc_hd__dlygate4sd3_1
X_4491_ _1487_ _1589_ _1590_ _1356_ net764 VGND VGND VPWR VPWR _0203_ sky130_fd_sc_hd__a32o_1
Xhold639 u_pe_array.g_pe_row\[1\].g_pe_col\[1\].u_pe.psum_out\[5\] VGND VGND VPWR
+ VPWR net713 sky130_fd_sc_hd__dlygate4sd3_1
XFILLER_0_100_53 VPWR VGND VPWR VGND sky130_ef_sc_hd__decap_12
X_6230_ _2937_ _2913_ _2926_ _2930_ VGND VGND VPWR VPWR _2938_ sky130_fd_sc_hd__a22o_1
XFILLER_0_69_67 VPWR VGND VPWR VGND sky130_ef_sc_hd__decap_12
Xhold628 u_pe_array.g_pe_row\[2\].g_pe_col\[2\].u_pe.psum_out\[1\] VGND VGND VPWR
+ VPWR net702 sky130_fd_sc_hd__dlygate4sd3_1
XFILLER_0_100_97 VGND VGND VPWR VPWR sky130_fd_sc_hd__fill_1
X_6161_ u_pe_array.g_pe_row\[0\].g_pe_col\[3\].u_pe.psum_out\[2\] _2874_ VGND VGND
+ VPWR VPWR _2875_ sky130_fd_sc_hd__xnor2_1
XTAP_900 VGND VPWR sky130_fd_sc_hd__tapvpwrvgnd_1
X_5112_ u_pe_array.g_pe_row\[2\].g_pe_col\[0\].u_pe.act_val\[3\] _1284_ _2040_ _2039_
+ VGND VGND VPWR VPWR _2055_ sky130_fd_sc_hd__a31o_1
XTAP_944 VGND VPWR sky130_fd_sc_hd__tapvpwrvgnd_1
XTAP_933 VGND VPWR sky130_fd_sc_hd__tapvpwrvgnd_1
XTAP_911 VGND VPWR sky130_fd_sc_hd__tapvpwrvgnd_1
XTAP_922 VGND VPWR sky130_fd_sc_hd__tapvpwrvgnd_1
XTAP_977 VGND VPWR sky130_fd_sc_hd__tapvpwrvgnd_1
XTAP_966 VGND VPWR sky130_fd_sc_hd__tapvpwrvgnd_1
XTAP_955 VGND VPWR sky130_fd_sc_hd__tapvpwrvgnd_1
X_6092_ _2795_ _2836_ _2837_ _2621_ net658 VGND VGND VPWR VPWR _0557_ sky130_fd_sc_hd__a32o_1
XFILLER_0_109_51 VGND VGND VPWR VPWR sky130_fd_sc_hd__decap_4
XTAP_999 VGND VPWR sky130_fd_sc_hd__tapvpwrvgnd_1
XTAP_988 VGND VPWR sky130_fd_sc_hd__tapvpwrvgnd_1
XFILLER_0_18_71 VGND VGND VPWR VPWR sky130_fd_sc_hd__decap_8
X_5043_ _1734_ VGND VGND VPWR VPWR _2009_ sky130_fd_sc_hd__buf_6
XFILLER_0_18_82 VGND VGND VPWR VPWR sky130_fd_sc_hd__fill_2
X_6994_ _3489_ VGND VGND VPWR VPWR _0807_ sky130_fd_sc_hd__clkbuf_1
X_5945_ u_pe_array.u_fifo1.buffer\[3\]\[3\] _2685_ _2686_ u_pe_array.u_fifo1.buffer\[2\]\[3\]
+ _2711_ VGND VGND VPWR VPWR _2712_ sky130_fd_sc_hd__a221o_1
X_5876_ net781 _2661_ _2273_ VGND VGND VPWR VPWR _2662_ sky130_fd_sc_hd__mux2_1
X_4827_ _1839_ _1840_ _1845_ _1842_ _1837_ VGND VGND VPWR VPWR _1846_ sky130_fd_sc_hd__a32o_1
XFILLER_0_35_318 VGND VGND VPWR VPWR sky130_fd_sc_hd__decap_8
X_7615_ clknet_leaf_69_clk _0521_ net72 VGND VGND VPWR VPWR u_pe_array.act_from_left\[5\]\[1\]
+ sky130_fd_sc_hd__dfrtp_1
XFILLER_0_118_589 VPWR VGND VPWR VGND sky130_ef_sc_hd__decap_12
XFILLER_0_118_567 VGND VGND VPWR VPWR sky130_fd_sc_hd__fill_1
XFILLER_0_62_126 VGND VGND VPWR VPWR sky130_fd_sc_hd__decap_4
XFILLER_0_7_264 VGND VGND VPWR VPWR sky130_fd_sc_hd__fill_2
XFILLER_0_28_392 VGND VGND VPWR VPWR sky130_fd_sc_hd__decap_4
XFILLER_0_71_671 VGND VGND VPWR VPWR sky130_fd_sc_hd__fill_1
X_4758_ _1771_ _1780_ _1779_ VGND VGND VPWR VPWR _1783_ sky130_fd_sc_hd__a21oi_1
X_7546_ clknet_leaf_91_clk _0452_ net949 VGND VGND VPWR VPWR u_pe_array.g_pe_row\[1\].g_pe_col\[2\].u_pe.psum_out\[1\]
+ sky130_fd_sc_hd__dfrtp_1
X_7477_ clknet_leaf_42_clk _0383_ net946 VGND VGND VPWR VPWR u_pe_array.act_from_down\[3\]\[12\]
+ sky130_fd_sc_hd__dfrtp_1
X_3709_ net825 _0939_ VGND VGND VPWR VPWR _0973_ sky130_fd_sc_hd__and2_1
X_4689_ u_pe_array.g_pe_row\[2\].g_pe_col\[2\].u_pe.psum_out\[4\] u_pe_array.g_pe_row\[2\].g_pe_col\[2\].u_pe.act_val\[4\]
+ _1599_ VGND VGND VPWR VPWR _1740_ sky130_fd_sc_hd__mux2_1
X_6428_ _3090_ _3091_ VGND VGND VPWR VPWR _3092_ sky130_fd_sc_hd__or2_1
XFILLER_0_101_478 VGND VGND VPWR VPWR sky130_fd_sc_hd__decap_6
XFILLER_0_11_281 VGND VGND VPWR VPWR sky130_fd_sc_hd__fill_1
X_6359_ _3017_ _3014_ _3013_ VGND VGND VPWR VPWR _3030_ sky130_fd_sc_hd__a21o_1
XPHY_210 VGND VGND VPWR VPWR sky130_fd_sc_hd__decap_3
XFILLER_0_66_421 VGND VGND VPWR VPWR sky130_fd_sc_hd__decap_3
XFILLER_0_14_29 VPWR VGND VPWR VGND sky130_ef_sc_hd__decap_12
XFILLER_0_38_101 VGND VGND VPWR VPWR sky130_fd_sc_hd__decap_3
XPHY_232 VGND VGND VPWR VPWR sky130_fd_sc_hd__decap_3
XPHY_221 VGND VGND VPWR VPWR sky130_fd_sc_hd__decap_3
XFILLER_0_39_679 VGND VGND VPWR VPWR sky130_fd_sc_hd__fill_1
XFILLER_0_81_413 VGND VGND VPWR VPWR sky130_fd_sc_hd__fill_2
XFILLER_0_26_307 VGND VGND VPWR VPWR sky130_fd_sc_hd__fill_1
XFILLER_0_54_649 VGND VGND VPWR VPWR sky130_fd_sc_hd__fill_1
XFILLER_0_34_373 VGND VGND VPWR VPWR sky130_fd_sc_hd__fill_1
XFILLER_0_34_384 VGND VGND VPWR VPWR sky130_fd_sc_hd__decap_6
XFILLER_0_1_429 VPWR VGND VPWR VGND sky130_ef_sc_hd__decap_12
XFILLER_0_22_557 VGND VGND VPWR VPWR sky130_fd_sc_hd__decap_4
XFILLER_0_39_48 VGND VGND VPWR VPWR sky130_fd_sc_hd__fill_1
Xhold3 u_pe_array.act_from_right\[8\]\[4\] VGND VGND VPWR VPWR net77 sky130_fd_sc_hd__dlygate4sd3_1
XFILLER_0_55_25 VPWR VGND VPWR VGND sky130_ef_sc_hd__decap_12
XFILLER_0_89_502 VGND VGND VPWR VPWR sky130_fd_sc_hd__fill_2
XFILLER_0_69_281 VGND VGND VPWR VPWR sky130_fd_sc_hd__fill_2
X_3991_ u_pe_array.g_pe_row\[3\].g_pe_col\[2\].u_pe.act_val\[3\] u_pe_array.g_pe_row\[3\].g_pe_col\[2\].u_pe.w_out\[0\]
+ VGND VGND VPWR VPWR _1194_ sky130_fd_sc_hd__nand2_1
X_5730_ u_pe_array.g_pe_row\[1\].g_pe_col\[1\].u_pe.act_val\[2\] u_pe_array.g_pe_row\[1\].g_pe_col\[1\].u_pe.w_out\[0\]
+ _2524_ VGND VGND VPWR VPWR _2538_ sky130_fd_sc_hd__and3_1
XFILLER_0_72_413 VGND VGND VPWR VPWR sky130_fd_sc_hd__fill_1
XFILLER_0_57_487 VPWR VGND VPWR VGND sky130_ef_sc_hd__decap_12
XFILLER_0_29_167 VGND VGND VPWR VPWR sky130_fd_sc_hd__fill_1
X_5661_ net301 _2143_ _2491_ _2494_ VGND VGND VPWR VPWR _0469_ sky130_fd_sc_hd__a22o_1
X_7400_ clknet_leaf_28_clk net86 net942 VGND VGND VPWR VPWR u_pe_array.g_pe_row\[2\].g_pe_col\[1\].u_pe.act_val\[4\]
+ sky130_fd_sc_hd__dfrtp_1
XFILLER_0_44_115 VGND VGND VPWR VPWR sky130_fd_sc_hd__fill_1
X_5592_ _2426_ VGND VGND VPWR VPWR _2438_ sky130_fd_sc_hd__inv_2
X_4612_ _1671_ _1672_ _1674_ VGND VGND VPWR VPWR _1676_ sky130_fd_sc_hd__a21o_1
X_4543_ net439 _1310_ _1483_ net458 VGND VGND VPWR VPWR _0231_ sky130_fd_sc_hd__a22o_1
XFILLER_0_53_693 VGND VGND VPWR VPWR sky130_fd_sc_hd__decap_4
XFILLER_0_13_513 VGND VGND VPWR VPWR sky130_fd_sc_hd__decap_4
X_7331_ clknet_leaf_1_clk _0237_ net944 VGND VGND VPWR VPWR u_pe_array.g_pe_row\[2\].g_pe_col\[3\].u_pe.psum_out\[4\]
+ sky130_fd_sc_hd__dfrtp_1
Xhold414 u_pe_array.g_pe_row\[0\].g_pe_col\[1\].u_pe.psum_out\[4\] VGND VGND VPWR
+ VPWR net488 sky130_fd_sc_hd__dlygate4sd3_1
Xhold436 u_pe_array.g_pe_row\[0\].g_pe_col\[1\].u_pe.psum_out\[1\] VGND VGND VPWR
+ VPWR net510 sky130_fd_sc_hd__dlygate4sd3_1
XFILLER_0_102_209 VGND VGND VPWR VPWR sky130_fd_sc_hd__decap_4
Xhold425 u_pe_array.act_from_up\[4\]\[9\] VGND VGND VPWR VPWR net499 sky130_fd_sc_hd__dlygate4sd3_1
Xhold403 u_pe_array.act_from_up\[4\]\[8\] VGND VGND VPWR VPWR net477 sky130_fd_sc_hd__dlygate4sd3_1
X_7262_ clknet_leaf_6_clk _0168_ net945 VGND VGND VPWR VPWR u_pe_array.act_from_left\[13\]\[2\]
+ sky130_fd_sc_hd__dfrtp_1
XFILLER_0_20_83 VGND VGND VPWR VPWR sky130_fd_sc_hd__fill_1
XFILLER_0_96_21 VGND VGND VPWR VPWR sky130_fd_sc_hd__decap_6
X_6213_ _2919_ _2920_ _2922_ VGND VGND VPWR VPWR _2923_ sky130_fd_sc_hd__a21oi_1
Xhold447 u_pe_array.g_pe_row\[1\].g_pe_col\[3\].u_pe.psum_out\[5\] VGND VGND VPWR
+ VPWR net521 sky130_fd_sc_hd__dlygate4sd3_1
Xhold458 u_pe_array.g_pe_row\[1\].g_pe_col\[0\].u_pe.psum_out\[0\] VGND VGND VPWR
+ VPWR net532 sky130_fd_sc_hd__dlygate4sd3_1
X_4474_ _1487_ _1574_ _1575_ _1356_ net673 VGND VGND VPWR VPWR _0201_ sky130_fd_sc_hd__a32o_1
Xhold469 u_pe_array.g_pe_row\[1\].g_pe_col\[0\].u_pe.psum_out\[6\] VGND VGND VPWR
+ VPWR net543 sky130_fd_sc_hd__dlygate4sd3_1
XFILLER_0_0_473 VGND VGND VPWR VPWR sky130_fd_sc_hd__decap_3
X_7193_ clknet_leaf_97_clk _0099_ net950 VGND VGND VPWR VPWR u_pe_array.g_pe_row\[3\].g_pe_col\[2\].u_pe.psum_out\[2\]
+ sky130_fd_sc_hd__dfrtp_1
X_6144_ u_pe_array.g_pe_row\[0\].g_pe_col\[3\].u_pe.act_val\[0\] u_pe_array.g_pe_row\[0\].g_pe_col\[3\].u_pe.w_out\[0\]
+ u_pe_array.g_pe_row\[0\].g_pe_col\[3\].u_pe.psum_out\[0\] VGND VGND VPWR VPWR _2860_
+ sky130_fd_sc_hd__a21o_1
XTAP_730 VGND VPWR sky130_fd_sc_hd__tapvpwrvgnd_1
XTAP_752 VGND VPWR sky130_fd_sc_hd__tapvpwrvgnd_1
XTAP_741 VGND VPWR sky130_fd_sc_hd__tapvpwrvgnd_1
X_6075_ _2795_ _2821_ _2822_ _2621_ net902 VGND VGND VPWR VPWR _0555_ sky130_fd_sc_hd__a32o_1
XTAP_763 VGND VPWR sky130_fd_sc_hd__tapvpwrvgnd_1
XTAP_774 VGND VPWR sky130_fd_sc_hd__tapvpwrvgnd_1
XTAP_785 VGND VPWR sky130_fd_sc_hd__tapvpwrvgnd_1
X_5026_ _1999_ _1426_ _0931_ VGND VGND VPWR VPWR _2000_ sky130_fd_sc_hd__mux2_1
XFILLER_0_31_3 VPWR VGND VPWR VGND sky130_ef_sc_hd__decap_12
XTAP_796 VGND VPWR sky130_fd_sc_hd__tapvpwrvgnd_1
XFILLER_0_95_505 VPWR VGND VPWR VGND sky130_ef_sc_hd__decap_12
Xclkbuf_leaf_92_clk clknet_3_4__leaf_clk VGND VGND VPWR VPWR clknet_leaf_92_clk sky130_fd_sc_hd__clkbuf_16
XFILLER_0_45_80 VGND VGND VPWR VPWR sky130_fd_sc_hd__decap_6
X_6977_ u_pe_array.u_fifo1.count\[0\] _3477_ u_pe_array.u_fifo1.count\[2\] VGND VGND
+ VPWR VPWR _3479_ sky130_fd_sc_hd__a21o_1
XFILLER_0_75_240 VGND VGND VPWR VPWR sky130_fd_sc_hd__fill_1
X_5928_ u_pe_array.u_fifo1.buffer\[5\]\[1\] _2687_ _2688_ u_pe_array.u_fifo1.buffer\[6\]\[1\]
+ _2689_ VGND VGND VPWR VPWR _2697_ sky130_fd_sc_hd__a221o_1
XFILLER_0_63_413 VGND VGND VPWR VPWR sky130_fd_sc_hd__fill_1
XFILLER_0_36_638 VGND VGND VPWR VPWR sky130_fd_sc_hd__decap_6
X_5859_ u_pe_array.g_pe_row\[1\].g_pe_col\[0\].u_pe.psum_out\[6\] _1112_ _1109_ _2648_
+ VGND VGND VPWR VPWR _2649_ sky130_fd_sc_hd__o211a_1
XFILLER_0_106_559 VGND VGND VPWR VPWR sky130_fd_sc_hd__fill_2
XFILLER_0_44_693 VGND VGND VPWR VPWR sky130_fd_sc_hd__decap_6
X_7529_ clknet_leaf_69_clk _0435_ net72 VGND VGND VPWR VPWR u_pe_array.act_from_left\[7\]\[10\]
+ sky130_fd_sc_hd__dfrtp_1
XFILLER_0_31_332 VGND VGND VPWR VPWR sky130_fd_sc_hd__decap_4
XFILLER_0_31_354 VGND VGND VPWR VPWR sky130_fd_sc_hd__fill_1
XFILLER_0_98_332 VGND VGND VPWR VPWR sky130_fd_sc_hd__decap_6
Xclkbuf_leaf_83_clk clknet_3_4__leaf_clk VGND VGND VPWR VPWR clknet_leaf_83_clk sky130_fd_sc_hd__clkbuf_16
XFILLER_0_66_273 VGND VGND VPWR VPWR sky130_fd_sc_hd__decap_4
XFILLER_0_39_487 VGND VGND VPWR VPWR sky130_fd_sc_hd__fill_2
XFILLER_0_27_649 VGND VGND VPWR VPWR sky130_fd_sc_hd__decap_3
XFILLER_0_1_259 VGND VGND VPWR VPWR sky130_fd_sc_hd__decap_4
XFILLER_0_1_237 VPWR VGND VPWR VGND sky130_ef_sc_hd__decap_12
XFILLER_0_5_27 VPWR VGND VPWR VGND sky130_ef_sc_hd__decap_12
X_4190_ _1348_ _1349_ VGND VGND VPWR VPWR _1351_ sky130_fd_sc_hd__nor2_1
XFILLER_0_89_332 VGND VGND VPWR VPWR sky130_fd_sc_hd__decap_4
XFILLER_0_77_505 VGND VGND VPWR VPWR sky130_fd_sc_hd__decap_8
Xclkbuf_leaf_74_clk clknet_3_5__leaf_clk VGND VGND VPWR VPWR clknet_leaf_74_clk sky130_fd_sc_hd__clkbuf_16
X_7880_ clknet_leaf_100_clk _0785_ VGND VGND VPWR VPWR u_pe_array.u_fifo2.buffer\[7\]\[2\]
+ sky130_fd_sc_hd__dfxtp_1
X_6900_ _0911_ net691 _3431_ VGND VGND VPWR VPWR _3432_ sky130_fd_sc_hd__mux2_1
XFILLER_0_106_41 VPWR VGND VPWR VGND sky130_ef_sc_hd__decap_12
XFILLER_0_77_549 VGND VGND VPWR VPWR sky130_fd_sc_hd__decap_8
X_6831_ net551 _0911_ _3392_ VGND VGND VPWR VPWR _3393_ sky130_fd_sc_hd__mux2_1
XFILLER_0_106_85 VPWR VGND VPWR VGND sky130_ef_sc_hd__decap_12
X_6762_ u_pe_array.g_pe_row\[0\].g_pe_col\[0\].u_pe.psum_out\[9\] u_pe_array.g_pe_row\[0\].g_pe_col\[0\].u_pe.psum_out\[10\]
+ _2488_ VGND VGND VPWR VPWR _3343_ sky130_fd_sc_hd__o21a_1
XFILLER_0_9_337 VGND VGND VPWR VPWR sky130_fd_sc_hd__decap_4
X_3974_ u_pe_array.g_pe_row\[3\].g_pe_col\[2\].u_pe.act_val\[0\] u_pe_array.g_pe_row\[3\].g_pe_col\[2\].u_pe.psum_out\[1\]
+ _0934_ VGND VGND VPWR VPWR _1179_ sky130_fd_sc_hd__and3_1
X_5713_ u_pe_array.g_pe_row\[1\].g_pe_col\[1\].u_pe.psum_out\[1\] _2518_ _2521_ VGND
+ VGND VPWR VPWR _2522_ sky130_fd_sc_hd__a21bo_1
X_6693_ _3280_ _3281_ VGND VGND VPWR VPWR _3282_ sky130_fd_sc_hd__xnor2_2
XFILLER_0_57_284 VGND VGND VPWR VPWR sky130_fd_sc_hd__decap_8
XFILLER_0_18_649 VGND VGND VPWR VPWR sky130_fd_sc_hd__fill_1
XFILLER_0_45_424 VGND VGND VPWR VPWR sky130_fd_sc_hd__fill_2
XFILLER_0_45_446 VGND VGND VPWR VPWR sky130_fd_sc_hd__fill_2
XFILLER_0_60_405 VGND VGND VPWR VPWR sky130_fd_sc_hd__decap_8
X_5644_ u_pe_array.g_pe_row\[1\].g_pe_col\[2\].u_pe.psum_out\[12\] _2477_ VGND VGND
+ VPWR VPWR _2484_ sky130_fd_sc_hd__xnor2_1
XFILLER_0_5_521 VGND VGND VPWR VPWR sky130_fd_sc_hd__fill_2
XFILLER_0_72_298 VGND VGND VPWR VPWR sky130_fd_sc_hd__fill_1
XFILLER_0_5_543 VPWR VGND VPWR VGND sky130_ef_sc_hd__decap_12
Xhold200 _0314_ VGND VGND VPWR VPWR net274 sky130_fd_sc_hd__dlygate4sd3_1
XFILLER_0_60_449 VGND VGND VPWR VPWR sky130_fd_sc_hd__fill_2
Xhold211 u_pe_array.g_pe_row\[2\].g_pe_col\[3\].u_pe.move_reg\[6\] VGND VGND VPWR
+ VPWR net285 sky130_fd_sc_hd__dlygate4sd3_1
X_5575_ u_pe_array.g_pe_row\[1\].g_pe_col\[2\].u_pe.act_val\[5\] _1595_ VGND VGND
+ VPWR VPWR _2422_ sky130_fd_sc_hd__nand2_1
X_7314_ clknet_leaf_5_clk _0220_ net945 VGND VGND VPWR VPWR u_pe_array.g_pe_row\[2\].g_pe_col\[3\].u_pe.act_val\[0\]
+ sky130_fd_sc_hd__dfrtp_4
Xhold233 _0310_ VGND VGND VPWR VPWR net307 sky130_fd_sc_hd__dlygate4sd3_1
Xhold222 _0311_ VGND VGND VPWR VPWR net296 sky130_fd_sc_hd__dlygate4sd3_1
Xhold244 u_fsm.cnt\[0\] VGND VGND VPWR VPWR net318 sky130_fd_sc_hd__dlygate4sd3_1
XFILLER_0_41_685 VGND VGND VPWR VPWR sky130_fd_sc_hd__fill_2
X_4526_ u_pe_array.g_pe_row\[2\].g_pe_col\[3\].u_pe.psum_out\[10\] u_pe_array.g_pe_row\[2\].g_pe_col\[3\].u_pe.move_reg\[10\]
+ _1599_ VGND VGND VPWR VPWR _1612_ sky130_fd_sc_hd__mux2_1
XFILLER_0_111_540 VGND VGND VPWR VPWR sky130_fd_sc_hd__decap_8
Xhold266 u_pe_array.act_from_down\[9\]\[0\] VGND VGND VPWR VPWR net340 sky130_fd_sc_hd__dlygate4sd3_1
Xhold255 _0351_ VGND VGND VPWR VPWR net329 sky130_fd_sc_hd__dlygate4sd3_1
Xhold277 u_pe_array.g_pe_row\[0\].g_pe_col\[3\].u_pe.psum_out\[5\] VGND VGND VPWR
+ VPWR net351 sky130_fd_sc_hd__dlygate4sd3_1
X_7245_ clknet_leaf_18_clk _0151_ net943 VGND VGND VPWR VPWR u_pe_array.g_pe_row\[2\].g_pe_col\[3\].u_pe.w_out\[0\]
+ sky130_fd_sc_hd__dfrtp_1
X_4457_ u_pe_array.g_pe_row\[3\].g_pe_col\[0\].u_pe.psum_out\[7\] VGND VGND VPWR VPWR
+ _1560_ sky130_fd_sc_hd__inv_2
XFILLER_0_40_195 VGND VGND VPWR VPWR sky130_fd_sc_hd__fill_1
Xhold299 u_pe_array.g_pe_row\[0\].g_pe_col\[3\].u_pe.psum_out\[4\] VGND VGND VPWR
+ VPWR net373 sky130_fd_sc_hd__dlygate4sd3_1
Xhold288 u_pe_array.act_from_up\[12\]\[8\] VGND VGND VPWR VPWR net362 sky130_fd_sc_hd__dlygate4sd3_1
X_7176_ clknet_leaf_9_clk _0082_ net945 VGND VGND VPWR VPWR u_pe_array.act_from_left\[15\]\[11\]
+ sky130_fd_sc_hd__dfrtp_1
X_6127_ u_pe_array.g_pe_row\[0\].g_pe_col\[3\].u_pe.psum_out\[11\] net495 _2844_ VGND
+ VGND VPWR VPWR _2858_ sky130_fd_sc_hd__mux2_1
X_4388_ u_pe_array.g_pe_row\[3\].g_pe_col\[0\].u_pe.act_val\[1\] _1287_ VGND VGND
+ VPWR VPWR _1497_ sky130_fd_sc_hd__and2b_1
XFILLER_0_0_292 VGND VGND VPWR VPWR sky130_fd_sc_hd__fill_2
XTAP_560 VGND VPWR sky130_fd_sc_hd__tapvpwrvgnd_1
XTAP_571 VGND VPWR sky130_fd_sc_hd__tapvpwrvgnd_1
XTAP_593 VGND VPWR sky130_fd_sc_hd__tapvpwrvgnd_1
XTAP_582 VGND VPWR sky130_fd_sc_hd__tapvpwrvgnd_1
X_6058_ u_pe_array.g_pe_row\[1\].g_pe_col\[0\].u_pe.psum_out\[7\] VGND VGND VPWR VPWR
+ _2807_ sky130_fd_sc_hd__inv_2
X_5009_ _1980_ _1985_ _1092_ VGND VGND VPWR VPWR _1987_ sky130_fd_sc_hd__o21ai_1
Xclkbuf_leaf_65_clk clknet_3_6__leaf_clk VGND VGND VPWR VPWR clknet_leaf_65_clk sky130_fd_sc_hd__clkbuf_16
XTAP_1715 VGND VPWR sky130_fd_sc_hd__tapvpwrvgnd_1
XTAP_1704 VGND VPWR sky130_fd_sc_hd__tapvpwrvgnd_1
XTAP_1748 VGND VPWR sky130_fd_sc_hd__tapvpwrvgnd_1
XTAP_1737 VGND VPWR sky130_fd_sc_hd__tapvpwrvgnd_1
XTAP_1726 VGND VPWR sky130_fd_sc_hd__tapvpwrvgnd_1
XFILLER_0_36_413 VGND VGND VPWR VPWR sky130_fd_sc_hd__decap_6
XFILLER_0_106_345 VGND VGND VPWR VPWR sky130_fd_sc_hd__fill_2
XFILLER_0_8_392 VPWR VGND VPWR VGND sky130_ef_sc_hd__decap_12
XFILLER_0_32_641 VGND VGND VPWR VPWR sky130_fd_sc_hd__decap_3
Xclkbuf_leaf_56_clk clknet_3_7__leaf_clk VGND VGND VPWR VPWR clknet_leaf_56_clk sky130_fd_sc_hd__clkbuf_16
XFILLER_0_99_685 VPWR VGND VPWR VGND sky130_ef_sc_hd__decap_12
XFILLER_0_98_173 VGND VGND VPWR VPWR sky130_fd_sc_hd__decap_8
XFILLER_0_98_195 VGND VGND VPWR VPWR sky130_fd_sc_hd__fill_1
XFILLER_0_39_262 VGND VGND VPWR VPWR sky130_fd_sc_hd__fill_1
XFILLER_0_94_390 VGND VGND VPWR VPWR sky130_fd_sc_hd__fill_1
XFILLER_0_54_210 VGND VGND VPWR VPWR sky130_fd_sc_hd__decap_4
XFILLER_0_6_307 VGND VGND VPWR VPWR sky130_fd_sc_hd__fill_1
XFILLER_0_54_287 VGND VGND VPWR VPWR sky130_fd_sc_hd__decap_3
XFILLER_0_54_265 VPWR VGND VPWR VGND sky130_ef_sc_hd__decap_12
X_3690_ _0962_ VGND VGND VPWR VPWR _0963_ sky130_fd_sc_hd__buf_12
XFILLER_0_2_513 VPWR VGND VPWR VGND sky130_ef_sc_hd__decap_12
XFILLER_0_35_490 VGND VGND VPWR VPWR sky130_fd_sc_hd__fill_2
XFILLER_0_112_348 VGND VGND VPWR VPWR sky130_fd_sc_hd__fill_1
X_5360_ _2250_ _2254_ VGND VGND VPWR VPWR _2256_ sky130_fd_sc_hd__or2_1
XFILLER_0_2_557 VPWR VGND VPWR VGND sky130_ef_sc_hd__decap_12
XFILLER_0_23_685 VPWR VGND VPWR VGND sky130_ef_sc_hd__decap_12
X_4311_ net816 _1453_ _1116_ VGND VGND VPWR VPWR _1454_ sky130_fd_sc_hd__mux2_1
X_5291_ _2189_ VGND VGND VPWR VPWR _2193_ sky130_fd_sc_hd__inv_2
XFILLER_0_10_324 VGND VGND VPWR VPWR sky130_fd_sc_hd__decap_8
XFILLER_0_22_195 VGND VGND VPWR VPWR sky130_fd_sc_hd__fill_1
X_4242_ _1397_ _1398_ net877 _1006_ VGND VGND VPWR VPWR _0146_ sky130_fd_sc_hd__a2bb2o_1
X_7030_ _3509_ VGND VGND VPWR VPWR _0823_ sky130_fd_sc_hd__clkbuf_1
X_4173_ _1330_ _1334_ VGND VGND VPWR VPWR _1335_ sky130_fd_sc_hd__xnor2_1
XFILLER_0_93_55 VGND VGND VPWR VPWR sky130_fd_sc_hd__fill_1
X_7932_ clknet_leaf_81_clk _0837_ VGND VGND VPWR VPWR u_pe_array.u_fifo1.buffer\[5\]\[4\]
+ sky130_fd_sc_hd__dfxtp_1
Xclkbuf_leaf_47_clk clknet_3_6__leaf_clk VGND VGND VPWR VPWR clknet_leaf_47_clk sky130_fd_sc_hd__clkbuf_16
XFILLER_0_77_313 VGND VGND VPWR VPWR sky130_fd_sc_hd__decap_3
X_7863_ clknet_leaf_99_clk _0768_ VGND VGND VPWR VPWR u_pe_array.u_fifo2.buffer\[4\]\[3\]
+ sky130_fd_sc_hd__dfxtp_1
X_7794_ clknet_leaf_54_clk net243 net74 VGND VGND VPWR VPWR u_pe_array.g_pe_row\[0\].g_pe_col\[0\].u_pe.act_val\[2\]
+ sky130_fd_sc_hd__dfrtp_4
XFILLER_0_58_571 VGND VGND VPWR VPWR sky130_fd_sc_hd__decap_8
X_6814_ _3379_ VGND VGND VPWR VPWR _3380_ sky130_fd_sc_hd__inv_2
X_6745_ net907 _2586_ _3328_ _0978_ VGND VGND VPWR VPWR _0719_ sky130_fd_sc_hd__a22o_1
XFILLER_0_9_145 VGND VGND VPWR VPWR sky130_fd_sc_hd__decap_3
X_3957_ net846 _1167_ _1169_ _1172_ VGND VGND VPWR VPWR _0087_ sky130_fd_sc_hd__a22o_1
XFILLER_0_9_178 VGND VGND VPWR VPWR sky130_fd_sc_hd__fill_1
XFILLER_0_116_643 VGND VGND VPWR VPWR sky130_fd_sc_hd__fill_1
X_6676_ u_pe_array.g_pe_row\[0\].g_pe_col\[0\].u_pe.psum_out\[3\] u_pe_array.g_pe_row\[0\].g_pe_col\[0\].u_pe.act_val\[3\]
+ _2486_ VGND VGND VPWR VPWR _3266_ sky130_fd_sc_hd__and3_1
X_3888_ _1129_ VGND VGND VPWR VPWR _0061_ sky130_fd_sc_hd__clkbuf_1
XFILLER_0_33_405 VGND VGND VPWR VPWR sky130_fd_sc_hd__decap_6
XFILLER_0_60_246 VGND VGND VPWR VPWR sky130_fd_sc_hd__decap_6
X_5627_ _2462_ _2463_ _2468_ _2465_ _2460_ VGND VGND VPWR VPWR _2469_ sky130_fd_sc_hd__a32o_1
XFILLER_0_103_337 VPWR VGND VPWR VGND sky130_ef_sc_hd__decap_12
XFILLER_0_60_268 VGND VGND VPWR VPWR sky130_fd_sc_hd__fill_1
X_5558_ _2402_ _2404_ _2406_ VGND VGND VPWR VPWR _2407_ sky130_fd_sc_hd__o21ai_1
X_4509_ net173 _1301_ _1305_ _1602_ VGND VGND VPWR VPWR _0209_ sky130_fd_sc_hd__a22o_1
X_5489_ u_pe_array.u_fifo2.buffer\[7\]\[2\] _2327_ _2329_ u_pe_array.u_fifo2.buffer\[1\]\[2\]
+ VGND VGND VPWR VPWR _2352_ sky130_fd_sc_hd__a22o_1
X_7228_ clknet_leaf_96_clk net256 net950 VGND VGND VPWR VPWR u_pe_array.g_pe_row\[3\].g_pe_col\[1\].u_pe.move_reg\[9\]
+ sky130_fd_sc_hd__dfrtp_1
X_7159_ clknet_leaf_97_clk _0065_ net945 VGND VGND VPWR VPWR u_pe_array.act_from_right\[13\]\[7\]
+ sky130_fd_sc_hd__dfrtp_1
XTAP_390 VGND VPWR sky130_fd_sc_hd__tapvpwrvgnd_1
Xclkbuf_leaf_38_clk clknet_3_3__leaf_clk VGND VGND VPWR VPWR clknet_leaf_38_clk sky130_fd_sc_hd__clkbuf_16
XTAP_1523 VGND VPWR sky130_fd_sc_hd__tapvpwrvgnd_1
XTAP_1512 VGND VPWR sky130_fd_sc_hd__tapvpwrvgnd_1
XTAP_1501 VGND VPWR sky130_fd_sc_hd__tapvpwrvgnd_1
XPHY_30 VGND VGND VPWR VPWR sky130_fd_sc_hd__decap_3
XTAP_1567 VGND VPWR sky130_fd_sc_hd__tapvpwrvgnd_1
XTAP_1556 VGND VPWR sky130_fd_sc_hd__tapvpwrvgnd_1
XTAP_1545 VGND VPWR sky130_fd_sc_hd__tapvpwrvgnd_1
XTAP_1534 VGND VPWR sky130_fd_sc_hd__tapvpwrvgnd_1
XFILLER_0_96_699 VGND VGND VPWR VPWR sky130_fd_sc_hd__fill_1
XFILLER_0_83_305 VGND VGND VPWR VPWR sky130_fd_sc_hd__fill_1
XPHY_41 VGND VGND VPWR VPWR sky130_fd_sc_hd__decap_3
XPHY_52 VGND VGND VPWR VPWR sky130_fd_sc_hd__decap_3
XPHY_63 VGND VGND VPWR VPWR sky130_fd_sc_hd__decap_3
XPHY_74 VGND VGND VPWR VPWR sky130_fd_sc_hd__decap_3
XFILLER_0_37_700 VGND VGND VPWR VPWR sky130_fd_sc_hd__decap_4
XTAP_1589 VGND VPWR sky130_fd_sc_hd__tapvpwrvgnd_1
XTAP_1578 VGND VPWR sky130_fd_sc_hd__tapvpwrvgnd_1
XPHY_85 VGND VGND VPWR VPWR sky130_fd_sc_hd__decap_3
XPHY_96 VGND VGND VPWR VPWR sky130_fd_sc_hd__decap_3
XFILLER_0_49_582 VGND VGND VPWR VPWR sky130_fd_sc_hd__fill_1
XFILLER_0_64_530 VGND VGND VPWR VPWR sky130_fd_sc_hd__fill_2
XFILLER_0_107_665 VGND VGND VPWR VPWR sky130_fd_sc_hd__decap_6
XFILLER_0_91_393 VGND VGND VPWR VPWR sky130_fd_sc_hd__decap_3
XFILLER_0_20_699 VGND VGND VPWR VPWR sky130_fd_sc_hd__fill_1
XFILLER_0_47_15 VGND VGND VPWR VPWR sky130_fd_sc_hd__fill_1
XFILLER_0_47_48 VGND VGND VPWR VPWR sky130_fd_sc_hd__decap_8
Xclkbuf_leaf_29_clk clknet_3_3__leaf_clk VGND VGND VPWR VPWR clknet_leaf_29_clk sky130_fd_sc_hd__clkbuf_16
X_4860_ u_pe_array.g_pe_row\[2\].g_pe_col\[1\].u_pe.psum_out\[3\] u_pe_array.g_pe_row\[2\].g_pe_col\[1\].u_pe.act_val\[3\]
+ _1867_ VGND VGND VPWR VPWR _1871_ sky130_fd_sc_hd__mux2_1
XFILLER_0_87_666 VGND VGND VPWR VPWR sky130_fd_sc_hd__decap_6
X_3811_ _1058_ _1062_ VGND VGND VPWR VPWR _1064_ sky130_fd_sc_hd__nand2_1
X_6530_ u_pe_array.g_pe_row\[0\].g_pe_col\[1\].u_pe.act_val\[4\] _2268_ VGND VGND
+ VPWR VPWR _3159_ sky130_fd_sc_hd__and2b_1
X_4791_ _1797_ _1799_ _1813_ VGND VGND VPWR VPWR _1814_ sky130_fd_sc_hd__a21oi_1
X_3742_ u_pe_array.g_pe_row\[3\].g_pe_col\[3\].u_pe.psum_out\[2\] _0999_ VGND VGND
+ VPWR VPWR _1000_ sky130_fd_sc_hd__xnor2_1
XFILLER_0_55_585 VPWR VGND VPWR VGND sky130_ef_sc_hd__decap_12
X_6461_ u_pe_array.g_pe_row\[0\].g_pe_col\[1\].u_pe.psum_out\[9\] net436 _3102_ VGND
+ VGND VPWR VPWR _3112_ sky130_fd_sc_hd__mux2_1
X_3673_ u_pe_array.g_pe_row\[3\].g_pe_col\[3\].u_pe.psum_out\[5\] u_pe_array.g_pe_row\[3\].g_pe_col\[3\].u_pe.act_val\[5\]
+ _0947_ VGND VGND VPWR VPWR _0954_ sky130_fd_sc_hd__mux2_1
XFILLER_0_70_533 VGND VGND VPWR VPWR sky130_fd_sc_hd__fill_2
XFILLER_0_42_224 VGND VGND VPWR VPWR sky130_fd_sc_hd__decap_8
X_5412_ u_pe_array.g_pe_row\[1\].g_pe_col\[2\].u_pe.move_reg\[7\] net62 VGND VGND
+ VPWR VPWR _2296_ sky130_fd_sc_hd__or2_1
X_6392_ _3055_ _3059_ _3044_ VGND VGND VPWR VPWR _3060_ sky130_fd_sc_hd__mux2_1
XFILLER_0_30_419 VGND VGND VPWR VPWR sky130_fd_sc_hd__fill_1
X_5343_ _2236_ _2240_ VGND VGND VPWR VPWR _2241_ sky130_fd_sc_hd__or2_1
XFILLER_0_2_354 VGND VGND VPWR VPWR sky130_fd_sc_hd__fill_1
XFILLER_0_2_365 VGND VGND VPWR VPWR sky130_fd_sc_hd__fill_2
XFILLER_0_10_121 VPWR VGND VPWR VGND sky130_ef_sc_hd__decap_12
XFILLER_0_2_398 VPWR VGND VPWR VGND sky130_ef_sc_hd__decap_12
XFILLER_0_50_290 VGND VGND VPWR VPWR sky130_fd_sc_hd__fill_2
X_5274_ u_pe_array.g_pe_row\[1\].g_pe_col\[3\].u_pe.act_val\[1\] _2164_ _2175_ _2176_
+ VGND VGND VPWR VPWR _2178_ sky130_fd_sc_hd__o22a_1
XFILLER_0_10_176 VGND VGND VPWR VPWR sky130_fd_sc_hd__decap_4
X_4225_ _1382_ VGND VGND VPWR VPWR _1383_ sky130_fd_sc_hd__inv_2
X_7013_ _3500_ VGND VGND VPWR VPWR _0815_ sky130_fd_sc_hd__clkbuf_1
X_4156_ u_pe_array.g_pe_row\[3\].g_pe_col\[1\].u_pe.act_val\[2\] u_pe_array.g_pe_row\[3\].g_pe_col\[1\].u_pe.w_out\[0\]
+ VGND VGND VPWR VPWR _1319_ sky130_fd_sc_hd__nand2_1
X_4087_ _1266_ _1270_ _1278_ _1280_ _1277_ VGND VGND VPWR VPWR _1281_ sky130_fd_sc_hd__a32o_1
X_7915_ clknet_leaf_77_clk _0820_ VGND VGND VPWR VPWR u_pe_array.u_fifo1.buffer\[2\]\[5\]
+ sky130_fd_sc_hd__dfxtp_1
XFILLER_0_78_688 VPWR VGND VPWR VGND sky130_ef_sc_hd__decap_12
XFILLER_0_77_154 VGND VGND VPWR VPWR sky130_fd_sc_hd__fill_1
X_7846_ clknet_leaf_98_clk _0751_ VGND VGND VPWR VPWR u_pe_array.u_fifo2.buffer\[1\]\[4\]
+ sky130_fd_sc_hd__dfxtp_1
XFILLER_0_92_124 VGND VGND VPWR VPWR sky130_fd_sc_hd__fill_1
X_4989_ _1954_ _1967_ _1968_ VGND VGND VPWR VPWR _1969_ sky130_fd_sc_hd__a21oi_1
XFILLER_0_93_658 VPWR VGND VPWR VGND sky130_ef_sc_hd__decap_12
XFILLER_0_65_349 VGND VGND VPWR VPWR sky130_fd_sc_hd__fill_1
XFILLER_0_18_243 VGND VGND VPWR VPWR sky130_fd_sc_hd__decap_3
X_7777_ clknet_leaf_90_clk _0683_ net949 VGND VGND VPWR VPWR u_fsm.ch_cnt\[1\] sky130_fd_sc_hd__dfrtp_1
X_6728_ _1092_ _3312_ _3313_ _1005_ net701 VGND VGND VPWR VPWR _0717_ sky130_fd_sc_hd__a32o_1
XFILLER_0_18_276 VPWR VGND VPWR VGND sky130_ef_sc_hd__decap_12
X_6659_ u_pe_array.g_pe_row\[0\].g_pe_col\[0\].u_pe.act_val\[0\] _3246_ _3250_ VGND
+ VGND VPWR VPWR _3251_ sky130_fd_sc_hd__or3b_1
XFILLER_0_61_533 VGND VGND VPWR VPWR sky130_fd_sc_hd__fill_1
XFILLER_0_5_181 VPWR VGND VPWR VGND sky130_ef_sc_hd__decap_12
XFILLER_0_33_279 VGND VGND VPWR VPWR sky130_fd_sc_hd__fill_1
XFILLER_0_104_657 VPWR VGND VPWR VGND sky130_ef_sc_hd__decap_12
XFILLER_0_103_189 VPWR VGND VPWR VGND sky130_ef_sc_hd__decap_12
XTAP_1320 VGND VPWR sky130_fd_sc_hd__tapvpwrvgnd_1
XTAP_1331 VGND VPWR sky130_fd_sc_hd__tapvpwrvgnd_1
XFILLER_0_96_485 VGND VGND VPWR VPWR sky130_fd_sc_hd__decap_4
XTAP_1375 VGND VPWR sky130_fd_sc_hd__tapvpwrvgnd_1
XTAP_1364 VGND VPWR sky130_fd_sc_hd__tapvpwrvgnd_1
XTAP_1353 VGND VPWR sky130_fd_sc_hd__tapvpwrvgnd_1
XTAP_1342 VGND VPWR sky130_fd_sc_hd__tapvpwrvgnd_1
XFILLER_0_56_327 VGND VGND VPWR VPWR sky130_fd_sc_hd__fill_1
XTAP_1397 VGND VPWR sky130_fd_sc_hd__tapvpwrvgnd_1
XTAP_1386 VGND VPWR sky130_fd_sc_hd__tapvpwrvgnd_1
Xinput15 v_in0[0] VGND VGND VPWR VPWR net15 sky130_fd_sc_hd__clkbuf_2
XFILLER_0_64_382 VGND VGND VPWR VPWR sky130_fd_sc_hd__decap_3
Xinput26 v_in1[5] VGND VGND VPWR VPWR net26 sky130_fd_sc_hd__buf_1
XFILLER_0_52_544 VPWR VGND VPWR VGND sky130_ef_sc_hd__decap_12
XFILLER_0_107_495 VGND VGND VPWR VPWR sky130_fd_sc_hd__fill_1
X_4010_ _1210_ _1211_ VGND VGND VPWR VPWR _1212_ sky130_fd_sc_hd__and2_1
XFILLER_0_74_35 VGND VGND VPWR VPWR sky130_fd_sc_hd__fill_1
X_5961_ u_pe_array.u_fifo1.buffer\[3\]\[5\] _2685_ _2686_ u_pe_array.u_fifo1.buffer\[2\]\[5\]
+ _2725_ VGND VGND VPWR VPWR _2726_ sky130_fd_sc_hd__a221o_1
X_4912_ u_pe_array.g_pe_row\[2\].g_pe_col\[1\].u_pe.act_val\[2\] u_pe_array.g_pe_row\[2\].g_pe_col\[1\].u_pe.w_out\[0\]
+ VGND VGND VPWR VPWR _1898_ sky130_fd_sc_hd__nand2_1
X_7700_ clknet_leaf_75_clk _0606_ net949 VGND VGND VPWR VPWR u_pe_array.act_from_up\[6\]\[4\]
+ sky130_fd_sc_hd__dfrtp_1
XFILLER_0_114_41 VPWR VGND VPWR VGND sky130_ef_sc_hd__decap_12
X_5892_ _2639_ net840 _1158_ VGND VGND VPWR VPWR _2672_ sky130_fd_sc_hd__mux2_1
X_7631_ clknet_leaf_72_clk _0537_ net949 VGND VGND VPWR VPWR u_pe_array.g_pe_row\[1\].g_pe_col\[0\].u_pe.act_val\[4\]
+ sky130_fd_sc_hd__dfrtp_1
XFILLER_0_114_85 VPWR VGND VPWR VGND sky130_ef_sc_hd__decap_12
XFILLER_0_90_606 VGND VGND VPWR VPWR sky130_fd_sc_hd__fill_1
XFILLER_0_74_135 VGND VGND VPWR VPWR sky130_fd_sc_hd__decap_4
XFILLER_0_28_541 VGND VGND VPWR VPWR sky130_fd_sc_hd__fill_1
X_4843_ u_pe_array.g_pe_row\[2\].g_pe_col\[2\].u_pe.psum_out\[9\] u_pe_array.g_pe_row\[2\].g_pe_col\[2\].u_pe.psum_out\[10\]
+ _0933_ VGND VGND VPWR VPWR _1860_ sky130_fd_sc_hd__o21a_1
XFILLER_0_117_237 VPWR VGND VPWR VGND sky130_ef_sc_hd__decap_12
X_7562_ clknet_leaf_46_clk _0468_ net947 VGND VGND VPWR VPWR u_pe_array.act_from_down\[1\]\[2\]
+ sky130_fd_sc_hd__dfrtp_1
XFILLER_0_90_617 VGND VGND VPWR VPWR sky130_fd_sc_hd__fill_2
X_4774_ u_pe_array.g_pe_row\[2\].g_pe_col\[2\].u_pe.act_val\[4\] u_pe_array.g_pe_row\[2\].g_pe_col\[2\].u_pe.w_out\[0\]
+ _1784_ VGND VGND VPWR VPWR _1798_ sky130_fd_sc_hd__and3_1
XFILLER_0_7_457 VPWR VGND VPWR VGND sky130_ef_sc_hd__decap_12
XFILLER_0_43_500 VGND VGND VPWR VPWR sky130_fd_sc_hd__decap_4
X_6513_ _3141_ _3143_ VGND VGND VPWR VPWR _3144_ sky130_fd_sc_hd__nor2_1
X_7493_ clknet_leaf_40_clk _0399_ net947 VGND VGND VPWR VPWR u_pe_array.g_pe_row\[1\].g_pe_col\[3\].u_pe.psum_out\[2\]
+ sky130_fd_sc_hd__dfrtp_1
XFILLER_0_15_213 VGND VGND VPWR VPWR sky130_fd_sc_hd__decap_8
X_3725_ _0984_ VGND VGND VPWR VPWR _0985_ sky130_fd_sc_hd__buf_8
XFILLER_0_43_544 VPWR VGND VPWR VGND sky130_ef_sc_hd__decap_12
XFILLER_0_113_410 VGND VGND VPWR VPWR sky130_fd_sc_hd__decap_3
X_6444_ net234 _3101_ _2987_ _3103_ VGND VGND VPWR VPWR _0643_ sky130_fd_sc_hd__a22o_1
Xclkbuf_leaf_9_clk clknet_3_1__leaf_clk VGND VGND VPWR VPWR clknet_leaf_9_clk sky130_fd_sc_hd__clkbuf_16
XFILLER_0_70_385 VGND VGND VPWR VPWR sky130_fd_sc_hd__fill_2
XFILLER_0_3_641 VPWR VGND VPWR VGND sky130_ef_sc_hd__decap_12
X_3656_ _0937_ _0941_ VGND VGND VPWR VPWR _0942_ sky130_fd_sc_hd__nor2_1
XFILLER_0_61_3 VPWR VGND VPWR VGND sky130_ef_sc_hd__decap_12
X_6375_ _3043_ u_pe_array.g_pe_row\[0\].g_pe_col\[2\].u_pe.psum_out\[6\] _2130_ VGND
+ VGND VPWR VPWR _3044_ sky130_fd_sc_hd__nand3_2
XFILLER_0_3_685 VPWR VGND VPWR VGND sky130_ef_sc_hd__decap_12
X_3587_ _0863_ _0887_ _0890_ VGND VGND VPWR VPWR _0891_ sky130_fd_sc_hd__and3_1
X_5326_ _2220_ _2222_ _2218_ VGND VGND VPWR VPWR _2225_ sky130_fd_sc_hd__o21bai_1
XFILLER_0_2_195 VGND VGND VPWR VPWR sky130_fd_sc_hd__fill_1
X_5257_ _2162_ VGND VGND VPWR VPWR _2163_ sky130_fd_sc_hd__inv_2
X_4208_ u_pe_array.g_pe_row\[3\].g_pe_col\[1\].u_pe.act_val\[5\] VGND VGND VPWR VPWR
+ _1367_ sky130_fd_sc_hd__inv_2
X_5188_ net795 _1904_ _2123_ _1726_ VGND VGND VPWR VPWR _0367_ sky130_fd_sc_hd__a22o_1
X_4139_ net121 u_fsm.psum_shift_en _1175_ u_pe_array.g_pe_row\[3\].g_pe_col\[1\].u_pe.move_reg\[7\]
+ VGND VGND VPWR VPWR _0132_ sky130_fd_sc_hd__a22o_1
XFILLER_0_3_93 VPWR VGND VPWR VGND sky130_ef_sc_hd__decap_12
XFILLER_0_65_113 VGND VGND VPWR VPWR sky130_fd_sc_hd__decap_3
X_7829_ clknet_leaf_85_clk _0734_ net948 VGND VGND VPWR VPWR u_pe_array.u_fifo2.rd_ptr\[1\]
+ sky130_fd_sc_hd__dfrtp_4
XFILLER_0_19_541 VGND VGND VPWR VPWR sky130_fd_sc_hd__decap_8
XFILLER_0_81_617 VGND VGND VPWR VPWR sky130_fd_sc_hd__decap_6
XFILLER_0_80_149 VPWR VGND VPWR VGND sky130_ef_sc_hd__decap_12
XFILLER_0_74_691 VGND VGND VPWR VPWR sky130_fd_sc_hd__decap_4
XFILLER_0_34_533 VPWR VGND VPWR VGND sky130_ef_sc_hd__decap_12
XFILLER_0_104_421 VPWR VGND VPWR VGND sky130_ef_sc_hd__decap_12
XFILLER_0_21_249 VGND VGND VPWR VPWR sky130_fd_sc_hd__decap_8
XTAP_1150 VGND VPWR sky130_fd_sc_hd__tapvpwrvgnd_1
XTAP_1183 VGND VPWR sky130_fd_sc_hd__tapvpwrvgnd_1
XTAP_1161 VGND VPWR sky130_fd_sc_hd__tapvpwrvgnd_1
XTAP_1172 VGND VPWR sky130_fd_sc_hd__tapvpwrvgnd_1
Xclkbuf_3_4__f_clk clknet_0_clk VGND VGND VPWR VPWR clknet_3_4__leaf_clk sky130_fd_sc_hd__clkbuf_16
XFILLER_0_84_477 VGND VGND VPWR VPWR sky130_fd_sc_hd__fill_1
XTAP_1194 VGND VPWR sky130_fd_sc_hd__tapvpwrvgnd_1
XFILLER_0_80_650 VGND VGND VPWR VPWR sky130_fd_sc_hd__decap_8
XFILLER_0_8_27 VGND VGND VPWR VPWR sky130_fd_sc_hd__fill_1
XFILLER_0_25_555 VGND VGND VPWR VPWR sky130_fd_sc_hd__decap_4
XFILLER_0_25_566 VGND VGND VPWR VPWR sky130_fd_sc_hd__fill_1
XFILLER_0_52_363 VGND VGND VPWR VPWR sky130_fd_sc_hd__fill_1
XFILLER_0_80_683 VGND VGND VPWR VPWR sky130_fd_sc_hd__decap_4
XFILLER_0_69_24 VGND VGND VPWR VPWR sky130_fd_sc_hd__decap_6
Xhold618 u_pe_array.u_fifo2.buffer\[7\]\[3\] VGND VGND VPWR VPWR net692 sky130_fd_sc_hd__dlygate4sd3_1
X_4490_ _1581_ _1583_ _1588_ VGND VGND VPWR VPWR _1590_ sky130_fd_sc_hd__or3_1
Xhold607 u_pe_array.g_pe_row\[1\].g_pe_col\[2\].u_pe.psum_out\[9\] VGND VGND VPWR
+ VPWR net681 sky130_fd_sc_hd__dlygate4sd3_1
XFILLER_0_52_374 VGND VGND VPWR VPWR sky130_fd_sc_hd__fill_1
XFILLER_0_110_424 VGND VGND VPWR VPWR sky130_fd_sc_hd__decap_8
XFILLER_0_100_65 VPWR VGND VPWR VGND sky130_ef_sc_hd__decap_12
XFILLER_0_69_79 VGND VGND VPWR VPWR sky130_fd_sc_hd__decap_4
XFILLER_0_12_249 VGND VGND VPWR VPWR sky130_fd_sc_hd__decap_3
Xhold629 u_pe_array.u_fifo2.buffer\[4\]\[4\] VGND VGND VPWR VPWR net703 sky130_fd_sc_hd__dlygate4sd3_1
X_6160_ _2872_ _2873_ VGND VGND VPWR VPWR _2874_ sky130_fd_sc_hd__xnor2_1
XTAP_901 VGND VPWR sky130_fd_sc_hd__tapvpwrvgnd_1
X_5111_ _2049_ _2053_ VGND VGND VPWR VPWR _2054_ sky130_fd_sc_hd__xnor2_1
XTAP_934 VGND VPWR sky130_fd_sc_hd__tapvpwrvgnd_1
XTAP_912 VGND VPWR sky130_fd_sc_hd__tapvpwrvgnd_1
XTAP_923 VGND VPWR sky130_fd_sc_hd__tapvpwrvgnd_1
XFILLER_0_85_45 VGND VGND VPWR VPWR sky130_fd_sc_hd__decap_8
XTAP_978 VGND VPWR sky130_fd_sc_hd__tapvpwrvgnd_1
XTAP_967 VGND VPWR sky130_fd_sc_hd__tapvpwrvgnd_1
XTAP_956 VGND VPWR sky130_fd_sc_hd__tapvpwrvgnd_1
X_6091_ _2828_ _2830_ _2835_ VGND VGND VPWR VPWR _2837_ sky130_fd_sc_hd__or3_1
XTAP_945 VGND VPWR sky130_fd_sc_hd__tapvpwrvgnd_1
XFILLER_0_0_699 VGND VGND VPWR VPWR sky130_fd_sc_hd__fill_1
X_5042_ net198 _2006_ _1735_ _2008_ VGND VGND VPWR VPWR _0336_ sky130_fd_sc_hd__a22o_1
XTAP_989 VGND VPWR sky130_fd_sc_hd__tapvpwrvgnd_1
XFILLER_0_18_61 VGND VGND VPWR VPWR sky130_fd_sc_hd__fill_2
X_6993_ net552 _3360_ _3484_ VGND VGND VPWR VPWR _3489_ sky130_fd_sc_hd__mux2_1
XFILLER_0_75_400 VPWR VGND VPWR VGND sky130_ef_sc_hd__decap_12
X_5944_ u_pe_array.u_fifo1.buffer\[5\]\[3\] _2687_ _2688_ u_pe_array.u_fifo1.buffer\[6\]\[3\]
+ _2689_ VGND VGND VPWR VPWR _2711_ sky130_fd_sc_hd__a221o_1
X_5875_ u_pe_array.g_pe_row\[1\].g_pe_col\[0\].u_pe.psum_out\[10\] _1112_ _1109_ _2660_
+ VGND VGND VPWR VPWR _2661_ sky130_fd_sc_hd__o211a_2
XFILLER_0_90_414 VGND VGND VPWR VPWR sky130_fd_sc_hd__decap_6
X_4826_ u_pe_array.g_pe_row\[2\].g_pe_col\[2\].u_pe.psum_out\[7\] u_pe_array.g_pe_row\[2\].g_pe_col\[2\].u_pe.psum_out\[8\]
+ _0933_ VGND VGND VPWR VPWR _1845_ sky130_fd_sc_hd__o21a_1
X_7614_ clknet_leaf_95_clk _0520_ net951 VGND VGND VPWR VPWR u_pe_array.act_from_left\[5\]\[0\]
+ sky130_fd_sc_hd__dfrtp_1
XFILLER_0_75_499 VGND VGND VPWR VPWR sky130_fd_sc_hd__decap_4
XFILLER_0_16_533 VPWR VGND VPWR VGND sky130_ef_sc_hd__decap_12
X_7545_ clknet_leaf_91_clk _0451_ net949 VGND VGND VPWR VPWR u_pe_array.g_pe_row\[1\].g_pe_col\[2\].u_pe.psum_out\[0\]
+ sky130_fd_sc_hd__dfrtp_1
X_4757_ net858 _1273_ _1782_ _1726_ VGND VGND VPWR VPWR _0277_ sky130_fd_sc_hd__a22o_1
XFILLER_0_50_81 VGND VGND VPWR VPWR sky130_fd_sc_hd__decap_3
X_3708_ _0972_ VGND VGND VPWR VPWR _0038_ sky130_fd_sc_hd__clkbuf_1
X_7476_ clknet_leaf_42_clk _0382_ net946 VGND VGND VPWR VPWR u_pe_array.act_from_down\[3\]\[11\]
+ sky130_fd_sc_hd__dfrtp_1
XFILLER_0_70_171 VPWR VGND VPWR VGND sky130_ef_sc_hd__decap_12
X_4688_ net637 _1732_ _1735_ _1739_ VGND VGND VPWR VPWR _0251_ sky130_fd_sc_hd__a22o_1
X_3639_ u_pe_array.act_from_up\[14\]\[5\] _0869_ _0854_ VGND VGND VPWR VPWR _0928_
+ sky130_fd_sc_hd__and3_2
X_6427_ _2130_ u_pe_array.g_pe_row\[0\].g_pe_col\[2\].u_pe.psum_out\[11\] VGND VGND
+ VPWR VPWR _3091_ sky130_fd_sc_hd__and2b_1
X_6358_ _3027_ _3028_ VGND VGND VPWR VPWR _3029_ sky130_fd_sc_hd__or2_1
X_5309_ _2208_ _2209_ VGND VGND VPWR VPWR _2210_ sky130_fd_sc_hd__or2_1
X_6289_ u_pe_array.g_pe_row\[0\].g_pe_col\[2\].u_pe.psum_out\[8\] u_pe_array.g_pe_row\[0\].g_pe_col\[2\].u_pe.move_reg\[8\]
+ _2844_ VGND VGND VPWR VPWR _2982_ sky130_fd_sc_hd__mux2_1
XPHY_200 VGND VGND VPWR VPWR sky130_fd_sc_hd__decap_3
XPHY_233 VGND VGND VPWR VPWR sky130_fd_sc_hd__decap_3
XPHY_222 VGND VGND VPWR VPWR sky130_fd_sc_hd__decap_3
XPHY_211 VGND VGND VPWR VPWR sky130_fd_sc_hd__decap_3
XFILLER_0_38_124 VPWR VGND VPWR VGND sky130_ef_sc_hd__decap_12
XFILLER_0_34_363 VGND VGND VPWR VPWR sky130_fd_sc_hd__fill_1
XFILLER_0_22_569 VGND VGND VPWR VPWR sky130_fd_sc_hd__decap_4
Xhold4 _0347_ VGND VGND VPWR VPWR net78 sky130_fd_sc_hd__dlygate4sd3_1
XFILLER_0_55_37 VGND VGND VPWR VPWR sky130_fd_sc_hd__decap_4
XFILLER_0_89_558 VGND VGND VPWR VPWR sky130_fd_sc_hd__fill_2
XFILLER_0_71_47 VGND VGND VPWR VPWR sky130_fd_sc_hd__decap_8
XFILLER_0_69_260 VGND VGND VPWR VPWR sky130_fd_sc_hd__fill_2
X_3990_ u_pe_array.g_pe_row\[3\].g_pe_col\[2\].u_pe.act_val\[2\] u_pe_array.g_pe_row\[3\].g_pe_col\[2\].u_pe.w_out\[0\]
+ _1186_ VGND VGND VPWR VPWR _1193_ sky130_fd_sc_hd__and3_1
XFILLER_0_97_591 VGND VGND VPWR VPWR sky130_fd_sc_hd__fill_1
XFILLER_0_29_113 VPWR VGND VPWR VGND sky130_ef_sc_hd__decap_12
XFILLER_0_29_146 VGND VGND VPWR VPWR sky130_fd_sc_hd__decap_8
X_5660_ u_pe_array.g_pe_row\[1\].g_pe_col\[1\].u_pe.psum_out\[3\] u_pe_array.g_pe_row\[1\].g_pe_col\[1\].u_pe.act_val\[3\]
+ _2133_ VGND VGND VPWR VPWR _2494_ sky130_fd_sc_hd__mux2_1
XFILLER_0_45_617 VGND VGND VPWR VPWR sky130_fd_sc_hd__decap_4
XFILLER_0_115_505 VPWR VGND VPWR VGND sky130_ef_sc_hd__decap_12
XFILLER_0_72_425 VGND VGND VPWR VPWR sky130_fd_sc_hd__fill_1
X_4611_ _1671_ _1672_ _1674_ VGND VGND VPWR VPWR _1675_ sky130_fd_sc_hd__and3_1
X_5591_ _2435_ _2436_ VGND VGND VPWR VPWR _2437_ sky130_fd_sc_hd__or2b_1
X_4542_ net337 _1310_ _1483_ u_pe_array.g_pe_row\[2\].g_pe_col\[3\].u_pe.move_reg\[10\]
+ VGND VGND VPWR VPWR _0230_ sky130_fd_sc_hd__a22o_1
X_7330_ clknet_leaf_2_clk _0236_ net69 VGND VGND VPWR VPWR u_pe_array.g_pe_row\[2\].g_pe_col\[3\].u_pe.psum_out\[3\]
+ sky130_fd_sc_hd__dfrtp_1
Xhold426 u_pe_array.g_pe_row\[2\].g_pe_col\[1\].u_pe.psum_out\[0\] VGND VGND VPWR
+ VPWR net500 sky130_fd_sc_hd__dlygate4sd3_1
Xhold415 u_pe_array.g_pe_row\[1\].g_pe_col\[3\].u_pe.move_reg\[12\] VGND VGND VPWR
+ VPWR net489 sky130_fd_sc_hd__dlygate4sd3_1
Xhold404 u_pe_array.act_from_up\[12\]\[10\] VGND VGND VPWR VPWR net478 sky130_fd_sc_hd__dlygate4sd3_1
X_7261_ clknet_leaf_17_clk _0167_ net943 VGND VGND VPWR VPWR u_pe_array.act_from_left\[13\]\[1\]
+ sky130_fd_sc_hd__dfrtp_1
XFILLER_0_13_569 VGND VGND VPWR VPWR sky130_fd_sc_hd__fill_1
XFILLER_0_20_95 VPWR VGND VPWR VGND sky130_ef_sc_hd__decap_12
X_4473_ _1565_ _1568_ _1573_ VGND VGND VPWR VPWR _1575_ sky130_fd_sc_hd__or3_1
Xhold448 u_pe_array.g_pe_row\[0\].g_pe_col\[0\].u_pe.psum_out\[0\] VGND VGND VPWR
+ VPWR net522 sky130_fd_sc_hd__dlygate4sd3_1
X_6212_ _2906_ _2908_ _2921_ VGND VGND VPWR VPWR _2922_ sky130_fd_sc_hd__a21oi_1
Xhold437 u_pe_array.act_from_up\[14\]\[5\] VGND VGND VPWR VPWR net511 sky130_fd_sc_hd__dlygate4sd3_1
Xhold459 _0546_ VGND VGND VPWR VPWR net533 sky130_fd_sc_hd__dlygate4sd3_1
XFILLER_0_21_591 VGND VGND VPWR VPWR sky130_fd_sc_hd__decap_4
X_7192_ clknet_leaf_104_clk _0098_ net944 VGND VGND VPWR VPWR u_pe_array.g_pe_row\[3\].g_pe_col\[2\].u_pe.psum_out\[1\]
+ sky130_fd_sc_hd__dfrtp_1
X_6143_ net147 _2730_ _2511_ u_pe_array.g_pe_row\[0\].g_pe_col\[3\].u_pe.move_reg\[12\]
+ VGND VGND VPWR VPWR _0586_ sky130_fd_sc_hd__a22o_1
XTAP_720 VGND VPWR sky130_fd_sc_hd__tapvpwrvgnd_1
XTAP_731 VGND VPWR sky130_fd_sc_hd__tapvpwrvgnd_1
XTAP_742 VGND VPWR sky130_fd_sc_hd__tapvpwrvgnd_1
X_6074_ _2812_ _2815_ _2820_ VGND VGND VPWR VPWR _2822_ sky130_fd_sc_hd__or3_1
XTAP_753 VGND VPWR sky130_fd_sc_hd__tapvpwrvgnd_1
XTAP_764 VGND VPWR sky130_fd_sc_hd__tapvpwrvgnd_1
XTAP_775 VGND VPWR sky130_fd_sc_hd__tapvpwrvgnd_1
XTAP_786 VGND VPWR sky130_fd_sc_hd__tapvpwrvgnd_1
X_5025_ u_pe_array.g_pe_row\[0\].g_pe_col\[3\].u_pe.w_out\[1\] VGND VGND VPWR VPWR
+ _1999_ sky130_fd_sc_hd__clkbuf_8
XTAP_797 VGND VPWR sky130_fd_sc_hd__tapvpwrvgnd_1
XFILLER_0_24_3 VGND VGND VPWR VPWR sky130_fd_sc_hd__decap_8
XFILLER_0_95_517 VGND VGND VPWR VPWR sky130_fd_sc_hd__decap_4
X_6976_ u_pe_array.u_fifo1.count\[2\] _3474_ _3477_ u_pe_array.u_fifo1.count\[0\]
+ VGND VGND VPWR VPWR _3478_ sky130_fd_sc_hd__o211ai_2
X_5927_ u_pe_array.u_fifo1.buffer\[7\]\[1\] _2681_ _2683_ u_pe_array.u_fifo1.buffer\[1\]\[1\]
+ VGND VGND VPWR VPWR _2696_ sky130_fd_sc_hd__a22o_1
XFILLER_0_0_83 VGND VGND VPWR VPWR sky130_fd_sc_hd__fill_1
XFILLER_0_48_455 VPWR VGND VPWR VGND sky130_ef_sc_hd__decap_12
XFILLER_0_48_477 VGND VGND VPWR VPWR sky130_fd_sc_hd__decap_4
XFILLER_0_118_365 VGND VGND VPWR VPWR sky130_fd_sc_hd__decap_8
XFILLER_0_90_233 VGND VGND VPWR VPWR sky130_fd_sc_hd__fill_1
X_5858_ u_pe_array.g_pe_row\[1\].g_pe_col\[0\].u_pe.move_reg\[6\] net62 VGND VGND
+ VPWR VPWR _2648_ sky130_fd_sc_hd__or2_1
XFILLER_0_63_447 VGND VGND VPWR VPWR sky130_fd_sc_hd__fill_1
XFILLER_0_61_80 VPWR VGND VPWR VGND sky130_ef_sc_hd__decap_12
X_5789_ u_pe_array.g_pe_row\[1\].g_pe_col\[1\].u_pe.psum_out\[8\] _1728_ VGND VGND
+ VPWR VPWR _2592_ sky130_fd_sc_hd__nand2_1
XFILLER_0_8_596 VGND VGND VPWR VPWR sky130_fd_sc_hd__fill_1
X_4809_ _1829_ _1805_ _1818_ _1822_ VGND VGND VPWR VPWR _1830_ sky130_fd_sc_hd__a22o_1
XFILLER_0_51_609 VGND VGND VPWR VPWR sky130_fd_sc_hd__decap_6
X_7528_ clknet_leaf_67_clk _0434_ net946 VGND VGND VPWR VPWR u_pe_array.act_from_left\[7\]\[9\]
+ sky130_fd_sc_hd__dfrtp_1
X_7459_ clknet_leaf_31_clk _0365_ net71 VGND VGND VPWR VPWR u_pe_array.g_pe_row\[2\].g_pe_col\[0\].u_pe.psum_out\[9\]
+ sky130_fd_sc_hd__dfrtp_2
XFILLER_0_9_81 VPWR VGND VPWR VGND sky130_ef_sc_hd__decap_12
XFILLER_0_98_322 VGND VGND VPWR VPWR sky130_fd_sc_hd__fill_1
XFILLER_0_41_17 VPWR VGND VPWR VGND sky130_ef_sc_hd__decap_12
XFILLER_0_109_365 VGND VGND VPWR VPWR sky130_fd_sc_hd__fill_1
XFILLER_0_26_138 VGND VGND VPWR VPWR sky130_fd_sc_hd__fill_2
XFILLER_0_1_205 VPWR VGND VPWR VGND sky130_ef_sc_hd__decap_12
XFILLER_0_105_593 VGND VGND VPWR VPWR sky130_fd_sc_hd__decap_8
XFILLER_0_1_249 VGND VGND VPWR VPWR sky130_fd_sc_hd__decap_6
XFILLER_0_5_39 VPWR VGND VPWR VGND sky130_ef_sc_hd__decap_12
XFILLER_0_106_53 VPWR VGND VPWR VGND sky130_ef_sc_hd__decap_12
XFILLER_0_82_79 VGND VGND VPWR VPWR sky130_fd_sc_hd__fill_2
X_6830_ _0916_ _3391_ VGND VGND VPWR VPWR _3392_ sky130_fd_sc_hd__nor2b_2
XFILLER_0_106_97 VPWR VGND VPWR VGND sky130_ef_sc_hd__decap_12
X_6761_ net724 _0986_ _3342_ _0978_ VGND VGND VPWR VPWR _0721_ sky130_fd_sc_hd__a22o_1
XFILLER_0_57_230 VGND VGND VPWR VPWR sky130_fd_sc_hd__decap_8
XFILLER_0_9_316 VGND VGND VPWR VPWR sky130_fd_sc_hd__fill_1
XFILLER_0_15_51 VGND VGND VPWR VPWR sky130_fd_sc_hd__decap_4
X_5712_ _2513_ _2517_ VGND VGND VPWR VPWR _2521_ sky130_fd_sc_hd__nand2_1
XFILLER_0_85_550 VGND VGND VPWR VPWR sky130_fd_sc_hd__decap_8
XFILLER_0_57_252 VGND VGND VPWR VPWR sky130_fd_sc_hd__fill_2
X_3973_ u_pe_array.g_pe_row\[3\].g_pe_col\[2\].u_pe.act_val\[0\] _0934_ u_pe_array.g_pe_row\[3\].g_pe_col\[2\].u_pe.psum_out\[1\]
+ VGND VGND VPWR VPWR _1178_ sky130_fd_sc_hd__a21oi_1
X_6692_ _3266_ _3267_ VGND VGND VPWR VPWR _3281_ sky130_fd_sc_hd__and2b_1
XFILLER_0_31_61 VGND VGND VPWR VPWR sky130_fd_sc_hd__fill_1
X_5643_ _2469_ _2473_ _2480_ _2482_ _2479_ VGND VGND VPWR VPWR _2483_ sky130_fd_sc_hd__a32o_1
XFILLER_0_115_357 VGND VGND VPWR VPWR sky130_fd_sc_hd__decap_3
XFILLER_0_115_335 VGND VGND VPWR VPWR sky130_fd_sc_hd__fill_1
XFILLER_0_5_555 VGND VGND VPWR VPWR sky130_fd_sc_hd__decap_4
XFILLER_0_26_661 VGND VGND VPWR VPWR sky130_fd_sc_hd__fill_1
X_5574_ u_pe_array.g_pe_row\[1\].g_pe_col\[2\].u_pe.act_val\[4\] _1595_ _2412_ VGND
+ VGND VPWR VPWR _2421_ sky130_fd_sc_hd__and3_1
XFILLER_0_115_368 VGND VGND VPWR VPWR sky130_fd_sc_hd__fill_2
X_4525_ _0943_ VGND VGND VPWR VPWR _1611_ sky130_fd_sc_hd__buf_8
Xhold201 u_pe_array.act_from_up\[4\]\[5\] VGND VGND VPWR VPWR net275 sky130_fd_sc_hd__dlygate4sd3_1
X_7313_ clknet_leaf_6_clk _0219_ net945 VGND VGND VPWR VPWR u_pe_array.act_from_right\[10\]\[12\]
+ sky130_fd_sc_hd__dfrtp_1
Xhold223 u_pe_array.g_pe_row\[1\].g_pe_col\[0\].u_pe.move_reg\[6\] VGND VGND VPWR
+ VPWR net297 sky130_fd_sc_hd__dlygate4sd3_1
Xhold234 u_pe_array.g_pe_row\[0\].g_pe_col\[2\].u_pe.move_reg\[9\] VGND VGND VPWR
+ VPWR net308 sky130_fd_sc_hd__dlygate4sd3_1
Xhold212 _0226_ VGND VGND VPWR VPWR net286 sky130_fd_sc_hd__dlygate4sd3_1
XFILLER_0_40_141 VGND VGND VPWR VPWR sky130_fd_sc_hd__decap_8
Xhold245 u_pe_array.act_from_right\[0\]\[3\] VGND VGND VPWR VPWR net319 sky130_fd_sc_hd__dlygate4sd3_1
Xhold267 _0302_ VGND VGND VPWR VPWR net341 sky130_fd_sc_hd__dlygate4sd3_1
X_7244_ clknet_leaf_14_clk _0150_ net942 VGND VGND VPWR VPWR u_pe_array.g_pe_row\[3\].g_pe_col\[1\].u_pe.psum_out\[12\]
+ sky130_fd_sc_hd__dfrtp_1
XFILLER_0_13_388 VGND VGND VPWR VPWR sky130_fd_sc_hd__decap_4
Xhold278 u_pe_array.g_pe_row\[2\].g_pe_col\[3\].u_pe.psum_out\[1\] VGND VGND VPWR
+ VPWR net352 sky130_fd_sc_hd__dlygate4sd3_1
Xhold256 u_pe_array.act_from_up\[6\]\[3\] VGND VGND VPWR VPWR net330 sky130_fd_sc_hd__dlygate4sd3_1
X_4456_ _1542_ _1543_ _1557_ _1558_ VGND VGND VPWR VPWR _1559_ sky130_fd_sc_hd__a31o_1
Xhold289 _0187_ VGND VGND VPWR VPWR net363 sky130_fd_sc_hd__dlygate4sd3_1
X_4387_ u_pe_array.g_pe_row\[3\].g_pe_col\[0\].u_pe.act_val\[0\] _1488_ _1287_ VGND
+ VGND VPWR VPWR _1496_ sky130_fd_sc_hd__a21bo_1
X_7175_ clknet_leaf_8_clk _0081_ net945 VGND VGND VPWR VPWR u_pe_array.act_from_left\[15\]\[10\]
+ sky130_fd_sc_hd__dfrtp_1
X_6126_ net407 _2853_ _2847_ _2857_ VGND VGND VPWR VPWR _0571_ sky130_fd_sc_hd__a22o_1
XTAP_550 VGND VPWR sky130_fd_sc_hd__tapvpwrvgnd_1
XTAP_561 VGND VPWR sky130_fd_sc_hd__tapvpwrvgnd_1
XTAP_572 VGND VPWR sky130_fd_sc_hd__tapvpwrvgnd_1
XTAP_594 VGND VPWR sky130_fd_sc_hd__tapvpwrvgnd_1
XTAP_583 VGND VPWR sky130_fd_sc_hd__tapvpwrvgnd_1
X_6057_ _2788_ _2789_ _2804_ _2805_ VGND VGND VPWR VPWR _2806_ sky130_fd_sc_hd__a31o_1
X_5008_ _1980_ _1985_ VGND VGND VPWR VPWR _1986_ sky130_fd_sc_hd__and2_1
XTAP_1705 VGND VPWR sky130_fd_sc_hd__tapvpwrvgnd_1
XTAP_1749 VGND VPWR sky130_fd_sc_hd__tapvpwrvgnd_1
XTAP_1738 VGND VPWR sky130_fd_sc_hd__tapvpwrvgnd_1
XTAP_1727 VGND VPWR sky130_fd_sc_hd__tapvpwrvgnd_1
XTAP_1716 VGND VPWR sky130_fd_sc_hd__tapvpwrvgnd_1
XFILLER_0_64_701 VGND VGND VPWR VPWR sky130_fd_sc_hd__decap_4
X_6959_ u_pe_array.u_fifo1.rd_ptr\[1\] u_pe_array.u_fifo1.rd_ptr\[0\] _3463_ VGND
+ VGND VPWR VPWR _3466_ sky130_fd_sc_hd__and3_1
XFILLER_0_36_425 VGND VGND VPWR VPWR sky130_fd_sc_hd__fill_1
XFILLER_0_36_436 VGND VGND VPWR VPWR sky130_fd_sc_hd__decap_3
XFILLER_0_106_335 VGND VGND VPWR VPWR sky130_fd_sc_hd__decap_6
XFILLER_0_23_108 VGND VGND VPWR VPWR sky130_fd_sc_hd__decap_4
XFILLER_0_51_417 VGND VGND VPWR VPWR sky130_fd_sc_hd__fill_2
Xhold790 u_pe_array.act_from_right\[5\]\[1\] VGND VGND VPWR VPWR net864 sky130_fd_sc_hd__dlygate4sd3_1
XFILLER_0_98_130 VGND VGND VPWR VPWR sky130_fd_sc_hd__decap_8
XFILLER_0_99_697 VGND VGND VPWR VPWR sky130_fd_sc_hd__decap_4
XFILLER_0_67_561 VGND VGND VPWR VPWR sky130_fd_sc_hd__fill_2
XFILLER_0_55_701 VGND VGND VPWR VPWR sky130_fd_sc_hd__decap_4
XFILLER_0_39_230 VPWR VGND VPWR VGND sky130_ef_sc_hd__decap_12
XFILLER_0_67_583 VGND VGND VPWR VPWR sky130_fd_sc_hd__decap_4
XFILLER_0_70_704 VGND VGND VPWR VPWR sky130_fd_sc_hd__fill_1
XFILLER_0_54_277 VGND VGND VPWR VPWR sky130_fd_sc_hd__decap_4
XFILLER_0_14_119 VGND VGND VPWR VPWR sky130_fd_sc_hd__decap_8
XFILLER_0_2_525 VGND VGND VPWR VPWR sky130_fd_sc_hd__decap_6
XFILLER_0_22_130 VGND VGND VPWR VPWR sky130_fd_sc_hd__decap_8
XFILLER_0_22_141 VGND VGND VPWR VPWR sky130_fd_sc_hd__decap_8
X_5290_ _2191_ _2192_ net581 _1006_ VGND VGND VPWR VPWR _0400_ sky130_fd_sc_hd__a2bb2o_1
X_4310_ u_pe_array.g_pe_row\[3\].g_pe_col\[0\].u_pe.psum_out\[7\] _1108_ _1110_ _1452_
+ VGND VGND VPWR VPWR _1453_ sky130_fd_sc_hd__o211a_2
XFILLER_0_2_569 VPWR VGND VPWR VGND sky130_ef_sc_hd__decap_12
XFILLER_0_23_697 VGND VGND VPWR VPWR sky130_fd_sc_hd__fill_2
X_4241_ _1388_ _1391_ _1396_ _1003_ VGND VGND VPWR VPWR _1398_ sky130_fd_sc_hd__a31o_1
XFILLER_0_10_347 VGND VGND VPWR VPWR sky130_fd_sc_hd__fill_1
X_4172_ _1332_ _1333_ VGND VGND VPWR VPWR _1334_ sky130_fd_sc_hd__nor2_1
XFILLER_0_89_141 VGND VGND VPWR VPWR sky130_fd_sc_hd__decap_6
X_7931_ clknet_leaf_78_clk _0836_ VGND VGND VPWR VPWR u_pe_array.u_fifo1.buffer\[5\]\[3\]
+ sky130_fd_sc_hd__dfxtp_1
X_7862_ clknet_leaf_86_clk _0767_ VGND VGND VPWR VPWR u_pe_array.u_fifo2.buffer\[4\]\[2\]
+ sky130_fd_sc_hd__dfxtp_1
X_7793_ clknet_leaf_55_clk net280 net74 VGND VGND VPWR VPWR u_pe_array.g_pe_row\[0\].g_pe_col\[0\].u_pe.act_val\[1\]
+ sky130_fd_sc_hd__dfrtp_2
XFILLER_0_77_358 VGND VGND VPWR VPWR sky130_fd_sc_hd__decap_8
XFILLER_0_58_561 VGND VGND VPWR VPWR sky130_fd_sc_hd__decap_3
XFILLER_0_58_550 VGND VGND VPWR VPWR sky130_fd_sc_hd__decap_3
X_6813_ _0915_ _3371_ VGND VGND VPWR VPWR _3379_ sky130_fd_sc_hd__or2_2
XFILLER_0_9_113 VPWR VGND VPWR VGND sky130_ef_sc_hd__decap_12
XFILLER_0_46_701 VGND VGND VPWR VPWR sky130_fd_sc_hd__decap_4
X_6744_ _3323_ _3327_ VGND VGND VPWR VPWR _3328_ sky130_fd_sc_hd__xnor2_1
X_3956_ net24 u_pe_array.act_from_up\[14\]\[3\] _0857_ VGND VGND VPWR VPWR _1172_
+ sky130_fd_sc_hd__mux2_1
XFILLER_0_45_211 VGND VGND VPWR VPWR sky130_fd_sc_hd__decap_4
X_6675_ u_pe_array.g_pe_row\[0\].g_pe_col\[0\].u_pe.act_val\[3\] _2486_ u_pe_array.g_pe_row\[0\].g_pe_col\[0\].u_pe.psum_out\[3\]
+ VGND VGND VPWR VPWR _3265_ sky130_fd_sc_hd__a21oi_1
XFILLER_0_61_704 VGND VGND VPWR VPWR sky130_fd_sc_hd__fill_1
XFILLER_0_91_3 VPWR VGND VPWR VGND sky130_ef_sc_hd__decap_12
XFILLER_0_60_214 VGND VGND VPWR VPWR sky130_fd_sc_hd__fill_1
X_3887_ net872 _1128_ _1116_ VGND VGND VPWR VPWR _1129_ sky130_fd_sc_hd__mux2_1
XFILLER_0_33_417 VGND VGND VPWR VPWR sky130_fd_sc_hd__decap_3
X_5626_ u_pe_array.g_pe_row\[1\].g_pe_col\[2\].u_pe.psum_out\[7\] u_pe_array.g_pe_row\[1\].g_pe_col\[2\].u_pe.psum_out\[8\]
+ _1597_ VGND VGND VPWR VPWR _2468_ sky130_fd_sc_hd__o21a_1
XFILLER_0_116_699 VGND VGND VPWR VPWR sky130_fd_sc_hd__fill_1
XFILLER_0_26_480 VPWR VGND VPWR VGND sky130_ef_sc_hd__decap_12
XFILLER_0_103_349 VPWR VGND VPWR VGND sky130_ef_sc_hd__decap_12
XFILLER_0_14_664 VPWR VGND VPWR VGND sky130_ef_sc_hd__decap_12
X_5557_ _2392_ _2393_ _2405_ VGND VGND VPWR VPWR _2406_ sky130_fd_sc_hd__o21a_1
X_5488_ u_pe_array.u_fifo2.buffer\[0\]\[2\] _2324_ VGND VGND VPWR VPWR _2351_ sky130_fd_sc_hd__or2_1
X_4508_ u_pe_array.g_pe_row\[2\].g_pe_col\[3\].u_pe.psum_out\[2\] u_pe_array.g_pe_row\[2\].g_pe_col\[3\].u_pe.act_val\[2\]
+ _1599_ VGND VGND VPWR VPWR _1602_ sky130_fd_sc_hd__mux2_1
XFILLER_0_111_360 VPWR VGND VPWR VGND sky130_ef_sc_hd__decap_12
X_7227_ clknet_leaf_8_clk net348 net950 VGND VGND VPWR VPWR u_pe_array.g_pe_row\[3\].g_pe_col\[1\].u_pe.move_reg\[8\]
+ sky130_fd_sc_hd__dfrtp_1
X_4439_ _1520_ _1521_ _1530_ _1532_ VGND VGND VPWR VPWR _1544_ sky130_fd_sc_hd__o22a_1
XFILLER_0_111_393 VGND VGND VPWR VPWR sky130_fd_sc_hd__decap_4
X_7158_ clknet_leaf_8_clk _0064_ net945 VGND VGND VPWR VPWR u_pe_array.act_from_right\[13\]\[6\]
+ sky130_fd_sc_hd__dfrtp_1
X_6109_ net218 _2499_ _2847_ _2848_ VGND VGND VPWR VPWR _0563_ sky130_fd_sc_hd__a22o_1
XTAP_391 VGND VPWR sky130_fd_sc_hd__tapvpwrvgnd_1
XTAP_380 VGND VPWR sky130_fd_sc_hd__tapvpwrvgnd_1
X_7089_ net595 _3362_ _3536_ VGND VGND VPWR VPWR _3542_ sky130_fd_sc_hd__mux2_1
XFILLER_0_96_601 VGND VGND VPWR VPWR sky130_fd_sc_hd__fill_2
XTAP_1524 VGND VPWR sky130_fd_sc_hd__tapvpwrvgnd_1
XTAP_1513 VGND VPWR sky130_fd_sc_hd__tapvpwrvgnd_1
XTAP_1502 VGND VPWR sky130_fd_sc_hd__tapvpwrvgnd_1
XFILLER_0_95_111 VGND VGND VPWR VPWR sky130_fd_sc_hd__fill_1
XPHY_20 VGND VGND VPWR VPWR sky130_fd_sc_hd__decap_3
XPHY_31 VGND VGND VPWR VPWR sky130_fd_sc_hd__decap_3
XTAP_1557 VGND VPWR sky130_fd_sc_hd__tapvpwrvgnd_1
XTAP_1546 VGND VPWR sky130_fd_sc_hd__tapvpwrvgnd_1
XTAP_1535 VGND VPWR sky130_fd_sc_hd__tapvpwrvgnd_1
XPHY_42 VGND VGND VPWR VPWR sky130_fd_sc_hd__decap_3
XPHY_53 VGND VGND VPWR VPWR sky130_fd_sc_hd__decap_3
XPHY_64 VGND VGND VPWR VPWR sky130_fd_sc_hd__decap_3
XFILLER_0_49_561 VPWR VGND VPWR VGND sky130_ef_sc_hd__decap_12
XTAP_1568 VGND VPWR sky130_fd_sc_hd__tapvpwrvgnd_1
XTAP_1579 VGND VPWR sky130_fd_sc_hd__tapvpwrvgnd_1
XPHY_75 VGND VGND VPWR VPWR sky130_fd_sc_hd__decap_3
XPHY_86 VGND VGND VPWR VPWR sky130_fd_sc_hd__decap_3
XPHY_97 VGND VGND VPWR VPWR sky130_fd_sc_hd__decap_3
XFILLER_0_106_121 VGND VGND VPWR VPWR sky130_fd_sc_hd__decap_6
XFILLER_0_51_203 VPWR VGND VPWR VGND sky130_ef_sc_hd__decap_12
XFILLER_0_17_491 VGND VGND VPWR VPWR sky130_fd_sc_hd__decap_4
XFILLER_0_51_269 VGND VGND VPWR VPWR sky130_fd_sc_hd__decap_8
XFILLER_0_20_667 VGND VGND VPWR VPWR sky130_fd_sc_hd__decap_8
XFILLER_0_2_29 VPWR VGND VPWR VGND sky130_ef_sc_hd__decap_12
XFILLER_0_63_48 VGND VGND VPWR VPWR sky130_fd_sc_hd__fill_2
XFILLER_0_99_494 VGND VGND VPWR VPWR sky130_fd_sc_hd__decap_8
XFILLER_0_28_701 VGND VGND VPWR VPWR sky130_fd_sc_hd__decap_4
X_3810_ _1058_ _1062_ VGND VGND VPWR VPWR _1063_ sky130_fd_sc_hd__or2_1
XFILLER_0_7_606 VGND VGND VPWR VPWR sky130_fd_sc_hd__fill_1
X_4790_ _1787_ _1788_ _1797_ _1799_ VGND VGND VPWR VPWR _1813_ sky130_fd_sc_hd__o22a_1
X_3741_ _0997_ _0998_ VGND VGND VPWR VPWR _0999_ sky130_fd_sc_hd__xnor2_1
XFILLER_0_82_361 VGND VGND VPWR VPWR sky130_fd_sc_hd__decap_3
XFILLER_0_12_41 VPWR VGND VPWR VGND sky130_ef_sc_hd__decap_12
XFILLER_0_43_704 VGND VGND VPWR VPWR sky130_fd_sc_hd__fill_1
X_6460_ net128 _3101_ _2987_ _3111_ VGND VGND VPWR VPWR _0651_ sky130_fd_sc_hd__a22o_1
X_3672_ net119 _0949_ _0944_ _0953_ VGND VGND VPWR VPWR _0021_ sky130_fd_sc_hd__a22o_1
XFILLER_0_55_597 VGND VGND VPWR VPWR sky130_fd_sc_hd__decap_8
XFILLER_0_113_625 VPWR VGND VPWR VGND sky130_ef_sc_hd__decap_12
X_5411_ _2295_ VGND VGND VPWR VPWR _0418_ sky130_fd_sc_hd__clkbuf_1
X_6391_ _3058_ VGND VGND VPWR VPWR _3059_ sky130_fd_sc_hd__inv_2
XFILLER_0_113_669 VGND VGND VPWR VPWR sky130_fd_sc_hd__decap_3
X_5342_ u_pe_array.g_pe_row\[1\].g_pe_col\[3\].u_pe.psum_out\[8\] _2239_ _2226_ VGND
+ VGND VPWR VPWR _2240_ sky130_fd_sc_hd__mux2_1
XFILLER_0_2_333 VGND VGND VPWR VPWR sky130_fd_sc_hd__fill_1
XFILLER_0_23_461 VPWR VGND VPWR VGND sky130_ef_sc_hd__decap_12
XFILLER_0_23_494 VGND VGND VPWR VPWR sky130_fd_sc_hd__decap_8
XFILLER_0_10_133 VGND VGND VPWR VPWR sky130_fd_sc_hd__decap_6
XFILLER_0_50_280 VGND VGND VPWR VPWR sky130_fd_sc_hd__fill_1
X_5273_ u_pe_array.g_pe_row\[1\].g_pe_col\[3\].u_pe.act_val\[1\] _2164_ _2175_ _2176_
+ VGND VGND VPWR VPWR _2177_ sky130_fd_sc_hd__nor4_1
X_7012_ net640 _3347_ _3499_ VGND VGND VPWR VPWR _3500_ sky130_fd_sc_hd__mux2_1
X_4224_ _1380_ _1381_ VGND VGND VPWR VPWR _1382_ sky130_fd_sc_hd__and2_1
X_4155_ _1033_ _1317_ _1318_ _0986_ net476 VGND VGND VPWR VPWR _0139_ sky130_fd_sc_hd__a32o_1
XFILLER_0_78_612 VGND VGND VPWR VPWR sky130_fd_sc_hd__decap_4
X_4086_ u_pe_array.g_pe_row\[3\].g_pe_col\[2\].u_pe.psum_out\[9\] u_pe_array.g_pe_row\[3\].g_pe_col\[2\].u_pe.psum_out\[10\]
+ _0934_ VGND VGND VPWR VPWR _1280_ sky130_fd_sc_hd__o21a_1
X_7914_ clknet_leaf_76_clk _0819_ VGND VGND VPWR VPWR u_pe_array.u_fifo1.buffer\[2\]\[4\]
+ sky130_fd_sc_hd__dfxtp_1
XFILLER_0_77_166 VGND VGND VPWR VPWR sky130_fd_sc_hd__fill_2
X_7845_ clknet_leaf_98_clk _0750_ VGND VGND VPWR VPWR u_pe_array.u_fifo2.buffer\[1\]\[3\]
+ sky130_fd_sc_hd__dfxtp_1
X_4988_ u_pe_array.g_pe_row\[2\].g_pe_col\[1\].u_pe.psum_out\[8\] _1954_ VGND VGND
+ VPWR VPWR _1968_ sky130_fd_sc_hd__nor2_1
XFILLER_0_108_419 VGND VGND VPWR VPWR sky130_fd_sc_hd__fill_1
X_7776_ clknet_leaf_91_clk _0682_ net949 VGND VGND VPWR VPWR u_fsm.ch_cnt\[0\] sky130_fd_sc_hd__dfrtp_1
XFILLER_0_46_531 VGND VGND VPWR VPWR sky130_fd_sc_hd__fill_1
X_6727_ _3306_ _3311_ VGND VGND VPWR VPWR _3313_ sky130_fd_sc_hd__nand2_1
XFILLER_0_80_309 VGND VGND VPWR VPWR sky130_fd_sc_hd__decap_3
X_3939_ _1165_ VGND VGND VPWR VPWR _0076_ sky130_fd_sc_hd__clkbuf_1
X_6658_ _3248_ _3249_ VGND VGND VPWR VPWR _3250_ sky130_fd_sc_hd__and2_1
XFILLER_0_18_288 VGND VGND VPWR VPWR sky130_fd_sc_hd__decap_4
XFILLER_0_33_225 VPWR VGND VPWR VGND sky130_ef_sc_hd__decap_12
XFILLER_0_46_597 VGND VGND VPWR VPWR sky130_fd_sc_hd__decap_4
XFILLER_0_103_113 VGND VGND VPWR VPWR sky130_fd_sc_hd__decap_4
X_5609_ _2435_ _2445_ u_pe_array.g_pe_row\[1\].g_pe_col\[2\].u_pe.psum_out\[7\] _2431_
+ VGND VGND VPWR VPWR _2453_ sky130_fd_sc_hd__o2bb2a_1
XFILLER_0_104_669 VPWR VGND VPWR VGND sky130_ef_sc_hd__decap_12
XFILLER_0_103_135 VPWR VGND VPWR VGND sky130_ef_sc_hd__decap_12
X_6589_ _3211_ _3212_ VGND VGND VPWR VPWR _3213_ sky130_fd_sc_hd__nand2_1
XFILLER_0_5_193 VPWR VGND VPWR VGND sky130_ef_sc_hd__decap_12
XFILLER_0_14_461 VGND VGND VPWR VPWR sky130_fd_sc_hd__fill_2
XTAP_1321 VGND VPWR sky130_fd_sc_hd__tapvpwrvgnd_1
XTAP_1332 VGND VPWR sky130_fd_sc_hd__tapvpwrvgnd_1
XTAP_1310 VGND VPWR sky130_fd_sc_hd__tapvpwrvgnd_1
XFILLER_0_69_656 VGND VGND VPWR VPWR sky130_fd_sc_hd__decap_8
XFILLER_0_96_475 VGND VGND VPWR VPWR sky130_fd_sc_hd__fill_1
XTAP_1365 VGND VPWR sky130_fd_sc_hd__tapvpwrvgnd_1
XTAP_1354 VGND VPWR sky130_fd_sc_hd__tapvpwrvgnd_1
XTAP_1343 VGND VPWR sky130_fd_sc_hd__tapvpwrvgnd_1
XFILLER_0_56_306 VGND VGND VPWR VPWR sky130_fd_sc_hd__fill_2
XTAP_1398 VGND VPWR sky130_fd_sc_hd__tapvpwrvgnd_1
XTAP_1387 VGND VPWR sky130_fd_sc_hd__tapvpwrvgnd_1
XTAP_1376 VGND VPWR sky130_fd_sc_hd__tapvpwrvgnd_1
XFILLER_0_83_169 VGND VGND VPWR VPWR sky130_fd_sc_hd__decap_6
Xinput16 v_in0[1] VGND VGND VPWR VPWR net16 sky130_fd_sc_hd__buf_2
Xinput27 w_in_flat[0] VGND VGND VPWR VPWR net27 sky130_fd_sc_hd__clkbuf_1
XFILLER_0_116_9 VGND VGND VPWR VPWR sky130_fd_sc_hd__fill_2
XFILLER_0_107_452 VGND VGND VPWR VPWR sky130_fd_sc_hd__decap_6
XFILLER_0_52_556 VGND VGND VPWR VPWR sky130_fd_sc_hd__decap_3
XFILLER_0_52_567 VPWR VGND VPWR VGND sky130_ef_sc_hd__decap_12
XFILLER_0_87_431 VPWR VGND VPWR VGND sky130_ef_sc_hd__decap_12
XFILLER_0_59_111 VGND VGND VPWR VPWR sky130_fd_sc_hd__fill_1
X_5960_ u_pe_array.u_fifo1.buffer\[5\]\[5\] _2687_ _2688_ u_pe_array.u_fifo1.buffer\[6\]\[5\]
+ _2689_ VGND VGND VPWR VPWR _2725_ sky130_fd_sc_hd__a221o_1
X_4911_ u_pe_array.g_pe_row\[2\].g_pe_col\[1\].u_pe.act_val\[1\] _1105_ VGND VGND
+ VPWR VPWR _1897_ sky130_fd_sc_hd__and2b_1
X_5891_ _2671_ VGND VGND VPWR VPWR _0522_ sky130_fd_sc_hd__clkbuf_1
X_7630_ clknet_leaf_72_clk _0536_ net949 VGND VGND VPWR VPWR u_pe_array.g_pe_row\[1\].g_pe_col\[0\].u_pe.act_val\[3\]
+ sky130_fd_sc_hd__dfrtp_1
XFILLER_0_114_53 VPWR VGND VPWR VGND sky130_ef_sc_hd__decap_12
XFILLER_0_23_51 VGND VGND VPWR VPWR sky130_fd_sc_hd__decap_4
X_4842_ _1487_ _1858_ _1859_ _1803_ net404 VGND VGND VPWR VPWR _0285_ sky130_fd_sc_hd__a32o_1
XFILLER_0_117_249 VPWR VGND VPWR VGND sky130_ef_sc_hd__decap_12
XFILLER_0_114_97 VPWR VGND VPWR VGND sky130_ef_sc_hd__decap_12
X_7561_ clknet_leaf_46_clk _0467_ net947 VGND VGND VPWR VPWR u_pe_array.act_from_down\[1\]\[1\]
+ sky130_fd_sc_hd__dfrtp_1
X_4773_ u_pe_array.g_pe_row\[2\].g_pe_col\[2\].u_pe.psum_out\[5\] _1796_ VGND VGND
+ VPWR VPWR _1797_ sky130_fd_sc_hd__xnor2_1
X_6512_ u_pe_array.g_pe_row\[0\].g_pe_col\[1\].u_pe.psum_out\[2\] _3130_ _3142_ VGND
+ VGND VPWR VPWR _3143_ sky130_fd_sc_hd__a21oi_1
XFILLER_0_99_55 VGND VGND VPWR VPWR sky130_fd_sc_hd__fill_1
X_7492_ clknet_leaf_39_clk _0398_ net947 VGND VGND VPWR VPWR u_pe_array.g_pe_row\[1\].g_pe_col\[3\].u_pe.psum_out\[1\]
+ sky130_fd_sc_hd__dfrtp_1
XFILLER_0_7_469 VPWR VGND VPWR VGND sky130_ef_sc_hd__decap_12
XFILLER_0_15_225 VGND VGND VPWR VPWR sky130_fd_sc_hd__decap_4
X_3724_ _0982_ _0983_ u_fsm.state\[1\] VGND VGND VPWR VPWR _0984_ sky130_fd_sc_hd__o21bai_1
X_6443_ u_pe_array.g_pe_row\[0\].g_pe_col\[1\].u_pe.psum_out\[0\] u_pe_array.g_pe_row\[0\].g_pe_col\[1\].u_pe.act_val\[0\]
+ _3102_ VGND VGND VPWR VPWR _3103_ sky130_fd_sc_hd__mux2_1
X_3655_ u_pe_array.g_pe_row\[0\].g_pe_col\[0\].u_pe.psum_shift_en_d _0865_ VGND VGND
+ VPWR VPWR _0941_ sky130_fd_sc_hd__and2_2
XFILLER_0_43_556 VGND VGND VPWR VPWR sky130_fd_sc_hd__decap_4
XFILLER_0_43_578 VGND VGND VPWR VPWR sky130_fd_sc_hd__decap_6
XFILLER_0_3_653 VPWR VGND VPWR VGND sky130_ef_sc_hd__decap_12
XFILLER_0_101_617 VPWR VGND VPWR VGND sky130_ef_sc_hd__decap_12
XFILLER_0_3_697 VGND VGND VPWR VPWR sky130_fd_sc_hd__decap_8
XFILLER_0_2_141 VPWR VGND VPWR VGND sky130_ef_sc_hd__decap_12
X_3586_ u_fsm.cnt\[0\] u_fsm.cnt\[1\] u_fsm.cnt\[2\] VGND VGND VPWR VPWR _0890_ sky130_fd_sc_hd__a21o_1
X_6374_ u_pe_array.g_pe_row\[0\].g_pe_col\[2\].u_pe.act_val\[5\] VGND VGND VPWR VPWR
+ _3043_ sky130_fd_sc_hd__inv_2
X_5325_ _1884_ _2223_ _2224_ _2173_ net754 VGND VGND VPWR VPWR _0403_ sky130_fd_sc_hd__a32o_1
X_5256_ u_pe_array.g_pe_row\[1\].g_pe_col\[3\].u_pe.psum_out\[0\] u_pe_array.g_pe_row\[1\].g_pe_col\[3\].u_pe.act_val\[0\]
+ _1423_ VGND VGND VPWR VPWR _2162_ sky130_fd_sc_hd__and3_1
X_4207_ net472 _1273_ _1366_ _1021_ VGND VGND VPWR VPWR _0143_ sky130_fd_sc_hd__a22o_1
X_5187_ _2118_ _2122_ VGND VGND VPWR VPWR _2123_ sky130_fd_sc_hd__xor2_1
X_4138_ net381 u_fsm.psum_shift_en _1175_ u_pe_array.g_pe_row\[3\].g_pe_col\[1\].u_pe.move_reg\[6\]
+ VGND VGND VPWR VPWR _0131_ sky130_fd_sc_hd__a22o_1
X_4069_ u_pe_array.g_pe_row\[3\].g_pe_col\[2\].u_pe.psum_out\[7\] u_pe_array.g_pe_row\[3\].g_pe_col\[2\].u_pe.psum_out\[8\]
+ _0934_ VGND VGND VPWR VPWR _1265_ sky130_fd_sc_hd__o21a_1
XFILLER_0_93_401 VGND VGND VPWR VPWR sky130_fd_sc_hd__fill_2
X_7828_ clknet_leaf_85_clk _0733_ net948 VGND VGND VPWR VPWR u_pe_array.u_fifo2.rd_ptr\[0\]
+ sky130_fd_sc_hd__dfrtp_4
X_7759_ clknet_leaf_44_clk net237 net947 VGND VGND VPWR VPWR u_pe_array.g_pe_row\[0\].g_pe_col\[1\].u_pe.move_reg\[9\]
+ sky130_fd_sc_hd__dfrtp_1
XFILLER_0_80_139 VGND VGND VPWR VPWR sky130_fd_sc_hd__fill_1
XFILLER_0_34_512 VGND VGND VPWR VPWR sky130_fd_sc_hd__decap_6
XFILLER_0_34_545 VGND VGND VPWR VPWR sky130_fd_sc_hd__fill_1
XFILLER_0_116_293 VPWR VGND VPWR VGND sky130_ef_sc_hd__decap_12
XFILLER_0_104_455 VGND VGND VPWR VPWR sky130_fd_sc_hd__decap_8
XFILLER_0_104_433 VGND VGND VPWR VPWR sky130_fd_sc_hd__fill_2
XFILLER_0_104_477 VGND VGND VPWR VPWR sky130_fd_sc_hd__decap_6
XFILLER_0_104_466 VGND VGND VPWR VPWR sky130_fd_sc_hd__decap_8
XFILLER_0_69_453 VGND VGND VPWR VPWR sky130_fd_sc_hd__fill_1
XFILLER_0_96_250 VGND VGND VPWR VPWR sky130_fd_sc_hd__fill_2
XTAP_1140 VGND VPWR sky130_fd_sc_hd__tapvpwrvgnd_1
XFILLER_0_57_615 VGND VGND VPWR VPWR sky130_fd_sc_hd__fill_1
XTAP_1162 VGND VPWR sky130_fd_sc_hd__tapvpwrvgnd_1
XTAP_1173 VGND VPWR sky130_fd_sc_hd__tapvpwrvgnd_1
XTAP_1151 VGND VPWR sky130_fd_sc_hd__tapvpwrvgnd_1
XTAP_1195 VGND VPWR sky130_fd_sc_hd__tapvpwrvgnd_1
XTAP_1184 VGND VPWR sky130_fd_sc_hd__tapvpwrvgnd_1
XFILLER_0_64_191 VGND VGND VPWR VPWR sky130_fd_sc_hd__decap_4
XFILLER_0_69_36 VGND VGND VPWR VPWR sky130_fd_sc_hd__decap_6
Xhold608 u_pe_array.u_fifo1.buffer\[2\]\[4\] VGND VGND VPWR VPWR net682 sky130_fd_sc_hd__dlygate4sd3_1
XFILLER_0_40_504 VGND VGND VPWR VPWR sky130_fd_sc_hd__fill_1
Xhold619 u_fsm.cnt\[3\] VGND VGND VPWR VPWR net693 sky130_fd_sc_hd__dlygate4sd3_1
XFILLER_0_100_77 VGND VGND VPWR VPWR sky130_fd_sc_hd__decap_6
XFILLER_0_0_645 VPWR VGND VPWR VGND sky130_ef_sc_hd__decap_12
X_5110_ _2051_ _2052_ VGND VGND VPWR VPWR _2053_ sky130_fd_sc_hd__nor2_1
XTAP_935 VGND VPWR sky130_fd_sc_hd__tapvpwrvgnd_1
X_6090_ _2828_ _2830_ _2835_ VGND VGND VPWR VPWR _2836_ sky130_fd_sc_hd__o21ai_1
XTAP_924 VGND VPWR sky130_fd_sc_hd__tapvpwrvgnd_1
XTAP_913 VGND VPWR sky130_fd_sc_hd__tapvpwrvgnd_1
XTAP_902 VGND VPWR sky130_fd_sc_hd__tapvpwrvgnd_1
X_5041_ u_pe_array.g_pe_row\[2\].g_pe_col\[0\].u_pe.psum_out\[6\] u_pe_array.g_pe_row\[2\].g_pe_col\[0\].u_pe.move_reg\[6\]
+ _1867_ VGND VGND VPWR VPWR _2008_ sky130_fd_sc_hd__mux2_1
XFILLER_0_85_57 VPWR VGND VPWR VGND sky130_ef_sc_hd__decap_12
XTAP_968 VGND VPWR sky130_fd_sc_hd__tapvpwrvgnd_1
XTAP_957 VGND VPWR sky130_fd_sc_hd__tapvpwrvgnd_1
XTAP_946 VGND VPWR sky130_fd_sc_hd__tapvpwrvgnd_1
XTAP_979 VGND VPWR sky130_fd_sc_hd__tapvpwrvgnd_1
X_6992_ _3488_ VGND VGND VPWR VPWR _0806_ sky130_fd_sc_hd__clkbuf_1
X_5943_ u_pe_array.u_fifo1.buffer\[7\]\[3\] _2681_ _2683_ u_pe_array.u_fifo1.buffer\[1\]\[3\]
+ VGND VGND VPWR VPWR _2710_ sky130_fd_sc_hd__a22o_1
XFILLER_0_75_423 VGND VGND VPWR VPWR sky130_fd_sc_hd__decap_8
X_5874_ u_pe_array.g_pe_row\[1\].g_pe_col\[0\].u_pe.move_reg\[10\] net62 VGND VGND
+ VPWR VPWR _2660_ sky130_fd_sc_hd__or2_1
XFILLER_0_8_701 VGND VGND VPWR VPWR sky130_fd_sc_hd__decap_4
XFILLER_0_118_547 VPWR VGND VPWR VGND sky130_ef_sc_hd__decap_12
X_7613_ clknet_leaf_47_clk _0519_ net73 VGND VGND VPWR VPWR net39 sky130_fd_sc_hd__dfrtp_1
X_4825_ _1487_ _1843_ _1844_ _1803_ net885 VGND VGND VPWR VPWR _0283_ sky130_fd_sc_hd__a32o_1
XFILLER_0_62_139 VGND VGND VPWR VPWR sky130_fd_sc_hd__fill_1
X_7544_ clknet_leaf_66_clk net207 net72 VGND VGND VPWR VPWR u_pe_array.g_pe_row\[1\].g_pe_col\[2\].u_pe.move_reg\[12\]
+ sky130_fd_sc_hd__dfrtp_1
XFILLER_0_7_244 VGND VGND VPWR VPWR sky130_fd_sc_hd__decap_3
XFILLER_0_28_361 VGND VGND VPWR VPWR sky130_fd_sc_hd__decap_3
XFILLER_0_7_277 VGND VGND VPWR VPWR sky130_fd_sc_hd__decap_3
XFILLER_0_16_545 VGND VGND VPWR VPWR sky130_fd_sc_hd__decap_4
X_4756_ _1771_ _1781_ VGND VGND VPWR VPWR _1782_ sky130_fd_sc_hd__xnor2_1
XFILLER_0_43_331 VGND VGND VPWR VPWR sky130_fd_sc_hd__decap_4
X_3707_ net856 _0939_ VGND VGND VPWR VPWR _0972_ sky130_fd_sc_hd__and2_1
X_7475_ clknet_leaf_65_clk _0381_ net946 VGND VGND VPWR VPWR u_pe_array.act_from_down\[3\]\[10\]
+ sky130_fd_sc_hd__dfrtp_1
XFILLER_0_71_673 VGND VGND VPWR VPWR sky130_fd_sc_hd__decap_6
X_4687_ u_pe_array.g_pe_row\[2\].g_pe_col\[2\].u_pe.psum_out\[3\] u_pe_array.g_pe_row\[2\].g_pe_col\[2\].u_pe.act_val\[3\]
+ _1599_ VGND VGND VPWR VPWR _1739_ sky130_fd_sc_hd__mux2_1
XFILLER_0_16_589 VGND VGND VPWR VPWR sky130_fd_sc_hd__fill_1
XFILLER_0_3_461 VPWR VGND VPWR VGND sky130_ef_sc_hd__decap_12
X_3638_ _0927_ VGND VGND VPWR VPWR _0013_ sky130_fd_sc_hd__clkbuf_1
XFILLER_0_43_397 VGND VGND VPWR VPWR sky130_fd_sc_hd__fill_1
X_6426_ u_pe_array.g_pe_row\[0\].g_pe_col\[2\].u_pe.psum_out\[11\] _2130_ VGND VGND
+ VPWR VPWR _3090_ sky130_fd_sc_hd__and2b_1
XFILLER_0_113_296 VGND VGND VPWR VPWR sky130_fd_sc_hd__decap_8
XFILLER_0_101_447 VGND VGND VPWR VPWR sky130_fd_sc_hd__fill_1
X_3569_ u_fsm.state\[1\] u_fsm.state\[0\] _0853_ net14 VGND VGND VPWR VPWR _0877_
+ sky130_fd_sc_hd__or4_1
X_6357_ _3025_ _3026_ VGND VGND VPWR VPWR _3028_ sky130_fd_sc_hd__nor2_1
X_5308_ _2206_ _2207_ _2196_ net66 VGND VGND VPWR VPWR _2209_ sky130_fd_sc_hd__a211oi_1
X_6288_ net185 _2006_ _2009_ _2981_ VGND VGND VPWR VPWR _0609_ sky130_fd_sc_hd__a22o_1
X_5239_ net6 net903 _0963_ VGND VGND VPWR VPWR _2153_ sky130_fd_sc_hd__mux2_1
XPHY_201 VGND VGND VPWR VPWR sky130_fd_sc_hd__decap_3
XPHY_234 VGND VGND VPWR VPWR sky130_fd_sc_hd__decap_3
XPHY_223 VGND VGND VPWR VPWR sky130_fd_sc_hd__decap_3
XPHY_212 VGND VGND VPWR VPWR sky130_fd_sc_hd__decap_3
XFILLER_0_38_136 VGND VGND VPWR VPWR sky130_fd_sc_hd__decap_4
XFILLER_0_26_309 VGND VGND VPWR VPWR sky130_fd_sc_hd__decap_4
XFILLER_0_109_558 VGND VGND VPWR VPWR sky130_fd_sc_hd__fill_2
XFILLER_0_47_681 VPWR VGND VPWR VGND sky130_ef_sc_hd__decap_12
XFILLER_0_39_28 VGND VGND VPWR VPWR sky130_fd_sc_hd__fill_2
XFILLER_0_30_570 VGND VGND VPWR VPWR sky130_fd_sc_hd__decap_3
XFILLER_0_30_581 VGND VGND VPWR VPWR sky130_fd_sc_hd__fill_2
Xhold5 u_pe_array.act_from_right\[8\]\[1\] VGND VGND VPWR VPWR net79 sky130_fd_sc_hd__dlygate4sd3_1
XFILLER_0_89_537 VGND VGND VPWR VPWR sky130_fd_sc_hd__decap_6
XFILLER_0_71_26 VGND VGND VPWR VPWR sky130_fd_sc_hd__fill_1
XFILLER_0_29_125 VGND VGND VPWR VPWR sky130_fd_sc_hd__decap_3
XFILLER_0_72_448 VGND VGND VPWR VPWR sky130_fd_sc_hd__decap_4
XFILLER_0_5_704 VGND VGND VPWR VPWR sky130_fd_sc_hd__fill_1
XFILLER_0_38_692 VGND VGND VPWR VPWR sky130_fd_sc_hd__decap_8
X_4610_ u_pe_array.g_pe_row\[2\].g_pe_col\[3\].u_pe.act_val\[4\] _1673_ _1663_ _1661_
+ VGND VGND VPWR VPWR _1674_ sky130_fd_sc_hd__o22ai_1
XFILLER_0_115_517 VGND VGND VPWR VPWR sky130_fd_sc_hd__decap_4
XFILLER_0_53_640 VPWR VGND VPWR VGND sky130_ef_sc_hd__decap_12
XFILLER_0_25_342 VGND VGND VPWR VPWR sky130_fd_sc_hd__decap_6
X_5590_ _2431_ _2432_ _2434_ VGND VGND VPWR VPWR _2436_ sky130_fd_sc_hd__a21o_1
X_4541_ net467 _1310_ _1483_ net471 VGND VGND VPWR VPWR _0229_ sky130_fd_sc_hd__a22o_1
XFILLER_0_53_673 VGND VGND VPWR VPWR sky130_fd_sc_hd__fill_1
XFILLER_0_13_526 VGND VGND VPWR VPWR sky130_fd_sc_hd__decap_3
XFILLER_0_20_41 VGND VGND VPWR VPWR sky130_fd_sc_hd__decap_8
XFILLER_0_52_150 VGND VGND VPWR VPWR sky130_fd_sc_hd__decap_4
Xhold416 u_pe_array.g_pe_row\[0\].g_pe_col\[1\].u_pe.psum_out\[5\] VGND VGND VPWR
+ VPWR net490 sky130_fd_sc_hd__dlygate4sd3_1
Xhold405 u_pe_array.act_from_up\[4\]\[10\] VGND VGND VPWR VPWR net479 sky130_fd_sc_hd__dlygate4sd3_1
XFILLER_0_20_85 VGND VGND VPWR VPWR sky130_fd_sc_hd__fill_2
Xhold427 u_pe_array.act_from_up\[12\]\[4\] VGND VGND VPWR VPWR net501 sky130_fd_sc_hd__dlygate4sd3_1
X_7260_ clknet_leaf_9_clk _0166_ net950 VGND VGND VPWR VPWR u_pe_array.act_from_left\[13\]\[0\]
+ sky130_fd_sc_hd__dfrtp_1
X_4472_ _1565_ _1568_ _1573_ VGND VGND VPWR VPWR _1574_ sky130_fd_sc_hd__o21ai_1
Xhold438 u_pe_array.g_pe_row\[0\].g_pe_col\[1\].u_pe.psum_out\[0\] VGND VGND VPWR
+ VPWR net512 sky130_fd_sc_hd__dlygate4sd3_1
Xhold449 u_pe_array.g_pe_row\[0\].g_pe_col\[0\].u_pe.psum_out\[2\] VGND VGND VPWR
+ VPWR net523 sky130_fd_sc_hd__dlygate4sd3_1
X_6211_ _2896_ _2897_ _2906_ _2908_ VGND VGND VPWR VPWR _2921_ sky130_fd_sc_hd__o22a_1
X_7191_ clknet_leaf_104_clk _0097_ net944 VGND VGND VPWR VPWR u_pe_array.g_pe_row\[3\].g_pe_col\[2\].u_pe.psum_out\[0\]
+ sky130_fd_sc_hd__dfrtp_1
XFILLER_0_40_378 VPWR VGND VPWR VGND sky130_ef_sc_hd__decap_12
XFILLER_0_96_45 VPWR VGND VPWR VGND sky130_ef_sc_hd__decap_12
X_6142_ net183 _2730_ _2511_ u_pe_array.g_pe_row\[0\].g_pe_col\[3\].u_pe.move_reg\[11\]
+ VGND VGND VPWR VPWR _0585_ sky130_fd_sc_hd__a22o_1
XTAP_710 VGND VPWR sky130_fd_sc_hd__tapvpwrvgnd_1
XFILLER_0_0_497 VGND VGND VPWR VPWR sky130_fd_sc_hd__fill_1
XFILLER_0_29_50 VGND VGND VPWR VPWR sky130_fd_sc_hd__decap_6
XTAP_721 VGND VPWR sky130_fd_sc_hd__tapvpwrvgnd_1
XTAP_732 VGND VPWR sky130_fd_sc_hd__tapvpwrvgnd_1
XTAP_743 VGND VPWR sky130_fd_sc_hd__tapvpwrvgnd_1
X_6073_ _2812_ _2815_ _2820_ VGND VGND VPWR VPWR _2821_ sky130_fd_sc_hd__o21ai_1
XFILLER_0_29_83 VGND VGND VPWR VPWR sky130_fd_sc_hd__fill_2
XTAP_754 VGND VPWR sky130_fd_sc_hd__tapvpwrvgnd_1
XTAP_765 VGND VPWR sky130_fd_sc_hd__tapvpwrvgnd_1
XTAP_776 VGND VPWR sky130_fd_sc_hd__tapvpwrvgnd_1
X_5024_ _1998_ VGND VGND VPWR VPWR _0328_ sky130_fd_sc_hd__clkbuf_1
XTAP_787 VGND VPWR sky130_fd_sc_hd__tapvpwrvgnd_1
XTAP_798 VGND VPWR sky130_fd_sc_hd__tapvpwrvgnd_1
XFILLER_0_17_3 VPWR VGND VPWR VGND sky130_ef_sc_hd__decap_12
XFILLER_0_45_71 VGND VGND VPWR VPWR sky130_fd_sc_hd__fill_1
X_6975_ _3476_ _3477_ VGND VGND VPWR VPWR _0800_ sky130_fd_sc_hd__xnor2_1
X_5926_ u_pe_array.u_fifo1.buffer\[0\]\[1\] _2678_ VGND VGND VPWR VPWR _2695_ sky130_fd_sc_hd__or2_1
XFILLER_0_48_467 VGND VGND VPWR VPWR sky130_fd_sc_hd__decap_8
X_5857_ _2647_ VGND VGND VPWR VPWR _0512_ sky130_fd_sc_hd__clkbuf_1
X_5788_ _2590_ _2565_ _2578_ _2582_ VGND VGND VPWR VPWR _2591_ sky130_fd_sc_hd__a22o_1
X_4808_ u_pe_array.g_pe_row\[2\].g_pe_col\[2\].u_pe.psum_out\[7\] VGND VGND VPWR VPWR
+ _1829_ sky130_fd_sc_hd__inv_2
XFILLER_0_28_180 VPWR VGND VPWR VGND sky130_ef_sc_hd__decap_12
XFILLER_0_90_289 VGND VGND VPWR VPWR sky130_fd_sc_hd__decap_6
XFILLER_0_90_267 VGND VGND VPWR VPWR sky130_fd_sc_hd__fill_1
X_4739_ u_pe_array.g_pe_row\[2\].g_pe_col\[2\].u_pe.psum_out\[2\] _1765_ VGND VGND
+ VPWR VPWR _1766_ sky130_fd_sc_hd__xnor2_1
XFILLER_0_16_375 VGND VGND VPWR VPWR sky130_fd_sc_hd__decap_4
XFILLER_0_50_109 VGND VGND VPWR VPWR sky130_fd_sc_hd__decap_4
X_7527_ clknet_leaf_68_clk _0433_ net72 VGND VGND VPWR VPWR u_pe_array.act_from_left\[7\]\[8\]
+ sky130_fd_sc_hd__dfrtp_1
X_7458_ clknet_leaf_32_clk _0364_ net71 VGND VGND VPWR VPWR u_pe_array.g_pe_row\[2\].g_pe_col\[0\].u_pe.psum_out\[8\]
+ sky130_fd_sc_hd__dfrtp_2
XFILLER_0_102_701 VGND VGND VPWR VPWR sky130_fd_sc_hd__decap_4
XFILLER_0_9_93 VPWR VGND VPWR VGND sky130_ef_sc_hd__decap_12
X_6409_ u_pe_array.g_pe_row\[0\].g_pe_col\[2\].u_pe.psum_out\[9\] _2130_ VGND VGND
+ VPWR VPWR _3075_ sky130_fd_sc_hd__nand2_1
X_7389_ clknet_leaf_35_clk _0295_ net942 VGND VGND VPWR VPWR u_pe_array.act_from_right\[8\]\[6\]
+ sky130_fd_sc_hd__dfrtp_1
XFILLER_0_86_529 VGND VGND VPWR VPWR sky130_fd_sc_hd__decap_3
XFILLER_0_39_401 VPWR VGND VPWR VGND sky130_ef_sc_hd__decap_12
XFILLER_0_109_300 VPWR VGND VPWR VGND sky130_ef_sc_hd__decap_12
XFILLER_0_41_29 VPWR VGND VPWR VGND sky130_ef_sc_hd__decap_12
XFILLER_0_81_223 VGND VGND VPWR VPWR sky130_fd_sc_hd__fill_1
XFILLER_0_109_388 VGND VGND VPWR VPWR sky130_fd_sc_hd__decap_4
XFILLER_0_22_301 VGND VGND VPWR VPWR sky130_fd_sc_hd__decap_6
XFILLER_0_35_673 VGND VGND VPWR VPWR sky130_fd_sc_hd__decap_8
XFILLER_0_35_684 VPWR VGND VPWR VGND sky130_ef_sc_hd__decap_12
XFILLER_0_50_643 VGND VGND VPWR VPWR sky130_fd_sc_hd__fill_1
XFILLER_0_1_217 VGND VGND VPWR VPWR sky130_fd_sc_hd__decap_6
XFILLER_0_50_687 VGND VGND VPWR VPWR sky130_fd_sc_hd__decap_3
XFILLER_0_22_389 VGND VGND VPWR VPWR sky130_fd_sc_hd__decap_8
XFILLER_0_50_698 VGND VGND VPWR VPWR sky130_fd_sc_hd__fill_2
XFILLER_0_106_65 VPWR VGND VPWR VGND sky130_ef_sc_hd__decap_12
X_6760_ _3337_ _3341_ VGND VGND VPWR VPWR _3342_ sky130_fd_sc_hd__xor2_1
XFILLER_0_15_74 VGND VGND VPWR VPWR sky130_fd_sc_hd__decap_6
X_5711_ _2233_ _2519_ _2520_ _2173_ net545 VGND VGND VPWR VPWR _0493_ sky130_fd_sc_hd__a32o_1
XFILLER_0_15_96 VPWR VGND VPWR VGND sky130_ef_sc_hd__decap_12
XFILLER_0_18_618 VGND VGND VPWR VPWR sky130_fd_sc_hd__decap_3
X_3972_ _1033_ _1176_ _1177_ _0986_ net570 VGND VGND VPWR VPWR _0097_ sky130_fd_sc_hd__a32o_1
X_6691_ _3278_ _3279_ VGND VGND VPWR VPWR _3280_ sky130_fd_sc_hd__or2_1
XFILLER_0_5_501 VGND VGND VPWR VPWR sky130_fd_sc_hd__decap_3
X_5642_ u_pe_array.g_pe_row\[1\].g_pe_col\[2\].u_pe.psum_out\[9\] u_pe_array.g_pe_row\[1\].g_pe_col\[2\].u_pe.psum_out\[10\]
+ _1597_ VGND VGND VPWR VPWR _2482_ sky130_fd_sc_hd__o21a_1
XFILLER_0_72_278 VGND VGND VPWR VPWR sky130_fd_sc_hd__fill_1
XFILLER_0_72_267 VGND VGND VPWR VPWR sky130_fd_sc_hd__decap_4
X_5573_ _2233_ _2419_ _2420_ _2173_ net536 VGND VGND VPWR VPWR _0455_ sky130_fd_sc_hd__a32o_1
Xhold202 u_pe_array.act_from_right\[0\]\[4\] VGND VGND VPWR VPWR net276 sky130_fd_sc_hd__dlygate4sd3_1
XFILLER_0_41_621 VGND VGND VPWR VPWR sky130_fd_sc_hd__decap_6
XFILLER_0_41_632 VPWR VGND VPWR VGND sky130_ef_sc_hd__decap_12
X_4524_ net451 _1605_ _1305_ _1610_ VGND VGND VPWR VPWR _0216_ sky130_fd_sc_hd__a22o_1
X_7312_ clknet_leaf_6_clk _0218_ net945 VGND VGND VPWR VPWR u_pe_array.act_from_right\[10\]\[11\]
+ sky130_fd_sc_hd__dfrtp_1
Xhold213 u_pe_array.g_pe_row\[0\].g_pe_col\[0\].u_pe.move_reg\[7\] VGND VGND VPWR
+ VPWR net287 sky130_fd_sc_hd__dlygate4sd3_1
Xhold224 _0539_ VGND VGND VPWR VPWR net298 sky130_fd_sc_hd__dlygate4sd3_1
Xhold235 _0624_ VGND VGND VPWR VPWR net309 sky130_fd_sc_hd__dlygate4sd3_1
Xhold246 _0700_ VGND VGND VPWR VPWR net320 sky130_fd_sc_hd__dlygate4sd3_1
Xhold268 u_pe_array.act_from_right\[0\]\[11\] VGND VGND VPWR VPWR net342 sky130_fd_sc_hd__dlygate4sd3_1
X_7243_ clknet_leaf_14_clk _0149_ net943 VGND VGND VPWR VPWR u_pe_array.g_pe_row\[3\].g_pe_col\[1\].u_pe.psum_out\[11\]
+ sky130_fd_sc_hd__dfrtp_1
Xhold257 u_pe_array.act_from_up\[4\]\[4\] VGND VGND VPWR VPWR net331 sky130_fd_sc_hd__dlygate4sd3_1
X_4455_ _1545_ _1557_ VGND VGND VPWR VPWR _1558_ sky130_fd_sc_hd__and2_1
Xhold279 u_pe_array.act_from_right\[8\]\[10\] VGND VGND VPWR VPWR net353 sky130_fd_sc_hd__dlygate4sd3_1
X_4386_ u_pe_array.g_pe_row\[3\].g_pe_col\[0\].u_pe.psum_out\[1\] _1491_ _1494_ VGND
+ VGND VPWR VPWR _1495_ sky130_fd_sc_hd__a21bo_1
XFILLER_0_0_272 VGND VGND VPWR VPWR sky130_fd_sc_hd__decap_8
X_7174_ clknet_leaf_95_clk _0080_ net945 VGND VGND VPWR VPWR u_pe_array.act_from_left\[15\]\[9\]
+ sky130_fd_sc_hd__dfrtp_1
XFILLER_0_40_197 VGND VGND VPWR VPWR sky130_fd_sc_hd__fill_1
X_6125_ u_pe_array.g_pe_row\[0\].g_pe_col\[3\].u_pe.psum_out\[10\] u_pe_array.g_pe_row\[0\].g_pe_col\[3\].u_pe.move_reg\[10\]
+ _2844_ VGND VGND VPWR VPWR _2857_ sky130_fd_sc_hd__mux2_1
XTAP_540 VGND VPWR sky130_fd_sc_hd__tapvpwrvgnd_1
XTAP_551 VGND VPWR sky130_fd_sc_hd__tapvpwrvgnd_1
XTAP_562 VGND VPWR sky130_fd_sc_hd__tapvpwrvgnd_1
XTAP_573 VGND VPWR sky130_fd_sc_hd__tapvpwrvgnd_1
XTAP_584 VGND VPWR sky130_fd_sc_hd__tapvpwrvgnd_1
XFILLER_0_56_81 VGND VGND VPWR VPWR sky130_fd_sc_hd__decap_3
XTAP_595 VGND VPWR sky130_fd_sc_hd__tapvpwrvgnd_1
X_6056_ _2791_ _2804_ VGND VGND VPWR VPWR _2805_ sky130_fd_sc_hd__and2_1
X_5007_ _1973_ _1983_ _1984_ VGND VGND VPWR VPWR _1985_ sky130_fd_sc_hd__a21oi_1
XTAP_1706 VGND VPWR sky130_fd_sc_hd__tapvpwrvgnd_1
XFILLER_0_68_529 VGND VGND VPWR VPWR sky130_fd_sc_hd__decap_3
XTAP_1739 VGND VPWR sky130_fd_sc_hd__tapvpwrvgnd_1
XTAP_1728 VGND VPWR sky130_fd_sc_hd__tapvpwrvgnd_1
XTAP_1717 VGND VPWR sky130_fd_sc_hd__tapvpwrvgnd_1
X_6958_ net734 _3463_ _3465_ VGND VGND VPWR VPWR _0795_ sky130_fd_sc_hd__a21oi_1
XFILLER_0_118_141 VPWR VGND VPWR VGND sky130_ef_sc_hd__decap_12
X_6889_ _3425_ VGND VGND VPWR VPWR _0766_ sky130_fd_sc_hd__clkbuf_1
X_5909_ u_pe_array.u_fifo1.buffer\[0\]\[0\] _2678_ VGND VGND VPWR VPWR _2679_ sky130_fd_sc_hd__or2_1
XFILLER_0_118_163 VGND VGND VPWR VPWR sky130_fd_sc_hd__decap_4
XFILLER_0_106_303 VGND VGND VPWR VPWR sky130_fd_sc_hd__decap_4
XFILLER_0_91_532 VGND VGND VPWR VPWR sky130_fd_sc_hd__decap_3
XFILLER_0_63_223 VGND VGND VPWR VPWR sky130_fd_sc_hd__fill_1
XFILLER_0_17_673 VPWR VGND VPWR VGND sky130_ef_sc_hd__decap_12
Xhold780 u_pe_array.g_pe_row\[2\].g_pe_col\[0\].u_pe.psum_out\[7\] VGND VGND VPWR
+ VPWR net854 sky130_fd_sc_hd__dlygate4sd3_1
XFILLER_0_6_3 VPWR VGND VPWR VGND sky130_ef_sc_hd__decap_12
Xhold791 u_pe_array.g_pe_row\[3\].g_pe_col\[2\].u_pe.psum_out\[6\] VGND VGND VPWR
+ VPWR net865 sky130_fd_sc_hd__dlygate4sd3_1
XFILLER_0_36_18 VGND VGND VPWR VPWR sky130_fd_sc_hd__decap_8
XFILLER_0_99_610 VGND VGND VPWR VPWR sky130_fd_sc_hd__decap_6
XFILLER_0_36_29 VGND VGND VPWR VPWR sky130_fd_sc_hd__fill_2
XFILLER_0_99_665 VGND VGND VPWR VPWR sky130_fd_sc_hd__decap_6
XFILLER_0_99_643 VGND VGND VPWR VPWR sky130_fd_sc_hd__fill_2
XFILLER_0_39_242 VGND VGND VPWR VPWR sky130_fd_sc_hd__decap_4
XFILLER_0_6_309 VGND VGND VPWR VPWR sky130_fd_sc_hd__fill_2
XFILLER_0_14_109 VGND VGND VPWR VPWR sky130_fd_sc_hd__decap_4
XFILLER_0_22_175 VPWR VGND VPWR VGND sky130_ef_sc_hd__decap_12
X_4240_ _1388_ _1391_ _1396_ VGND VGND VPWR VPWR _1397_ sky130_fd_sc_hd__a21oi_1
XFILLER_0_22_197 VGND VGND VPWR VPWR sky130_fd_sc_hd__decap_3
X_4171_ _1331_ u_pe_array.g_pe_row\[3\].g_pe_col\[1\].u_pe.psum_out\[3\] _1106_ VGND
+ VGND VPWR VPWR _1333_ sky130_fd_sc_hd__and3_1
XFILLER_0_93_57 VPWR VGND VPWR VGND sky130_ef_sc_hd__decap_12
X_7930_ clknet_leaf_78_clk _0835_ VGND VGND VPWR VPWR u_pe_array.u_fifo1.buffer\[5\]\[2\]
+ sky130_fd_sc_hd__dfxtp_1
X_7861_ clknet_leaf_99_clk _0766_ VGND VGND VPWR VPWR u_pe_array.u_fifo2.buffer\[4\]\[1\]
+ sky130_fd_sc_hd__dfxtp_1
XFILLER_0_26_62 VGND VGND VPWR VPWR sky130_fd_sc_hd__fill_2
XFILLER_0_77_337 VGND VGND VPWR VPWR sky130_fd_sc_hd__decap_8
X_6812_ net720 _3376_ _3378_ VGND VGND VPWR VPWR _0736_ sky130_fd_sc_hd__a21oi_1
X_7792_ clknet_leaf_56_clk net235 net74 VGND VGND VPWR VPWR u_pe_array.g_pe_row\[0\].g_pe_col\[0\].u_pe.act_val\[0\]
+ sky130_fd_sc_hd__dfrtp_2
XFILLER_0_9_125 VPWR VGND VPWR VGND sky130_ef_sc_hd__decap_12
X_6743_ _3317_ _3324_ _3325_ _3326_ VGND VGND VPWR VPWR _3327_ sky130_fd_sc_hd__a31o_1
XFILLER_0_58_595 VGND VGND VPWR VPWR sky130_fd_sc_hd__fill_1
X_3955_ net833 _1167_ _1169_ _1171_ VGND VGND VPWR VPWR _0086_ sky130_fd_sc_hd__a22o_1
X_6674_ _3260_ VGND VGND VPWR VPWR _3264_ sky130_fd_sc_hd__inv_2
XFILLER_0_42_94 VGND VGND VPWR VPWR sky130_fd_sc_hd__fill_2
XFILLER_0_116_645 VPWR VGND VPWR VGND sky130_ef_sc_hd__decap_12
XFILLER_0_115_111 VGND VGND VPWR VPWR sky130_fd_sc_hd__fill_1
X_3886_ u_pe_array.g_pe_row\[3\].g_pe_col\[2\].u_pe.psum_out\[3\] _1108_ _1110_ _1127_
+ VGND VGND VPWR VPWR _1128_ sky130_fd_sc_hd__o211a_1
X_5625_ _2233_ _2466_ _2467_ _2173_ net681 VGND VGND VPWR VPWR _0460_ sky130_fd_sc_hd__a32o_1
XFILLER_0_84_3 VPWR VGND VPWR VGND sky130_ef_sc_hd__decap_12
XFILLER_0_26_492 VGND VGND VPWR VPWR sky130_fd_sc_hd__fill_2
XFILLER_0_13_142 VGND VGND VPWR VPWR sky130_fd_sc_hd__decap_8
XFILLER_0_5_375 VGND VGND VPWR VPWR sky130_fd_sc_hd__fill_1
XFILLER_0_14_643 VGND VGND VPWR VPWR sky130_fd_sc_hd__fill_1
XFILLER_0_14_676 VPWR VGND VPWR VGND sky130_ef_sc_hd__decap_12
X_5556_ _2390_ _2391_ VGND VGND VPWR VPWR _2405_ sky130_fd_sc_hd__nand2_1
X_4507_ net177 _1301_ _1305_ _1601_ VGND VGND VPWR VPWR _0208_ sky130_fd_sc_hd__a22o_1
X_5487_ _2320_ _2349_ _2350_ _2343_ net894 VGND VGND VPWR VPWR _0439_ sky130_fd_sc_hd__a32o_1
XFILLER_0_111_372 VGND VGND VPWR VPWR sky130_fd_sc_hd__decap_8
X_7226_ clknet_leaf_8_clk net122 net950 VGND VGND VPWR VPWR u_pe_array.g_pe_row\[3\].g_pe_col\[1\].u_pe.move_reg\[7\]
+ sky130_fd_sc_hd__dfrtp_1
X_4438_ _1524_ _1533_ VGND VGND VPWR VPWR _1543_ sky130_fd_sc_hd__and2b_1
XFILLER_0_6_83 VGND VGND VPWR VPWR sky130_fd_sc_hd__fill_1
X_7157_ clknet_leaf_16_clk _0063_ net943 VGND VGND VPWR VPWR u_pe_array.act_from_right\[13\]\[5\]
+ sky130_fd_sc_hd__dfrtp_1
X_4369_ u_pe_array.act_from_up\[12\]\[10\] _1310_ _1175_ net204 VGND VGND VPWR VPWR
+ _0189_ sky130_fd_sc_hd__a22o_1
X_6108_ u_pe_array.g_pe_row\[0\].g_pe_col\[3\].u_pe.psum_out\[2\] u_pe_array.g_pe_row\[0\].g_pe_col\[3\].u_pe.act_val\[2\]
+ _2844_ VGND VGND VPWR VPWR _2848_ sky130_fd_sc_hd__mux2_1
XTAP_392 VGND VPWR sky130_fd_sc_hd__tapvpwrvgnd_1
XTAP_381 VGND VPWR sky130_fd_sc_hd__tapvpwrvgnd_1
XTAP_370 VGND VPWR sky130_fd_sc_hd__tapvpwrvgnd_1
X_7088_ _3541_ VGND VGND VPWR VPWR _0849_ sky130_fd_sc_hd__clkbuf_1
X_6039_ _2766_ _2767_ _2776_ _2778_ VGND VGND VPWR VPWR _2790_ sky130_fd_sc_hd__o22a_1
XTAP_1514 VGND VPWR sky130_fd_sc_hd__tapvpwrvgnd_1
XTAP_1503 VGND VPWR sky130_fd_sc_hd__tapvpwrvgnd_1
XFILLER_0_96_624 VGND VGND VPWR VPWR sky130_fd_sc_hd__decap_3
XFILLER_0_95_123 VGND VGND VPWR VPWR sky130_fd_sc_hd__fill_1
XFILLER_0_83_90 VGND VGND VPWR VPWR sky130_fd_sc_hd__decap_6
XPHY_21 VGND VGND VPWR VPWR sky130_fd_sc_hd__decap_3
XPHY_10 VGND VGND VPWR VPWR sky130_fd_sc_hd__decap_3
XTAP_1547 VGND VPWR sky130_fd_sc_hd__tapvpwrvgnd_1
XTAP_1536 VGND VPWR sky130_fd_sc_hd__tapvpwrvgnd_1
XTAP_1525 VGND VPWR sky130_fd_sc_hd__tapvpwrvgnd_1
XFILLER_0_96_679 VPWR VGND VPWR VGND sky130_ef_sc_hd__decap_12
XFILLER_0_95_167 VGND VGND VPWR VPWR sky130_fd_sc_hd__fill_1
XPHY_32 VGND VGND VPWR VPWR sky130_fd_sc_hd__decap_3
XPHY_43 VGND VGND VPWR VPWR sky130_fd_sc_hd__decap_3
XPHY_54 VGND VGND VPWR VPWR sky130_fd_sc_hd__decap_3
XPHY_65 VGND VGND VPWR VPWR sky130_fd_sc_hd__decap_3
XTAP_1569 VGND VPWR sky130_fd_sc_hd__tapvpwrvgnd_1
XTAP_1558 VGND VPWR sky130_fd_sc_hd__tapvpwrvgnd_1
XPHY_76 VGND VGND VPWR VPWR sky130_fd_sc_hd__decap_3
XPHY_87 VGND VGND VPWR VPWR sky130_fd_sc_hd__decap_3
XPHY_98 VGND VGND VPWR VPWR sky130_fd_sc_hd__decap_3
XFILLER_0_49_573 VGND VGND VPWR VPWR sky130_fd_sc_hd__fill_2
XFILLER_0_36_212 VGND VGND VPWR VPWR sky130_fd_sc_hd__decap_3
XFILLER_0_8_191 VGND VGND VPWR VPWR sky130_fd_sc_hd__decap_4
XFILLER_0_24_429 VGND VGND VPWR VPWR sky130_fd_sc_hd__decap_8
XFILLER_0_51_215 VGND VGND VPWR VPWR sky130_fd_sc_hd__decap_3
XFILLER_0_106_188 VGND VGND VPWR VPWR sky130_fd_sc_hd__fill_1
XFILLER_0_51_259 VGND VGND VPWR VPWR sky130_fd_sc_hd__fill_1
XFILLER_0_20_657 VGND VGND VPWR VPWR sky130_fd_sc_hd__fill_1
XFILLER_0_74_307 VGND VGND VPWR VPWR sky130_fd_sc_hd__fill_1
X_3740_ u_pe_array.g_pe_row\[3\].g_pe_col\[3\].u_pe.act_val\[2\] u_pe_array.g_pe_row\[3\].g_pe_col\[3\].u_pe.w_out\[0\]
+ VGND VGND VPWR VPWR _0998_ sky130_fd_sc_hd__nand2_1
Xclkbuf_leaf_106_clk clknet_3_0__leaf_clk VGND VGND VPWR VPWR clknet_leaf_106_clk
+ sky130_fd_sc_hd__clkbuf_16
XFILLER_0_103_55 VGND VGND VPWR VPWR sky130_fd_sc_hd__fill_1
XFILLER_0_12_53 VPWR VGND VPWR VGND sky130_ef_sc_hd__decap_12
XFILLER_0_6_139 VGND VGND VPWR VPWR sky130_fd_sc_hd__fill_1
X_3671_ u_pe_array.g_pe_row\[3\].g_pe_col\[3\].u_pe.psum_out\[4\] u_pe_array.g_pe_row\[3\].g_pe_col\[3\].u_pe.act_val\[4\]
+ _0947_ VGND VGND VPWR VPWR _0953_ sky130_fd_sc_hd__mux2_1
XFILLER_0_42_215 VGND VGND VPWR VPWR sky130_fd_sc_hd__fill_1
XFILLER_0_113_637 VPWR VGND VPWR VGND sky130_ef_sc_hd__decap_12
X_5410_ net83 _2294_ _2273_ VGND VGND VPWR VPWR _2295_ sky130_fd_sc_hd__mux2_1
X_6390_ _3056_ _3057_ VGND VGND VPWR VPWR _3058_ sky130_fd_sc_hd__and2_1
X_5341_ _2237_ _2238_ VGND VGND VPWR VPWR _2239_ sky130_fd_sc_hd__and2_1
XFILLER_0_23_473 VGND VGND VPWR VPWR sky130_fd_sc_hd__decap_6
X_5272_ u_pe_array.g_pe_row\[1\].g_pe_col\[3\].u_pe.psum_out\[2\] u_pe_array.g_pe_row\[1\].g_pe_col\[3\].u_pe.act_val\[2\]
+ _1423_ VGND VGND VPWR VPWR _2176_ sky130_fd_sc_hd__and3_1
X_7011_ _3498_ VGND VGND VPWR VPWR _3499_ sky130_fd_sc_hd__buf_2
X_4223_ u_pe_array.g_pe_row\[3\].g_pe_col\[1\].u_pe.psum_out\[7\] _1106_ VGND VGND
+ VPWR VPWR _1381_ sky130_fd_sc_hd__or2_1
X_4154_ u_pe_array.g_pe_row\[3\].g_pe_col\[1\].u_pe.act_val\[1\] u_pe_array.g_pe_row\[3\].g_pe_col\[1\].u_pe.w_out\[0\]
+ _1315_ _1316_ VGND VGND VPWR VPWR _1318_ sky130_fd_sc_hd__a22o_1
X_4085_ net915 _1273_ _1279_ _1021_ VGND VGND VPWR VPWR _0108_ sky130_fd_sc_hd__a22o_1
XFILLER_0_37_61 VGND VGND VPWR VPWR sky130_fd_sc_hd__fill_1
XFILLER_0_78_602 VGND VGND VPWR VPWR sky130_fd_sc_hd__fill_1
X_7913_ clknet_leaf_77_clk _0818_ VGND VGND VPWR VPWR u_pe_array.u_fifo1.buffer\[2\]\[3\]
+ sky130_fd_sc_hd__dfxtp_1
XFILLER_0_77_101 VGND VGND VPWR VPWR sky130_fd_sc_hd__decap_8
X_7844_ clknet_leaf_100_clk _0749_ VGND VGND VPWR VPWR u_pe_array.u_fifo2.buffer\[1\]\[2\]
+ sky130_fd_sc_hd__dfxtp_1
XFILLER_0_92_115 VGND VGND VPWR VPWR sky130_fd_sc_hd__fill_1
X_7775_ clknet_leaf_51_clk _0681_ net946 VGND VGND VPWR VPWR u_pe_array.g_pe_row\[0\].g_pe_col\[1\].u_pe.psum_out\[12\]
+ sky130_fd_sc_hd__dfrtp_1
X_4987_ _1965_ _1966_ VGND VGND VPWR VPWR _1967_ sky130_fd_sc_hd__nand2_1
X_6726_ _3306_ _3311_ VGND VGND VPWR VPWR _3312_ sky130_fd_sc_hd__or2_1
X_3938_ _1135_ net906 _1159_ VGND VGND VPWR VPWR _1165_ sky130_fd_sc_hd__mux2_1
XFILLER_0_61_502 VGND VGND VPWR VPWR sky130_fd_sc_hd__fill_2
XFILLER_0_116_464 VGND VGND VPWR VPWR sky130_fd_sc_hd__decap_4
X_6657_ u_pe_array.g_pe_row\[0\].g_pe_col\[0\].u_pe.act_val\[1\] _2486_ _3247_ VGND
+ VGND VPWR VPWR _3249_ sky130_fd_sc_hd__nand3_1
XFILLER_0_6_662 VPWR VGND VPWR VGND sky130_ef_sc_hd__decap_12
X_3869_ u_pe_array.g_pe_row\[3\].g_pe_col\[2\].u_pe.psum_out\[0\] _1108_ _1110_ _1113_
+ VGND VGND VPWR VPWR _1114_ sky130_fd_sc_hd__o211a_1
XFILLER_0_33_237 VGND VGND VPWR VPWR sky130_fd_sc_hd__decap_6
XFILLER_0_116_475 VGND VGND VPWR VPWR sky130_fd_sc_hd__fill_1
X_6588_ u_pe_array.g_pe_row\[0\].g_pe_col\[1\].u_pe.psum_out\[10\] _2268_ VGND VGND
+ VPWR VPWR _3212_ sky130_fd_sc_hd__or2_1
XFILLER_0_61_568 VGND VGND VPWR VPWR sky130_fd_sc_hd__decap_6
XFILLER_0_5_161 VGND VGND VPWR VPWR sky130_fd_sc_hd__decap_6
X_5608_ _2415_ _2426_ _2427_ VGND VGND VPWR VPWR _2452_ sky130_fd_sc_hd__o21bai_1
XFILLER_0_103_147 VGND VGND VPWR VPWR sky130_fd_sc_hd__fill_1
X_5539_ u_pe_array.g_pe_row\[1\].g_pe_col\[2\].u_pe.psum_out\[2\] _2388_ VGND VGND
+ VPWR VPWR _2389_ sky130_fd_sc_hd__xnor2_1
XFILLER_0_103_158 VGND VGND VPWR VPWR sky130_fd_sc_hd__decap_8
XFILLER_0_112_681 VPWR VGND VPWR VGND sky130_ef_sc_hd__decap_12
XFILLER_0_111_191 VGND VGND VPWR VPWR sky130_fd_sc_hd__fill_2
X_7209_ clknet_leaf_35_clk _0115_ net942 VGND VGND VPWR VPWR u_pe_array.act_from_down\[9\]\[3\]
+ sky130_fd_sc_hd__dfrtp_1
XFILLER_0_96_421 VGND VGND VPWR VPWR sky130_fd_sc_hd__fill_1
XTAP_1322 VGND VPWR sky130_fd_sc_hd__tapvpwrvgnd_1
XTAP_1311 VGND VPWR sky130_fd_sc_hd__tapvpwrvgnd_1
XTAP_1300 VGND VPWR sky130_fd_sc_hd__tapvpwrvgnd_1
XTAP_1366 VGND VPWR sky130_fd_sc_hd__tapvpwrvgnd_1
XTAP_1355 VGND VPWR sky130_fd_sc_hd__tapvpwrvgnd_1
XTAP_1344 VGND VPWR sky130_fd_sc_hd__tapvpwrvgnd_1
XTAP_1333 VGND VPWR sky130_fd_sc_hd__tapvpwrvgnd_1
XFILLER_0_68_178 VGND VGND VPWR VPWR sky130_fd_sc_hd__decap_4
XFILLER_0_37_510 VPWR VGND VPWR VGND sky130_ef_sc_hd__decap_12
XTAP_1399 VGND VPWR sky130_fd_sc_hd__tapvpwrvgnd_1
XTAP_1388 VGND VPWR sky130_fd_sc_hd__tapvpwrvgnd_1
XTAP_1377 VGND VPWR sky130_fd_sc_hd__tapvpwrvgnd_1
XFILLER_0_77_690 VPWR VGND VPWR VGND sky130_ef_sc_hd__decap_12
Xinput28 w_in_flat[1] VGND VGND VPWR VPWR net28 sky130_fd_sc_hd__clkbuf_1
Xinput17 v_in0[2] VGND VGND VPWR VPWR net17 sky130_fd_sc_hd__clkbuf_1
XFILLER_0_91_192 VGND VGND VPWR VPWR sky130_fd_sc_hd__fill_2
XFILLER_0_52_579 VGND VGND VPWR VPWR sky130_fd_sc_hd__fill_1
XFILLER_0_58_27 VGND VGND VPWR VPWR sky130_fd_sc_hd__fill_1
XFILLER_0_20_421 VGND VGND VPWR VPWR sky130_fd_sc_hd__decap_8
XFILLER_0_99_281 VPWR VGND VPWR VGND sky130_ef_sc_hd__decap_12
XFILLER_0_87_421 VGND VGND VPWR VPWR sky130_fd_sc_hd__fill_2
X_4910_ u_pe_array.g_pe_row\[2\].g_pe_col\[1\].u_pe.act_val\[0\] _1888_ _1105_ VGND
+ VGND VPWR VPWR _1896_ sky130_fd_sc_hd__a21bo_1
XFILLER_0_87_443 VGND VGND VPWR VPWR sky130_fd_sc_hd__decap_4
XFILLER_0_75_605 VGND VGND VPWR VPWR sky130_fd_sc_hd__decap_8
X_5890_ _2636_ net874 _1158_ VGND VGND VPWR VPWR _2671_ sky130_fd_sc_hd__mux2_1
XFILLER_0_59_134 VGND VGND VPWR VPWR sky130_fd_sc_hd__decap_8
XFILLER_0_87_498 VGND VGND VPWR VPWR sky130_fd_sc_hd__decap_6
XFILLER_0_59_167 VGND VGND VPWR VPWR sky130_fd_sc_hd__fill_1
X_4841_ _1850_ _1852_ _1857_ VGND VGND VPWR VPWR _1859_ sky130_fd_sc_hd__or3_1
XFILLER_0_47_318 VGND VGND VPWR VPWR sky130_fd_sc_hd__decap_8
XFILLER_0_114_65 VPWR VGND VPWR VGND sky130_ef_sc_hd__decap_12
XFILLER_0_28_521 VGND VGND VPWR VPWR sky130_fd_sc_hd__decap_8
XFILLER_0_117_217 VGND VGND VPWR VPWR sky130_fd_sc_hd__decap_6
X_7560_ clknet_leaf_45_clk _0466_ net947 VGND VGND VPWR VPWR u_pe_array.act_from_down\[1\]\[0\]
+ sky130_fd_sc_hd__dfrtp_1
X_4772_ _1794_ _1795_ VGND VGND VPWR VPWR _1796_ sky130_fd_sc_hd__xnor2_1
X_6511_ u_pe_array.g_pe_row\[0\].g_pe_col\[1\].u_pe.act_val\[2\] u_pe_array.g_pe_row\[0\].g_pe_col\[1\].u_pe.w_out\[0\]
+ _3128_ VGND VGND VPWR VPWR _3142_ sky130_fd_sc_hd__and3_1
X_7491_ clknet_leaf_38_clk _0397_ net951 VGND VGND VPWR VPWR u_pe_array.g_pe_row\[1\].g_pe_col\[3\].u_pe.psum_out\[0\]
+ sky130_fd_sc_hd__dfrtp_1
X_3723_ u_fsm.state\[0\] _0860_ VGND VGND VPWR VPWR _0983_ sky130_fd_sc_hd__nor2_8
X_6442_ _0946_ VGND VGND VPWR VPWR _3102_ sky130_fd_sc_hd__clkbuf_16
X_3654_ _0939_ VGND VGND VPWR VPWR _0940_ sky130_fd_sc_hd__buf_8
XFILLER_0_15_259 VGND VGND VPWR VPWR sky130_fd_sc_hd__decap_4
XFILLER_0_113_478 VGND VGND VPWR VPWR sky130_fd_sc_hd__fill_1
XFILLER_0_101_629 VGND VGND VPWR VPWR sky130_fd_sc_hd__decap_6
XFILLER_0_3_665 VGND VGND VPWR VPWR sky130_fd_sc_hd__decap_6
XFILLER_0_2_153 VPWR VGND VPWR VGND sky130_ef_sc_hd__decap_12
X_3585_ _0889_ VGND VGND VPWR VPWR _0001_ sky130_fd_sc_hd__clkbuf_1
X_6373_ net875 _2586_ _3042_ _0978_ VGND VGND VPWR VPWR _0633_ sky130_fd_sc_hd__a22o_1
XFILLER_0_100_128 VPWR VGND VPWR VGND sky130_ef_sc_hd__decap_12
X_5324_ _2220_ _2222_ VGND VGND VPWR VPWR _2224_ sky130_fd_sc_hd__nand2_1
XFILLER_0_2_197 VPWR VGND VPWR VGND sky130_ef_sc_hd__decap_12
X_5255_ u_pe_array.g_pe_row\[1\].g_pe_col\[3\].u_pe.act_val\[0\] _1423_ u_pe_array.g_pe_row\[1\].g_pe_col\[3\].u_pe.psum_out\[0\]
+ VGND VGND VPWR VPWR _2161_ sky130_fd_sc_hd__a21o_1
X_4206_ _1364_ _1365_ VGND VGND VPWR VPWR _1366_ sky130_fd_sc_hd__xnor2_1
XFILLER_0_47_3 VGND VGND VPWR VPWR sky130_fd_sc_hd__decap_3
X_5186_ u_pe_array.g_pe_row\[2\].g_pe_col\[0\].u_pe.psum_out\[11\] _2121_ _2112_ VGND
+ VGND VPWR VPWR _2122_ sky130_fd_sc_hd__mux2_1
X_4137_ u_pe_array.g_pe_row\[3\].g_pe_col\[1\].u_pe.act_val\[5\] _1301_ _1305_ net748
+ VGND VGND VPWR VPWR _0130_ sky130_fd_sc_hd__a22o_1
XFILLER_0_3_51 VGND VGND VPWR VPWR sky130_fd_sc_hd__decap_4
XFILLER_0_78_421 VGND VGND VPWR VPWR sky130_fd_sc_hd__decap_4
X_4068_ _1033_ _1263_ _1264_ _0986_ net899 VGND VGND VPWR VPWR _0106_ sky130_fd_sc_hd__a32o_1
Xwire63 _0930_ VGND VGND VPWR VPWR net63 sky130_fd_sc_hd__buf_4
X_7827_ clknet_leaf_87_clk _0732_ net948 VGND VGND VPWR VPWR u_pe_array.u_fifo2.wr_ptr\[3\]
+ sky130_fd_sc_hd__dfrtp_1
XFILLER_0_38_307 VGND VGND VPWR VPWR sky130_fd_sc_hd__fill_1
XFILLER_0_38_329 VGND VGND VPWR VPWR sky130_fd_sc_hd__decap_8
X_7758_ clknet_leaf_44_clk net367 net947 VGND VGND VPWR VPWR u_pe_array.g_pe_row\[0\].g_pe_col\[1\].u_pe.move_reg\[8\]
+ sky130_fd_sc_hd__dfrtp_1
X_6709_ _3286_ VGND VGND VPWR VPWR _3296_ sky130_fd_sc_hd__inv_2
X_7689_ clknet_leaf_57_clk _0595_ net74 VGND VGND VPWR VPWR u_pe_array.g_pe_row\[0\].g_pe_col\[3\].u_pe.psum_out\[8\]
+ sky130_fd_sc_hd__dfrtp_2
XFILLER_0_74_682 VGND VGND VPWR VPWR sky130_fd_sc_hd__fill_2
XFILLER_0_61_310 VGND VGND VPWR VPWR sky130_fd_sc_hd__decap_4
XFILLER_0_19_598 VGND VGND VPWR VPWR sky130_fd_sc_hd__fill_2
XFILLER_0_6_481 VGND VGND VPWR VPWR sky130_fd_sc_hd__fill_1
XFILLER_0_69_410 VGND VGND VPWR VPWR sky130_fd_sc_hd__fill_1
XFILLER_0_96_262 VGND VGND VPWR VPWR sky130_fd_sc_hd__fill_2
XFILLER_0_84_413 VGND VGND VPWR VPWR sky130_fd_sc_hd__decap_6
XTAP_1141 VGND VPWR sky130_fd_sc_hd__tapvpwrvgnd_1
XTAP_1130 VGND VPWR sky130_fd_sc_hd__tapvpwrvgnd_1
XTAP_1174 VGND VPWR sky130_fd_sc_hd__tapvpwrvgnd_1
XTAP_1152 VGND VPWR sky130_fd_sc_hd__tapvpwrvgnd_1
XTAP_1163 VGND VPWR sky130_fd_sc_hd__tapvpwrvgnd_1
XTAP_1196 VGND VPWR sky130_fd_sc_hd__tapvpwrvgnd_1
XTAP_1185 VGND VPWR sky130_fd_sc_hd__tapvpwrvgnd_1
XFILLER_0_72_608 VGND VGND VPWR VPWR sky130_fd_sc_hd__decap_8
XFILLER_0_25_502 VGND VGND VPWR VPWR sky130_fd_sc_hd__fill_2
XFILLER_0_25_524 VPWR VGND VPWR VGND sky130_ef_sc_hd__decap_12
XFILLER_0_92_490 VGND VGND VPWR VPWR sky130_fd_sc_hd__fill_1
XFILLER_0_8_29 VPWR VGND VPWR VGND sky130_ef_sc_hd__decap_12
XFILLER_0_4_418 VGND VGND VPWR VPWR sky130_fd_sc_hd__fill_2
XFILLER_0_52_321 VGND VGND VPWR VPWR sky130_fd_sc_hd__fill_1
XFILLER_0_52_343 VPWR VGND VPWR VGND sky130_ef_sc_hd__decap_12
Xhold609 u_pe_array.u_fifo2.buffer\[3\]\[2\] VGND VGND VPWR VPWR net683 sky130_fd_sc_hd__dlygate4sd3_1
XFILLER_0_52_365 VGND VGND VPWR VPWR sky130_fd_sc_hd__fill_1
XFILLER_0_20_240 VGND VGND VPWR VPWR sky130_fd_sc_hd__fill_2
XTAP_925 VGND VPWR sky130_fd_sc_hd__tapvpwrvgnd_1
XFILLER_0_0_657 VPWR VGND VPWR VGND sky130_ef_sc_hd__decap_12
XTAP_914 VGND VPWR sky130_fd_sc_hd__tapvpwrvgnd_1
XTAP_903 VGND VPWR sky130_fd_sc_hd__tapvpwrvgnd_1
X_5040_ net773 _2006_ _1735_ _2007_ VGND VGND VPWR VPWR _0335_ sky130_fd_sc_hd__a22o_1
XTAP_958 VGND VPWR sky130_fd_sc_hd__tapvpwrvgnd_1
XTAP_947 VGND VPWR sky130_fd_sc_hd__tapvpwrvgnd_1
XTAP_936 VGND VPWR sky130_fd_sc_hd__tapvpwrvgnd_1
XFILLER_0_85_69 VGND VGND VPWR VPWR sky130_fd_sc_hd__decap_4
XTAP_969 VGND VPWR sky130_fd_sc_hd__tapvpwrvgnd_1
XFILLER_0_18_41 VPWR VGND VPWR VGND sky130_ef_sc_hd__decap_12
XFILLER_0_79_207 VGND VGND VPWR VPWR sky130_fd_sc_hd__fill_1
X_6991_ net560 _3358_ _3484_ VGND VGND VPWR VPWR _3488_ sky130_fd_sc_hd__mux2_1
X_5942_ u_pe_array.u_fifo1.buffer\[0\]\[3\] _2678_ VGND VGND VPWR VPWR _2709_ sky130_fd_sc_hd__or2_1
XFILLER_0_48_605 VPWR VGND VPWR VGND sky130_ef_sc_hd__decap_12
X_5873_ _2659_ VGND VGND VPWR VPWR _0516_ sky130_fd_sc_hd__clkbuf_1
XFILLER_0_75_457 VGND VGND VPWR VPWR sky130_fd_sc_hd__fill_1
XFILLER_0_7_223 VGND VGND VPWR VPWR sky130_fd_sc_hd__fill_1
X_7612_ clknet_leaf_79_clk _0518_ net948 VGND VGND VPWR VPWR net38 sky130_fd_sc_hd__dfrtp_1
X_4824_ _1834_ _1837_ _1842_ VGND VGND VPWR VPWR _1844_ sky130_fd_sc_hd__or3_1
XFILLER_0_118_559 VGND VGND VPWR VPWR sky130_fd_sc_hd__fill_1
X_7543_ clknet_leaf_70_clk net109 net72 VGND VGND VPWR VPWR u_pe_array.g_pe_row\[1\].g_pe_col\[2\].u_pe.move_reg\[11\]
+ sky130_fd_sc_hd__dfrtp_1
XFILLER_0_7_256 VGND VGND VPWR VPWR sky130_fd_sc_hd__decap_8
X_4755_ _1779_ _1780_ VGND VGND VPWR VPWR _1781_ sky130_fd_sc_hd__or2b_1
X_3706_ _0971_ VGND VGND VPWR VPWR _0037_ sky130_fd_sc_hd__clkbuf_1
X_7474_ clknet_leaf_42_clk _0380_ net946 VGND VGND VPWR VPWR u_pe_array.act_from_down\[3\]\[9\]
+ sky130_fd_sc_hd__dfrtp_1
X_4686_ net676 _1732_ _1735_ _1738_ VGND VGND VPWR VPWR _0250_ sky130_fd_sc_hd__a22o_1
XFILLER_0_31_505 VGND VGND VPWR VPWR sky130_fd_sc_hd__decap_4
XFILLER_0_43_387 VGND VGND VPWR VPWR sky130_fd_sc_hd__decap_4
XFILLER_0_70_195 VGND VGND VPWR VPWR sky130_fd_sc_hd__fill_1
X_3637_ _0926_ net675 _0918_ VGND VGND VPWR VPWR _0927_ sky130_fd_sc_hd__mux2_1
X_6425_ u_pe_array.g_pe_row\[0\].g_pe_col\[2\].u_pe.psum_out\[10\] _3075_ _3082_ _3086_
+ VGND VGND VPWR VPWR _3089_ sky130_fd_sc_hd__a2bb2o_1
XFILLER_0_11_251 VGND VGND VPWR VPWR sky130_fd_sc_hd__decap_4
XFILLER_0_3_473 VPWR VGND VPWR VGND sky130_ef_sc_hd__decap_12
X_3568_ _0864_ _0869_ _0875_ VGND VGND VPWR VPWR _0876_ sky130_fd_sc_hd__o21ai_1
X_6356_ _3025_ _3026_ VGND VGND VPWR VPWR _3027_ sky130_fd_sc_hd__and2_1
X_5307_ _2196_ net66 _2206_ _2207_ VGND VGND VPWR VPWR _2208_ sky130_fd_sc_hd__o211a_1
XFILLER_0_11_262 VGND VGND VPWR VPWR sky130_fd_sc_hd__fill_1
X_6287_ u_pe_array.g_pe_row\[0\].g_pe_col\[2\].u_pe.psum_out\[7\] u_pe_array.g_pe_row\[0\].g_pe_col\[2\].u_pe.move_reg\[7\]
+ _2844_ VGND VGND VPWR VPWR _2981_ sky130_fd_sc_hd__mux2_1
X_5238_ u_pe_array.g_pe_row\[1\].g_pe_col\[3\].u_pe.act_val\[4\] _2143_ _2132_ _2152_
+ VGND VGND VPWR VPWR _0388_ sky130_fd_sc_hd__a22o_1
X_5169_ _2097_ _2104_ _2105_ _2106_ VGND VGND VPWR VPWR _2107_ sky130_fd_sc_hd__a31o_1
Xclkbuf_leaf_95_clk clknet_3_1__leaf_clk VGND VGND VPWR VPWR clknet_leaf_95_clk sky130_fd_sc_hd__clkbuf_16
XFILLER_0_78_262 VGND VGND VPWR VPWR sky130_fd_sc_hd__decap_6
XFILLER_0_66_402 VGND VGND VPWR VPWR sky130_fd_sc_hd__decap_4
XPHY_224 VGND VGND VPWR VPWR sky130_fd_sc_hd__decap_3
XPHY_213 VGND VGND VPWR VPWR sky130_fd_sc_hd__decap_3
XPHY_202 VGND VGND VPWR VPWR sky130_fd_sc_hd__decap_3
XPHY_235 VGND VGND VPWR VPWR sky130_fd_sc_hd__decap_3
XFILLER_0_54_608 VGND VGND VPWR VPWR sky130_fd_sc_hd__decap_8
XFILLER_0_46_170 VGND VGND VPWR VPWR sky130_fd_sc_hd__fill_1
XFILLER_0_47_671 VGND VGND VPWR VPWR sky130_fd_sc_hd__fill_1
XFILLER_0_47_693 VPWR VGND VPWR VGND sky130_ef_sc_hd__decap_12
XFILLER_0_53_107 VGND VGND VPWR VPWR sky130_fd_sc_hd__decap_4
XFILLER_0_117_581 VPWR VGND VPWR VGND sky130_ef_sc_hd__decap_12
XFILLER_0_61_140 VGND VGND VPWR VPWR sky130_fd_sc_hd__decap_3
XFILLER_0_34_365 VGND VGND VPWR VPWR sky130_fd_sc_hd__decap_8
XFILLER_0_104_253 VGND VGND VPWR VPWR sky130_fd_sc_hd__decap_8
XFILLER_0_100_470 VGND VGND VPWR VPWR sky130_fd_sc_hd__decap_6
Xhold6 _0344_ VGND VGND VPWR VPWR net80 sky130_fd_sc_hd__dlygate4sd3_1
XFILLER_0_89_505 VGND VGND VPWR VPWR sky130_fd_sc_hd__decap_4
Xclkbuf_leaf_86_clk clknet_3_4__leaf_clk VGND VGND VPWR VPWR clknet_leaf_86_clk sky130_fd_sc_hd__clkbuf_16
XFILLER_0_57_446 VGND VGND VPWR VPWR sky130_fd_sc_hd__fill_2
XFILLER_0_57_435 VGND VGND VPWR VPWR sky130_fd_sc_hd__fill_1
XFILLER_0_72_405 VGND VGND VPWR VPWR sky130_fd_sc_hd__decap_8
XFILLER_0_53_652 VGND VGND VPWR VPWR sky130_fd_sc_hd__decap_6
XFILLER_0_25_321 VGND VGND VPWR VPWR sky130_fd_sc_hd__decap_4
XFILLER_0_111_55 VGND VGND VPWR VPWR sky130_fd_sc_hd__fill_1
X_4540_ net360 _1310_ _1483_ net365 VGND VGND VPWR VPWR _0228_ sky130_fd_sc_hd__a22o_1
Xclkbuf_leaf_10_clk clknet_3_1__leaf_clk VGND VGND VPWR VPWR clknet_leaf_10_clk sky130_fd_sc_hd__clkbuf_16
Xhold406 u_pe_array.g_pe_row\[2\].g_pe_col\[0\].u_pe.move_reg\[7\] VGND VGND VPWR
+ VPWR net480 sky130_fd_sc_hd__dlygate4sd3_1
Xhold417 u_pe_array.act_from_up\[12\]\[2\] VGND VGND VPWR VPWR net491 sky130_fd_sc_hd__dlygate4sd3_1
X_4471_ _1562_ _1570_ _1571_ _1572_ VGND VGND VPWR VPWR _1573_ sky130_fd_sc_hd__a31o_1
XFILLER_0_110_223 VGND VGND VPWR VPWR sky130_fd_sc_hd__fill_1
Xhold428 u_pe_array.g_pe_row\[2\].g_pe_col\[1\].u_pe.psum_out\[2\] VGND VGND VPWR
+ VPWR net502 sky130_fd_sc_hd__dlygate4sd3_1
X_6210_ _2900_ _2909_ VGND VGND VPWR VPWR _2920_ sky130_fd_sc_hd__and2b_1
Xhold439 u_pe_array.g_pe_row\[3\].g_pe_col\[3\].u_pe.psum_out\[0\] VGND VGND VPWR
+ VPWR net513 sky130_fd_sc_hd__dlygate4sd3_1
XFILLER_0_0_421 VPWR VGND VPWR VGND sky130_ef_sc_hd__decap_12
X_7190_ clknet_leaf_8_clk net262 net950 VGND VGND VPWR VPWR u_pe_array.g_pe_row\[3\].g_pe_col\[2\].u_pe.move_reg\[12\]
+ sky130_fd_sc_hd__dfrtp_1
XFILLER_0_96_57 VPWR VGND VPWR VGND sky130_ef_sc_hd__decap_12
X_6141_ net132 _2730_ _2511_ u_pe_array.g_pe_row\[0\].g_pe_col\[3\].u_pe.move_reg\[10\]
+ VGND VGND VPWR VPWR _0584_ sky130_fd_sc_hd__a22o_1
XTAP_700 VGND VPWR sky130_fd_sc_hd__tapvpwrvgnd_1
XTAP_711 VGND VPWR sky130_fd_sc_hd__tapvpwrvgnd_1
XTAP_722 VGND VPWR sky130_fd_sc_hd__tapvpwrvgnd_1
XTAP_733 VGND VPWR sky130_fd_sc_hd__tapvpwrvgnd_1
X_6072_ _2809_ _2817_ _2818_ _2819_ VGND VGND VPWR VPWR _2820_ sky130_fd_sc_hd__a31o_1
XTAP_755 VGND VPWR sky130_fd_sc_hd__tapvpwrvgnd_1
XTAP_744 VGND VPWR sky130_fd_sc_hd__tapvpwrvgnd_1
XTAP_766 VGND VPWR sky130_fd_sc_hd__tapvpwrvgnd_1
XTAP_777 VGND VPWR sky130_fd_sc_hd__tapvpwrvgnd_1
X_5023_ u_pe_array.g_pe_row\[0\].g_pe_col\[3\].u_pe.w_out\[0\] _1423_ _0931_ VGND
+ VGND VPWR VPWR _1998_ sky130_fd_sc_hd__mux2_1
Xclkbuf_leaf_77_clk clknet_3_5__leaf_clk VGND VGND VPWR VPWR clknet_leaf_77_clk sky130_fd_sc_hd__clkbuf_16
XTAP_788 VGND VPWR sky130_fd_sc_hd__tapvpwrvgnd_1
XTAP_799 VGND VPWR sky130_fd_sc_hd__tapvpwrvgnd_1
X_6974_ _3473_ u_pe_array.u_fifo1.count\[0\] u_pe_array.u_fifo1.count\[3\] _2341_
+ u_pe_array.u_fifo1.count\[1\] VGND VGND VPWR VPWR _3477_ sky130_fd_sc_hd__a41o_1
X_5925_ _2320_ _2693_ _2694_ _2343_ net730 VGND VGND VPWR VPWR _0533_ sky130_fd_sc_hd__a32o_1
XFILLER_0_8_521 VGND VGND VPWR VPWR sky130_fd_sc_hd__decap_8
X_5856_ net841 _2646_ _2273_ VGND VGND VPWR VPWR _2647_ sky130_fd_sc_hd__mux2_1
XFILLER_0_0_85 VPWR VGND VPWR VGND sky130_ef_sc_hd__decap_12
XFILLER_0_118_345 VGND VGND VPWR VPWR sky130_fd_sc_hd__fill_1
XFILLER_0_75_276 VGND VGND VPWR VPWR sky130_fd_sc_hd__decap_4
X_4807_ _1811_ _1812_ _1826_ _1827_ VGND VGND VPWR VPWR _1828_ sky130_fd_sc_hd__a31o_1
XFILLER_0_29_671 VGND VGND VPWR VPWR sky130_fd_sc_hd__fill_1
X_5787_ u_pe_array.g_pe_row\[1\].g_pe_col\[1\].u_pe.psum_out\[7\] VGND VGND VPWR VPWR
+ _2590_ sky130_fd_sc_hd__inv_2
XFILLER_0_106_529 VGND VGND VPWR VPWR sky130_fd_sc_hd__decap_3
XFILLER_0_106_507 VGND VGND VPWR VPWR sky130_fd_sc_hd__decap_6
XFILLER_0_28_192 VGND VGND VPWR VPWR sky130_fd_sc_hd__decap_4
XFILLER_0_90_279 VGND VGND VPWR VPWR sky130_fd_sc_hd__fill_1
X_7526_ clknet_leaf_68_clk _0432_ net72 VGND VGND VPWR VPWR u_pe_array.act_from_left\[7\]\[7\]
+ sky130_fd_sc_hd__dfrtp_1
X_4738_ _1763_ _1764_ VGND VGND VPWR VPWR _1765_ sky130_fd_sc_hd__xnor2_1
XFILLER_0_16_365 VGND VGND VPWR VPWR sky130_fd_sc_hd__fill_1
XFILLER_0_44_674 VGND VGND VPWR VPWR sky130_fd_sc_hd__fill_2
X_7457_ clknet_leaf_31_clk _0363_ net71 VGND VGND VPWR VPWR u_pe_array.g_pe_row\[2\].g_pe_col\[0\].u_pe.psum_out\[7\]
+ sky130_fd_sc_hd__dfrtp_4
X_4669_ net620 _1273_ _1725_ _1726_ VGND VGND VPWR VPWR _0245_ sky130_fd_sc_hd__a22o_1
XFILLER_0_3_281 VGND VGND VPWR VPWR sky130_fd_sc_hd__fill_2
X_6408_ _3073_ _3074_ net893 _1007_ VGND VGND VPWR VPWR _0636_ sky130_fd_sc_hd__a2bb2o_1
X_7388_ clknet_leaf_28_clk _0294_ net942 VGND VGND VPWR VPWR u_pe_array.act_from_right\[8\]\[5\]
+ sky130_fd_sc_hd__dfrtp_1
XFILLER_0_101_278 VGND VGND VPWR VPWR sky130_fd_sc_hd__fill_2
X_6339_ _3009_ _3010_ VGND VGND VPWR VPWR _3011_ sky130_fd_sc_hd__nor2_1
Xclkbuf_leaf_68_clk clknet_3_4__leaf_clk VGND VGND VPWR VPWR clknet_leaf_68_clk sky130_fd_sc_hd__clkbuf_16
XFILLER_0_86_519 VGND VGND VPWR VPWR sky130_fd_sc_hd__fill_1
XFILLER_0_39_413 VPWR VGND VPWR VGND sky130_ef_sc_hd__decap_12
XFILLER_0_109_312 VGND VGND VPWR VPWR sky130_fd_sc_hd__fill_2
XFILLER_0_54_416 VGND VGND VPWR VPWR sky130_fd_sc_hd__decap_4
XFILLER_0_81_268 VGND VGND VPWR VPWR sky130_fd_sc_hd__decap_4
XFILLER_0_34_195 VGND VGND VPWR VPWR sky130_fd_sc_hd__fill_1
XFILLER_0_35_696 VGND VGND VPWR VPWR sky130_fd_sc_hd__decap_8
XFILLER_0_105_584 VGND VGND VPWR VPWR sky130_fd_sc_hd__fill_1
XFILLER_0_10_508 VGND VGND VPWR VPWR sky130_fd_sc_hd__fill_1
XFILLER_0_50_655 VPWR VGND VPWR VGND sky130_ef_sc_hd__decap_12
XFILLER_0_66_27 VGND VGND VPWR VPWR sky130_fd_sc_hd__fill_1
Xclkbuf_leaf_59_clk clknet_3_7__leaf_clk VGND VGND VPWR VPWR clknet_leaf_59_clk sky130_fd_sc_hd__clkbuf_16
XFILLER_0_89_324 VGND VGND VPWR VPWR sky130_fd_sc_hd__fill_1
XFILLER_0_82_26 VGND VGND VPWR VPWR sky130_fd_sc_hd__fill_2
XFILLER_0_106_77 VGND VGND VPWR VPWR sky130_fd_sc_hd__decap_6
X_3971_ u_pe_array.g_pe_row\[3\].g_pe_col\[2\].u_pe.psum_out\[0\] u_pe_array.g_pe_row\[3\].g_pe_col\[2\].u_pe.act_val\[0\]
+ u_pe_array.g_pe_row\[3\].g_pe_col\[2\].u_pe.w_out\[0\] VGND VGND VPWR VPWR _1177_
+ sky130_fd_sc_hd__nand3_1
X_5710_ u_pe_array.g_pe_row\[1\].g_pe_col\[1\].u_pe.psum_out\[1\] _2518_ VGND VGND
+ VPWR VPWR _2520_ sky130_fd_sc_hd__nand2_1
X_6690_ u_pe_array.g_pe_row\[0\].g_pe_col\[0\].u_pe.act_val\[3\] _3246_ _3276_ _3277_
+ VGND VGND VPWR VPWR _3279_ sky130_fd_sc_hd__o22a_1
XFILLER_0_45_416 VGND VGND VPWR VPWR sky130_fd_sc_hd__decap_8
XFILLER_0_5_513 VGND VGND VPWR VPWR sky130_fd_sc_hd__decap_8
XFILLER_0_45_438 VGND VGND VPWR VPWR sky130_fd_sc_hd__decap_8
XFILLER_0_45_449 VGND VGND VPWR VPWR sky130_fd_sc_hd__decap_3
X_5641_ net805 _1904_ _2481_ _1726_ VGND VGND VPWR VPWR _0462_ sky130_fd_sc_hd__a22o_1
X_5572_ _2417_ _2418_ VGND VGND VPWR VPWR _2420_ sky130_fd_sc_hd__nand2_1
XFILLER_0_13_335 VGND VGND VPWR VPWR sky130_fd_sc_hd__fill_1
XFILLER_0_26_685 VPWR VGND VPWR VGND sky130_ef_sc_hd__decap_12
XFILLER_0_41_644 VPWR VGND VPWR VGND sky130_ef_sc_hd__decap_12
X_4523_ u_pe_array.g_pe_row\[2\].g_pe_col\[3\].u_pe.psum_out\[9\] u_pe_array.g_pe_row\[2\].g_pe_col\[3\].u_pe.move_reg\[9\]
+ _1599_ VGND VGND VPWR VPWR _1610_ sky130_fd_sc_hd__mux2_1
X_7311_ clknet_leaf_7_clk net393 net945 VGND VGND VPWR VPWR u_pe_array.act_from_right\[10\]\[10\]
+ sky130_fd_sc_hd__dfrtp_1
XFILLER_0_53_482 VGND VGND VPWR VPWR sky130_fd_sc_hd__fill_2
Xhold214 _0704_ VGND VGND VPWR VPWR net288 sky130_fd_sc_hd__dlygate4sd3_1
Xhold203 u_pe_array.g_pe_row\[2\].g_pe_col\[0\].u_pe.move_reg\[6\] VGND VGND VPWR
+ VPWR net277 sky130_fd_sc_hd__dlygate4sd3_1
X_7242_ clknet_leaf_14_clk _0148_ net942 VGND VGND VPWR VPWR u_pe_array.g_pe_row\[3\].g_pe_col\[1\].u_pe.psum_out\[10\]
+ sky130_fd_sc_hd__dfrtp_2
Xhold225 u_pe_array.g_pe_row\[1\].g_pe_col\[0\].u_pe.move_reg\[9\] VGND VGND VPWR
+ VPWR net299 sky130_fd_sc_hd__dlygate4sd3_1
Xhold236 u_pe_array.act_from_down\[11\]\[12\] VGND VGND VPWR VPWR net310 sky130_fd_sc_hd__dlygate4sd3_1
X_4454_ _1541_ _1554_ VGND VGND VPWR VPWR _1557_ sky130_fd_sc_hd__and2b_1
Xhold269 u_pe_array.g_pe_row\[2\].g_pe_col\[3\].u_pe.psum_out\[3\] VGND VGND VPWR
+ VPWR net343 sky130_fd_sc_hd__dlygate4sd3_1
Xhold258 u_pe_array.act_from_up\[6\]\[2\] VGND VGND VPWR VPWR net332 sky130_fd_sc_hd__dlygate4sd3_1
Xhold247 u_pe_array.act_from_down\[11\]\[3\] VGND VGND VPWR VPWR net321 sky130_fd_sc_hd__dlygate4sd3_1
X_4385_ _1485_ _1490_ VGND VGND VPWR VPWR _1494_ sky130_fd_sc_hd__nand2_1
X_7173_ clknet_leaf_96_clk _0079_ net945 VGND VGND VPWR VPWR u_pe_array.act_from_left\[15\]\[8\]
+ sky130_fd_sc_hd__dfrtp_1
X_6124_ net452 _2853_ _2847_ _2856_ VGND VGND VPWR VPWR _0570_ sky130_fd_sc_hd__a22o_1
XTAP_530 VGND VPWR sky130_fd_sc_hd__tapvpwrvgnd_1
XTAP_541 VGND VPWR sky130_fd_sc_hd__tapvpwrvgnd_1
XTAP_552 VGND VPWR sky130_fd_sc_hd__tapvpwrvgnd_1
XTAP_563 VGND VPWR sky130_fd_sc_hd__tapvpwrvgnd_1
XTAP_574 VGND VPWR sky130_fd_sc_hd__tapvpwrvgnd_1
XTAP_585 VGND VPWR sky130_fd_sc_hd__tapvpwrvgnd_1
X_6055_ _2787_ _2801_ VGND VGND VPWR VPWR _2804_ sky130_fd_sc_hd__and2b_1
X_5006_ u_pe_array.g_pe_row\[2\].g_pe_col\[1\].u_pe.psum_out\[10\] _1973_ VGND VGND
+ VPWR VPWR _1984_ sky130_fd_sc_hd__nor2_1
XTAP_596 VGND VPWR sky130_fd_sc_hd__tapvpwrvgnd_1
XTAP_1729 VGND VPWR sky130_fd_sc_hd__tapvpwrvgnd_1
XTAP_1718 VGND VPWR sky130_fd_sc_hd__tapvpwrvgnd_1
XTAP_1707 VGND VPWR sky130_fd_sc_hd__tapvpwrvgnd_1
X_6957_ u_pe_array.u_fifo1.rd_ptr\[0\] _3463_ _3464_ VGND VGND VPWR VPWR _3465_ sky130_fd_sc_hd__o21ai_1
X_6888_ _0920_ net710 _3423_ VGND VGND VPWR VPWR _3425_ sky130_fd_sc_hd__mux2_1
X_5908_ _2676_ _2677_ VGND VGND VPWR VPWR _2678_ sky130_fd_sc_hd__or2_2
XFILLER_0_118_153 VGND VGND VPWR VPWR sky130_fd_sc_hd__decap_4
XFILLER_0_91_544 VGND VGND VPWR VPWR sky130_fd_sc_hd__decap_6
X_5839_ _2633_ VGND VGND VPWR VPWR _0508_ sky130_fd_sc_hd__clkbuf_1
XFILLER_0_118_197 VGND VGND VPWR VPWR sky130_fd_sc_hd__decap_3
XFILLER_0_91_566 VGND VGND VPWR VPWR sky130_fd_sc_hd__fill_2
XFILLER_0_63_268 VGND VGND VPWR VPWR sky130_fd_sc_hd__decap_4
XFILLER_0_16_151 VGND VGND VPWR VPWR sky130_fd_sc_hd__fill_2
X_7509_ clknet_leaf_12_clk _0415_ net72 VGND VGND VPWR VPWR u_pe_array.act_from_right\[5\]\[3\]
+ sky130_fd_sc_hd__dfrtp_1
XFILLER_0_17_685 VPWR VGND VPWR VGND sky130_ef_sc_hd__decap_12
XFILLER_0_32_633 VGND VGND VPWR VPWR sky130_fd_sc_hd__decap_8
XFILLER_0_31_121 VGND VGND VPWR VPWR sky130_fd_sc_hd__fill_1
XFILLER_0_31_165 VGND VGND VPWR VPWR sky130_fd_sc_hd__decap_3
XFILLER_0_102_587 VGND VGND VPWR VPWR sky130_fd_sc_hd__fill_1
Xhold781 u_pe_array.act_from_up\[12\]\[0\] VGND VGND VPWR VPWR net855 sky130_fd_sc_hd__dlygate4sd3_1
Xhold770 u_pe_array.g_pe_row\[1\].g_pe_col\[2\].u_pe.psum_out\[2\] VGND VGND VPWR
+ VPWR net844 sky130_fd_sc_hd__dlygate4sd3_1
Xhold792 u_pe_array.g_pe_row\[3\].g_pe_col\[0\].u_pe.psum_out\[8\] VGND VGND VPWR
+ VPWR net866 sky130_fd_sc_hd__dlygate4sd3_1
XFILLER_0_52_29 VGND VGND VPWR VPWR sky130_fd_sc_hd__decap_6
XFILLER_0_109_131 VPWR VGND VPWR VGND sky130_ef_sc_hd__decap_12
XFILLER_0_39_254 VGND VGND VPWR VPWR sky130_fd_sc_hd__decap_8
XFILLER_0_39_276 VGND VGND VPWR VPWR sky130_fd_sc_hd__decap_4
XFILLER_0_109_164 VGND VGND VPWR VPWR sky130_fd_sc_hd__fill_1
XFILLER_0_82_533 VGND VGND VPWR VPWR sky130_fd_sc_hd__decap_4
XFILLER_0_109_175 VPWR VGND VPWR VGND sky130_ef_sc_hd__decap_12
XFILLER_0_23_644 VGND VGND VPWR VPWR sky130_fd_sc_hd__fill_1
XFILLER_0_105_381 VGND VGND VPWR VPWR sky130_fd_sc_hd__fill_1
XFILLER_0_50_463 VGND VGND VPWR VPWR sky130_fd_sc_hd__fill_2
XFILLER_0_77_48 VGND VGND VPWR VPWR sky130_fd_sc_hd__decap_8
XFILLER_0_22_187 VGND VGND VPWR VPWR sky130_fd_sc_hd__decap_8
X_4170_ _1331_ _1106_ u_pe_array.g_pe_row\[3\].g_pe_col\[1\].u_pe.psum_out\[3\] VGND
+ VGND VPWR VPWR _1332_ sky130_fd_sc_hd__a21oi_1
XFILLER_0_93_69 VPWR VGND VPWR VGND sky130_ef_sc_hd__decap_12
XFILLER_0_89_110 VGND VGND VPWR VPWR sky130_fd_sc_hd__fill_2
X_7860_ clknet_leaf_99_clk _0765_ VGND VGND VPWR VPWR u_pe_array.u_fifo2.buffer\[4\]\[0\]
+ sky130_fd_sc_hd__dfxtp_1
X_6811_ u_pe_array.u_fifo2.rd_ptr\[3\] _3376_ _3372_ VGND VGND VPWR VPWR _3378_ sky130_fd_sc_hd__o21ai_1
XFILLER_0_26_85 VGND VGND VPWR VPWR sky130_fd_sc_hd__fill_1
XFILLER_0_58_541 VGND VGND VPWR VPWR sky130_fd_sc_hd__fill_1
X_7791_ clknet_leaf_93_clk u_fsm.psum_shift_en net949 VGND VGND VPWR VPWR u_pe_array.g_pe_row\[0\].g_pe_col\[0\].u_pe.psum_shift_en_d
+ sky130_fd_sc_hd__dfrtp_4
X_6742_ u_pe_array.g_pe_row\[0\].g_pe_col\[0\].u_pe.psum_out\[8\] u_pe_array.g_pe_row\[0\].g_pe_col\[0\].u_pe.psum_out\[9\]
+ _2488_ VGND VGND VPWR VPWR _3326_ sky130_fd_sc_hd__and3_1
XFILLER_0_85_360 VPWR VGND VPWR VGND sky130_ef_sc_hd__decap_12
XFILLER_0_9_137 VGND VGND VPWR VPWR sky130_fd_sc_hd__decap_8
X_3954_ net23 net676 _0857_ VGND VGND VPWR VPWR _1171_ sky130_fd_sc_hd__mux2_1
X_6673_ _1092_ _3262_ _3263_ _1005_ net523 VGND VGND VPWR VPWR _0712_ sky130_fd_sc_hd__a32o_1
XFILLER_0_73_544 VGND VGND VPWR VPWR sky130_fd_sc_hd__fill_1
X_3885_ _1126_ _1112_ VGND VGND VPWR VPWR _1127_ sky130_fd_sc_hd__nand2_1
XFILLER_0_42_73 VGND VGND VPWR VPWR sky130_fd_sc_hd__fill_2
XFILLER_0_60_205 VGND VGND VPWR VPWR sky130_fd_sc_hd__fill_1
XFILLER_0_5_321 VPWR VGND VPWR VGND sky130_ef_sc_hd__decap_12
XFILLER_0_45_268 VPWR VGND VPWR VGND sky130_ef_sc_hd__decap_12
X_5624_ _2458_ _2460_ _2465_ VGND VGND VPWR VPWR _2467_ sky130_fd_sc_hd__or3_1
XFILLER_0_116_657 VPWR VGND VPWR VGND sky130_ef_sc_hd__decap_12
XFILLER_0_26_460 VGND VGND VPWR VPWR sky130_fd_sc_hd__fill_1
XFILLER_0_115_167 VGND VGND VPWR VPWR sky130_fd_sc_hd__fill_1
X_5555_ _2403_ VGND VGND VPWR VPWR _2404_ sky130_fd_sc_hd__inv_2
XFILLER_0_77_3 VPWR VGND VPWR VGND sky130_ef_sc_hd__decap_12
XFILLER_0_14_688 VPWR VGND VPWR VGND sky130_ef_sc_hd__decap_12
X_4506_ u_pe_array.g_pe_row\[2\].g_pe_col\[3\].u_pe.psum_out\[1\] u_pe_array.g_pe_row\[2\].g_pe_col\[3\].u_pe.act_val\[1\]
+ _1599_ VGND VGND VPWR VPWR _1601_ sky130_fd_sc_hd__mux2_1
X_5486_ u_pe_array.act_from_up\[6\]\[1\] _2341_ VGND VGND VPWR VPWR _2350_ sky130_fd_sc_hd__or2_1
XFILLER_0_41_474 VGND VGND VPWR VPWR sky130_fd_sc_hd__decap_3
X_7225_ clknet_leaf_8_clk net382 net950 VGND VGND VPWR VPWR u_pe_array.g_pe_row\[3\].g_pe_col\[1\].u_pe.move_reg\[6\]
+ sky130_fd_sc_hd__dfrtp_1
X_4437_ _1505_ _1513_ _1512_ VGND VGND VPWR VPWR _1542_ sky130_fd_sc_hd__a21o_1
X_7156_ clknet_leaf_5_clk _0062_ net945 VGND VGND VPWR VPWR u_pe_array.act_from_right\[13\]\[4\]
+ sky130_fd_sc_hd__dfrtp_1
X_4368_ u_pe_array.act_from_up\[12\]\[9\] _1310_ _1175_ net216 VGND VGND VPWR VPWR
+ _0188_ sky130_fd_sc_hd__a22o_1
X_6107_ _0943_ VGND VGND VPWR VPWR _2847_ sky130_fd_sc_hd__clkbuf_8
XTAP_360 VGND VPWR sky130_fd_sc_hd__tapvpwrvgnd_1
X_4299_ _1444_ VGND VGND VPWR VPWR _0157_ sky130_fd_sc_hd__clkbuf_1
XTAP_393 VGND VPWR sky130_fd_sc_hd__tapvpwrvgnd_1
XTAP_382 VGND VPWR sky130_fd_sc_hd__tapvpwrvgnd_1
XTAP_371 VGND VPWR sky130_fd_sc_hd__tapvpwrvgnd_1
X_7087_ net600 _3360_ _3536_ VGND VGND VPWR VPWR _3541_ sky130_fd_sc_hd__mux2_1
X_6038_ _2770_ _2779_ VGND VGND VPWR VPWR _2789_ sky130_fd_sc_hd__and2b_1
XTAP_1515 VGND VPWR sky130_fd_sc_hd__tapvpwrvgnd_1
XTAP_1504 VGND VPWR sky130_fd_sc_hd__tapvpwrvgnd_1
XPHY_22 VGND VGND VPWR VPWR sky130_fd_sc_hd__decap_3
XPHY_11 VGND VGND VPWR VPWR sky130_fd_sc_hd__decap_3
XTAP_1548 VGND VPWR sky130_fd_sc_hd__tapvpwrvgnd_1
XTAP_1537 VGND VPWR sky130_fd_sc_hd__tapvpwrvgnd_1
XTAP_1526 VGND VPWR sky130_fd_sc_hd__tapvpwrvgnd_1
XFILLER_0_96_669 VGND VGND VPWR VPWR sky130_fd_sc_hd__fill_1
XPHY_33 VGND VGND VPWR VPWR sky130_fd_sc_hd__decap_3
XPHY_44 VGND VGND VPWR VPWR sky130_fd_sc_hd__decap_3
XPHY_55 VGND VGND VPWR VPWR sky130_fd_sc_hd__decap_3
XFILLER_0_49_530 VGND VGND VPWR VPWR sky130_fd_sc_hd__decap_6
XTAP_1559 VGND VPWR sky130_fd_sc_hd__tapvpwrvgnd_1
XPHY_66 VGND VGND VPWR VPWR sky130_fd_sc_hd__decap_3
XPHY_77 VGND VGND VPWR VPWR sky130_fd_sc_hd__decap_3
XPHY_88 VGND VGND VPWR VPWR sky130_fd_sc_hd__decap_3
XPHY_99 VGND VGND VPWR VPWR sky130_fd_sc_hd__decap_3
XFILLER_0_87_614 VGND VGND VPWR VPWR sky130_fd_sc_hd__fill_2
XFILLER_0_86_113 VGND VGND VPWR VPWR sky130_fd_sc_hd__fill_2
XFILLER_0_55_500 VGND VGND VPWR VPWR sky130_fd_sc_hd__decap_4
XFILLER_0_94_190 VGND VGND VPWR VPWR sky130_fd_sc_hd__decap_6
XFILLER_0_12_65 VGND VGND VPWR VPWR sky130_fd_sc_hd__decap_3
XFILLER_0_27_279 VGND VGND VPWR VPWR sky130_fd_sc_hd__fill_1
XFILLER_0_42_205 VGND VGND VPWR VPWR sky130_fd_sc_hd__fill_2
X_3670_ net321 _0949_ _0944_ _0952_ VGND VGND VPWR VPWR _0020_ sky130_fd_sc_hd__a22o_1
XFILLER_0_113_649 VPWR VGND VPWR VGND sky130_ef_sc_hd__decap_12
X_5340_ u_pe_array.g_pe_row\[1\].g_pe_col\[3\].u_pe.psum_out\[8\] _1426_ VGND VGND
+ VPWR VPWR _2238_ sky130_fd_sc_hd__or2_1
X_5271_ u_pe_array.g_pe_row\[1\].g_pe_col\[3\].u_pe.act_val\[2\] _1423_ u_pe_array.g_pe_row\[1\].g_pe_col\[3\].u_pe.psum_out\[2\]
+ VGND VGND VPWR VPWR _2175_ sky130_fd_sc_hd__a21oi_1
XFILLER_0_10_113 VGND VGND VPWR VPWR sky130_fd_sc_hd__fill_1
X_4222_ u_pe_array.g_pe_row\[3\].g_pe_col\[1\].u_pe.psum_out\[7\] _1106_ VGND VGND
+ VPWR VPWR _1380_ sky130_fd_sc_hd__nand2_1
X_7010_ u_pe_array.u_fifo1.wr_ptr\[0\] u_pe_array.u_fifo1.wr_ptr\[1\] _3483_ VGND
+ VGND VPWR VPWR _3498_ sky130_fd_sc_hd__and3b_1
X_4153_ u_pe_array.g_pe_row\[3\].g_pe_col\[1\].u_pe.act_val\[1\] u_pe_array.g_pe_row\[3\].g_pe_col\[1\].u_pe.w_out\[0\]
+ _1315_ _1316_ VGND VGND VPWR VPWR _1317_ sky130_fd_sc_hd__nand4_1
X_4084_ _1274_ _1278_ VGND VGND VPWR VPWR _1279_ sky130_fd_sc_hd__xor2_1
XFILLER_0_37_73 VGND VGND VPWR VPWR sky130_fd_sc_hd__fill_1
X_7912_ clknet_leaf_81_clk _0817_ VGND VGND VPWR VPWR u_pe_array.u_fifo1.buffer\[2\]\[2\]
+ sky130_fd_sc_hd__dfxtp_1
XFILLER_0_77_113 VGND VGND VPWR VPWR sky130_fd_sc_hd__decap_8
XFILLER_0_78_658 VGND VGND VPWR VPWR sky130_fd_sc_hd__fill_1
XFILLER_0_77_146 VGND VGND VPWR VPWR sky130_fd_sc_hd__decap_8
X_7843_ clknet_leaf_100_clk _0748_ VGND VGND VPWR VPWR u_pe_array.u_fifo2.buffer\[1\]\[1\]
+ sky130_fd_sc_hd__dfxtp_1
X_4986_ u_pe_array.g_pe_row\[2\].g_pe_col\[1\].u_pe.psum_out\[8\] _1105_ VGND VGND
+ VPWR VPWR _1966_ sky130_fd_sc_hd__or2_1
X_7774_ clknet_leaf_43_clk _0680_ net946 VGND VGND VPWR VPWR u_pe_array.g_pe_row\[0\].g_pe_col\[1\].u_pe.psum_out\[11\]
+ sky130_fd_sc_hd__dfrtp_1
X_6725_ u_pe_array.g_pe_row\[0\].g_pe_col\[0\].u_pe.psum_out\[7\] _3309_ _3310_ VGND
+ VGND VPWR VPWR _3311_ sky130_fd_sc_hd__mux2_1
XFILLER_0_18_202 VPWR VGND VPWR VGND sky130_ef_sc_hd__decap_12
X_3937_ _1164_ VGND VGND VPWR VPWR _0075_ sky130_fd_sc_hd__clkbuf_1
XFILLER_0_46_533 VGND VGND VPWR VPWR sky130_fd_sc_hd__decap_6
XFILLER_0_116_410 VGND VGND VPWR VPWR sky130_fd_sc_hd__decap_8
X_6656_ u_pe_array.g_pe_row\[0\].g_pe_col\[0\].u_pe.act_val\[1\] _2486_ _3247_ VGND
+ VGND VPWR VPWR _3248_ sky130_fd_sc_hd__a21o_1
XFILLER_0_6_641 VGND VGND VPWR VPWR sky130_fd_sc_hd__decap_3
X_3868_ _1111_ _1112_ VGND VGND VPWR VPWR _1113_ sky130_fd_sc_hd__nand2_1
X_6587_ u_pe_array.g_pe_row\[0\].g_pe_col\[1\].u_pe.psum_out\[10\] _2268_ VGND VGND
+ VPWR VPWR _3211_ sky130_fd_sc_hd__nand2_1
X_3799_ _1037_ _1039_ _1052_ VGND VGND VPWR VPWR _1053_ sky130_fd_sc_hd__a21oi_1
XFILLER_0_6_674 VPWR VGND VPWR VGND sky130_ef_sc_hd__decap_12
XFILLER_0_14_441 VPWR VGND VPWR VGND sky130_ef_sc_hd__decap_12
X_5607_ _2417_ _2418_ _2450_ VGND VGND VPWR VPWR _2451_ sky130_fd_sc_hd__or3_1
XFILLER_0_14_474 VGND VGND VPWR VPWR sky130_fd_sc_hd__fill_2
X_5538_ u_pe_array.g_pe_row\[1\].g_pe_col\[2\].u_pe.act_val\[1\] _1597_ VGND VGND
+ VPWR VPWR _2388_ sky130_fd_sc_hd__or2b_1
XFILLER_0_14_485 VGND VGND VPWR VPWR sky130_fd_sc_hd__fill_2
XFILLER_0_41_293 VGND VGND VPWR VPWR sky130_fd_sc_hd__fill_1
XFILLER_0_112_693 VGND VGND VPWR VPWR sky130_fd_sc_hd__decap_6
X_7208_ clknet_leaf_22_clk _0114_ net942 VGND VGND VPWR VPWR u_pe_array.act_from_down\[9\]\[2\]
+ sky130_fd_sc_hd__dfrtp_1
XFILLER_0_78_80 VGND VGND VPWR VPWR sky130_fd_sc_hd__decap_4
X_5469_ u_pe_array.u_fifo2.rd_ptr\[0\] u_pe_array.u_fifo2.rd_ptr\[3\] u_pe_array.u_fifo2.rd_ptr\[2\]
+ u_pe_array.u_fifo2.rd_ptr\[1\] VGND VGND VPWR VPWR _2334_ sky130_fd_sc_hd__and4bb_2
X_7139_ clknet_leaf_18_clk _0045_ net945 VGND VGND VPWR VPWR u_pe_array.g_pe_row\[3\].g_pe_col\[3\].u_pe.psum_out\[2\]
+ sky130_fd_sc_hd__dfrtp_1
XTAP_1323 VGND VPWR sky130_fd_sc_hd__tapvpwrvgnd_1
XTAP_1312 VGND VPWR sky130_fd_sc_hd__tapvpwrvgnd_1
XTAP_1301 VGND VPWR sky130_fd_sc_hd__tapvpwrvgnd_1
XFILLER_0_96_499 VGND VGND VPWR VPWR sky130_fd_sc_hd__decap_3
XTAP_1356 VGND VPWR sky130_fd_sc_hd__tapvpwrvgnd_1
XTAP_1345 VGND VPWR sky130_fd_sc_hd__tapvpwrvgnd_1
XTAP_1334 VGND VPWR sky130_fd_sc_hd__tapvpwrvgnd_1
XFILLER_0_84_639 VGND VGND VPWR VPWR sky130_fd_sc_hd__decap_4
XTAP_1389 VGND VPWR sky130_fd_sc_hd__tapvpwrvgnd_1
XTAP_1378 VGND VPWR sky130_fd_sc_hd__tapvpwrvgnd_1
XTAP_1367 VGND VPWR sky130_fd_sc_hd__tapvpwrvgnd_1
XFILLER_0_37_522 VPWR VGND VPWR VGND sky130_ef_sc_hd__decap_12
Xinput18 v_in0[3] VGND VGND VPWR VPWR net18 sky130_fd_sc_hd__clkbuf_2
Xinput29 w_in_flat[2] VGND VGND VPWR VPWR net29 sky130_fd_sc_hd__clkbuf_1
XFILLER_0_32_271 VGND VGND VPWR VPWR sky130_fd_sc_hd__decap_4
XFILLER_0_103_671 VGND VGND VPWR VPWR sky130_fd_sc_hd__fill_1
XFILLER_0_20_477 VGND VGND VPWR VPWR sky130_fd_sc_hd__fill_1
XFILLER_0_74_27 VGND VGND VPWR VPWR sky130_fd_sc_hd__fill_1
XFILLER_0_59_113 VPWR VGND VPWR VGND sky130_ef_sc_hd__decap_12
XFILLER_0_99_293 VPWR VGND VPWR VGND sky130_ef_sc_hd__decap_12
XFILLER_0_90_15 VPWR VGND VPWR VGND sky130_ef_sc_hd__decap_12
XFILLER_0_75_617 VGND VGND VPWR VPWR sky130_fd_sc_hd__decap_6
X_4840_ _1850_ _1852_ _1857_ VGND VGND VPWR VPWR _1858_ sky130_fd_sc_hd__o21ai_1
XFILLER_0_114_77 VGND VGND VPWR VPWR sky130_fd_sc_hd__decap_6
XFILLER_0_23_42 VGND VGND VPWR VPWR sky130_fd_sc_hd__fill_1
XFILLER_0_28_533 VGND VGND VPWR VPWR sky130_fd_sc_hd__decap_8
X_6510_ u_pe_array.g_pe_row\[0\].g_pe_col\[1\].u_pe.psum_out\[3\] _3140_ VGND VGND
+ VPWR VPWR _3141_ sky130_fd_sc_hd__xor2_1
XFILLER_0_74_149 VGND VGND VPWR VPWR sky130_fd_sc_hd__fill_1
X_4771_ u_pe_array.g_pe_row\[2\].g_pe_col\[2\].u_pe.act_val\[4\] _0933_ VGND VGND
+ VPWR VPWR _1795_ sky130_fd_sc_hd__and2b_1
XFILLER_0_28_555 VGND VGND VPWR VPWR sky130_fd_sc_hd__decap_3
X_7490_ clknet_leaf_42_clk _0396_ net946 VGND VGND VPWR VPWR u_pe_array.g_pe_row\[1\].g_pe_col\[3\].u_pe.move_reg\[12\]
+ sky130_fd_sc_hd__dfrtp_1
X_3722_ u_fsm.state\[0\] _0860_ VGND VGND VPWR VPWR _0982_ sky130_fd_sc_hd__and2_1
XFILLER_0_99_57 VPWR VGND VPWR VGND sky130_ef_sc_hd__decap_12
X_6441_ _0938_ VGND VGND VPWR VPWR _3101_ sky130_fd_sc_hd__clkbuf_8
X_3653_ _0938_ VGND VGND VPWR VPWR _0939_ sky130_fd_sc_hd__buf_8
XFILLER_0_11_400 VGND VGND VPWR VPWR sky130_fd_sc_hd__decap_3
XFILLER_0_2_121 VPWR VGND VPWR VGND sky130_ef_sc_hd__decap_12
X_6372_ _3040_ _3041_ VGND VGND VPWR VPWR _3042_ sky130_fd_sc_hd__xnor2_1
XFILLER_0_113_457 VGND VGND VPWR VPWR sky130_fd_sc_hd__decap_8
X_5323_ _2220_ _2222_ VGND VGND VPWR VPWR _2223_ sky130_fd_sc_hd__or2_1
XFILLER_0_11_422 VGND VGND VPWR VPWR sky130_fd_sc_hd__fill_1
XFILLER_0_11_411 VGND VGND VPWR VPWR sky130_fd_sc_hd__decap_3
XFILLER_0_2_165 VPWR VGND VPWR VGND sky130_ef_sc_hd__decap_12
X_3584_ _0851_ _0887_ _0888_ VGND VGND VPWR VPWR _0889_ sky130_fd_sc_hd__and3_1
XFILLER_0_23_271 VGND VGND VPWR VPWR sky130_fd_sc_hd__decap_3
X_5254_ _2160_ VGND VGND VPWR VPWR _0396_ sky130_fd_sc_hd__clkbuf_1
X_5185_ _2119_ _2120_ VGND VGND VPWR VPWR _2121_ sky130_fd_sc_hd__or2_1
X_4205_ _1352_ _1353_ _1350_ VGND VGND VPWR VPWR _1365_ sky130_fd_sc_hd__o21ba_1
XFILLER_0_48_83 VGND VGND VPWR VPWR sky130_fd_sc_hd__fill_1
X_4136_ u_pe_array.act_from_right\[13\]\[5\] net747 _0963_ VGND VGND VPWR VPWR _1309_
+ sky130_fd_sc_hd__mux2_1
X_4067_ _1255_ _1257_ _1262_ VGND VGND VPWR VPWR _1264_ sky130_fd_sc_hd__or3_1
XFILLER_0_78_433 VGND VGND VPWR VPWR sky130_fd_sc_hd__decap_4
XFILLER_0_78_477 VPWR VGND VPWR VGND sky130_ef_sc_hd__decap_12
X_7826_ clknet_leaf_85_clk _0731_ net948 VGND VGND VPWR VPWR u_pe_array.u_fifo2.wr_ptr\[2\]
+ sky130_fd_sc_hd__dfrtp_1
XFILLER_0_93_447 VGND VGND VPWR VPWR sky130_fd_sc_hd__fill_1
X_4969_ _1944_ _1949_ VGND VGND VPWR VPWR _1951_ sky130_fd_sc_hd__nand2_1
X_7757_ clknet_leaf_44_clk net107 net947 VGND VGND VPWR VPWR u_pe_array.g_pe_row\[0\].g_pe_col\[1\].u_pe.move_reg\[7\]
+ sky130_fd_sc_hd__dfrtp_1
X_6708_ _1092_ _3294_ _3295_ _1005_ net518 VGND VGND VPWR VPWR _0715_ sky130_fd_sc_hd__a32o_1
X_7688_ clknet_leaf_57_clk _0594_ net74 VGND VGND VPWR VPWR u_pe_array.g_pe_row\[0\].g_pe_col\[3\].u_pe.psum_out\[7\]
+ sky130_fd_sc_hd__dfrtp_4
XFILLER_0_19_588 VGND VGND VPWR VPWR sky130_fd_sc_hd__fill_1
XFILLER_0_34_525 VGND VGND VPWR VPWR sky130_fd_sc_hd__decap_6
XFILLER_0_46_363 VGND VGND VPWR VPWR sky130_fd_sc_hd__fill_1
XFILLER_0_46_385 VGND VGND VPWR VPWR sky130_fd_sc_hd__fill_2
X_6639_ u_pe_array.g_pe_row\[0\].g_pe_col\[0\].u_pe.act_val\[2\] _2343_ _2320_ net242
+ VGND VGND VPWR VPWR _0699_ sky130_fd_sc_hd__a22o_1
XFILLER_0_104_413 VGND VGND VPWR VPWR sky130_fd_sc_hd__decap_6
XFILLER_0_6_460 VPWR VGND VPWR VGND sky130_ef_sc_hd__decap_12
XFILLER_0_88_219 VGND VGND VPWR VPWR sky130_fd_sc_hd__decap_6
XTAP_1131 VGND VPWR sky130_fd_sc_hd__tapvpwrvgnd_1
XTAP_1120 VGND VPWR sky130_fd_sc_hd__tapvpwrvgnd_1
XFILLER_0_57_617 VPWR VGND VPWR VGND sky130_ef_sc_hd__decap_12
XTAP_1153 VGND VPWR sky130_fd_sc_hd__tapvpwrvgnd_1
XTAP_1164 VGND VPWR sky130_fd_sc_hd__tapvpwrvgnd_1
XTAP_1142 VGND VPWR sky130_fd_sc_hd__tapvpwrvgnd_1
XFILLER_0_69_499 VGND VGND VPWR VPWR sky130_fd_sc_hd__decap_4
XTAP_1197 VGND VPWR sky130_fd_sc_hd__tapvpwrvgnd_1
XTAP_1186 VGND VPWR sky130_fd_sc_hd__tapvpwrvgnd_1
XTAP_1175 VGND VPWR sky130_fd_sc_hd__tapvpwrvgnd_1
XFILLER_0_52_355 VGND VGND VPWR VPWR sky130_fd_sc_hd__decap_8
XFILLER_0_85_15 VGND VGND VPWR VPWR sky130_fd_sc_hd__decap_3
XTAP_926 VGND VPWR sky130_fd_sc_hd__tapvpwrvgnd_1
XFILLER_0_0_669 VGND VGND VPWR VPWR sky130_fd_sc_hd__decap_3
XTAP_915 VGND VPWR sky130_fd_sc_hd__tapvpwrvgnd_1
XTAP_904 VGND VPWR sky130_fd_sc_hd__tapvpwrvgnd_1
XTAP_959 VGND VPWR sky130_fd_sc_hd__tapvpwrvgnd_1
XTAP_948 VGND VPWR sky130_fd_sc_hd__tapvpwrvgnd_1
XTAP_937 VGND VPWR sky130_fd_sc_hd__tapvpwrvgnd_1
XFILLER_0_109_55 VGND VGND VPWR VPWR sky130_fd_sc_hd__fill_1
XFILLER_0_18_53 VGND VGND VPWR VPWR sky130_fd_sc_hd__decap_8
X_6990_ _3487_ VGND VGND VPWR VPWR _0805_ sky130_fd_sc_hd__clkbuf_1
XFILLER_0_26_9 VGND VGND VPWR VPWR sky130_fd_sc_hd__decap_4
X_5941_ _2320_ _2707_ _2708_ _2343_ net812 VGND VGND VPWR VPWR _0535_ sky130_fd_sc_hd__a32o_1
XFILLER_0_48_617 VGND VGND VPWR VPWR sky130_fd_sc_hd__decap_6
XFILLER_0_118_505 VGND VGND VPWR VPWR sky130_fd_sc_hd__fill_1
X_5872_ net809 _2658_ _2273_ VGND VGND VPWR VPWR _2659_ sky130_fd_sc_hd__mux2_1
X_7611_ clknet_leaf_32_clk _0517_ net71 VGND VGND VPWR VPWR net37 sky130_fd_sc_hd__dfrtp_1
X_4823_ _1834_ _1837_ _1842_ VGND VGND VPWR VPWR _1843_ sky130_fd_sc_hd__o21ai_1
X_7542_ clknet_leaf_69_clk net105 net72 VGND VGND VPWR VPWR u_pe_array.g_pe_row\[1\].g_pe_col\[2\].u_pe.move_reg\[10\]
+ sky130_fd_sc_hd__dfrtp_1
X_4754_ _1776_ _1778_ VGND VGND VPWR VPWR _1780_ sky130_fd_sc_hd__nand2_1
X_7473_ clknet_leaf_42_clk _0379_ net946 VGND VGND VPWR VPWR u_pe_array.act_from_down\[3\]\[8\]
+ sky130_fd_sc_hd__dfrtp_1
X_3705_ net487 _0939_ VGND VGND VPWR VPWR _0971_ sky130_fd_sc_hd__and2_1
XFILLER_0_50_73 VGND VGND VPWR VPWR sky130_fd_sc_hd__decap_8
XFILLER_0_113_221 VGND VGND VPWR VPWR sky130_fd_sc_hd__decap_3
X_4685_ u_pe_array.g_pe_row\[2\].g_pe_col\[2\].u_pe.psum_out\[2\] u_pe_array.g_pe_row\[2\].g_pe_col\[2\].u_pe.act_val\[2\]
+ _1599_ VGND VGND VPWR VPWR _1738_ sky130_fd_sc_hd__mux2_1
X_3636_ u_pe_array.act_from_up\[14\]\[4\] _0869_ _0854_ VGND VGND VPWR VPWR _0926_
+ sky130_fd_sc_hd__and3_2
XFILLER_0_3_441 VGND VGND VPWR VPWR sky130_fd_sc_hd__decap_6
X_6424_ _2795_ _3087_ _3088_ _1005_ net923 VGND VGND VPWR VPWR _0638_ sky130_fd_sc_hd__a32o_1
XFILLER_0_3_485 VPWR VGND VPWR VGND sky130_ef_sc_hd__decap_12
X_3567_ _0860_ _0873_ _0874_ VGND VGND VPWR VPWR _0875_ sky130_fd_sc_hd__o21ai_1
X_6355_ u_pe_array.g_pe_row\[0\].g_pe_col\[2\].u_pe.act_val\[3\] _2128_ _3011_ _3010_
+ VGND VGND VPWR VPWR _3026_ sky130_fd_sc_hd__a31o_1
XFILLER_0_101_449 VGND VGND VPWR VPWR sky130_fd_sc_hd__decap_4
X_5306_ u_pe_array.g_pe_row\[1\].g_pe_col\[3\].u_pe.act_val\[4\] _2164_ _2204_ _2205_
+ VGND VGND VPWR VPWR _2207_ sky130_fd_sc_hd__o22ai_1
X_6286_ net190 _2006_ _2009_ _2980_ VGND VGND VPWR VPWR _0608_ sky130_fd_sc_hd__a22o_1
X_5237_ net5 u_pe_array.act_from_left\[7\]\[4\] _0963_ VGND VGND VPWR VPWR _2152_
+ sky130_fd_sc_hd__mux2_1
X_5168_ u_pe_array.g_pe_row\[2\].g_pe_col\[0\].u_pe.psum_out\[8\] u_pe_array.g_pe_row\[2\].g_pe_col\[0\].u_pe.psum_out\[9\]
+ _1286_ VGND VGND VPWR VPWR _2106_ sky130_fd_sc_hd__and3_1
X_5099_ _2034_ _2035_ _2041_ VGND VGND VPWR VPWR _2043_ sky130_fd_sc_hd__o21ai_1
X_4119_ net492 _1167_ _1169_ _1299_ VGND VGND VPWR VPWR _0122_ sky130_fd_sc_hd__a22o_1
XFILLER_0_94_701 VGND VGND VPWR VPWR sky130_fd_sc_hd__decap_4
XPHY_225 VGND VGND VPWR VPWR sky130_fd_sc_hd__decap_3
XFILLER_0_109_505 VPWR VGND VPWR VGND sky130_ef_sc_hd__decap_12
XPHY_214 VGND VGND VPWR VPWR sky130_fd_sc_hd__decap_3
XPHY_203 VGND VGND VPWR VPWR sky130_fd_sc_hd__decap_3
XFILLER_0_91_91 VGND VGND VPWR VPWR sky130_fd_sc_hd__fill_1
XFILLER_0_66_414 VGND VGND VPWR VPWR sky130_fd_sc_hd__decap_6
XPHY_236 VGND VGND VPWR VPWR sky130_fd_sc_hd__decap_3
X_7809_ clknet_leaf_55_clk _0714_ net74 VGND VGND VPWR VPWR u_pe_array.g_pe_row\[0\].g_pe_col\[0\].u_pe.psum_out\[4\]
+ sky130_fd_sc_hd__dfrtp_1
XFILLER_0_66_458 VGND VGND VPWR VPWR sky130_fd_sc_hd__fill_1
XFILLER_0_19_341 VGND VGND VPWR VPWR sky130_fd_sc_hd__fill_1
XFILLER_0_93_288 VPWR VGND VPWR VGND sky130_ef_sc_hd__decap_12
XFILLER_0_62_653 VGND VGND VPWR VPWR sky130_fd_sc_hd__decap_3
XFILLER_0_19_385 VGND VGND VPWR VPWR sky130_fd_sc_hd__fill_1
XFILLER_0_117_593 VGND VGND VPWR VPWR sky130_fd_sc_hd__decap_3
XFILLER_0_39_19 VGND VGND VPWR VPWR sky130_fd_sc_hd__decap_3
XFILLER_0_100_482 VGND VGND VPWR VPWR sky130_fd_sc_hd__decap_4
Xhold7 u_pe_array.act_from_right\[5\]\[8\] VGND VGND VPWR VPWR net81 sky130_fd_sc_hd__dlygate4sd3_1
XFILLER_0_97_561 VGND VGND VPWR VPWR sky130_fd_sc_hd__decap_4
XFILLER_0_57_458 VGND VGND VPWR VPWR sky130_fd_sc_hd__fill_1
XFILLER_0_84_299 VGND VGND VPWR VPWR sky130_fd_sc_hd__fill_1
Xhold418 u_pe_array.act_from_down\[9\]\[10\] VGND VGND VPWR VPWR net492 sky130_fd_sc_hd__dlygate4sd3_1
Xhold407 u_pe_array.u_fifo1.wr_ptr\[3\] VGND VGND VPWR VPWR net481 sky130_fd_sc_hd__dlygate4sd3_1
X_4470_ u_pe_array.g_pe_row\[3\].g_pe_col\[0\].u_pe.psum_out\[8\] u_pe_array.g_pe_row\[3\].g_pe_col\[0\].u_pe.psum_out\[9\]
+ _1287_ VGND VGND VPWR VPWR _1572_ sky130_fd_sc_hd__and3_1
Xhold429 u_pe_array.g_pe_row\[2\].g_pe_col\[1\].u_pe.psum_out\[3\] VGND VGND VPWR
+ VPWR net503 sky130_fd_sc_hd__dlygate4sd3_1
XFILLER_0_40_358 VGND VGND VPWR VPWR sky130_fd_sc_hd__decap_6
XFILLER_0_96_69 VPWR VGND VPWR VGND sky130_ef_sc_hd__decap_12
X_6140_ net193 _2730_ _2511_ u_pe_array.g_pe_row\[0\].g_pe_col\[3\].u_pe.move_reg\[9\]
+ VGND VGND VPWR VPWR _0583_ sky130_fd_sc_hd__a22o_1
XFILLER_0_0_433 VPWR VGND VPWR VGND sky130_ef_sc_hd__decap_12
XFILLER_0_21_561 VGND VGND VPWR VPWR sky130_fd_sc_hd__decap_6
XTAP_701 VGND VPWR sky130_fd_sc_hd__tapvpwrvgnd_1
XFILLER_0_0_477 VPWR VGND VPWR VGND sky130_ef_sc_hd__decap_12
XFILLER_0_29_30 VGND VGND VPWR VPWR sky130_fd_sc_hd__decap_6
XTAP_712 VGND VPWR sky130_fd_sc_hd__tapvpwrvgnd_1
XTAP_723 VGND VPWR sky130_fd_sc_hd__tapvpwrvgnd_1
XTAP_734 VGND VPWR sky130_fd_sc_hd__tapvpwrvgnd_1
X_6071_ u_pe_array.g_pe_row\[1\].g_pe_col\[0\].u_pe.psum_out\[8\] u_pe_array.g_pe_row\[1\].g_pe_col\[0\].u_pe.psum_out\[9\]
+ _1865_ VGND VGND VPWR VPWR _2819_ sky130_fd_sc_hd__and3_1
XTAP_756 VGND VPWR sky130_fd_sc_hd__tapvpwrvgnd_1
XTAP_745 VGND VPWR sky130_fd_sc_hd__tapvpwrvgnd_1
XTAP_767 VGND VPWR sky130_fd_sc_hd__tapvpwrvgnd_1
X_5022_ net905 _1904_ _1997_ _1726_ VGND VGND VPWR VPWR _0327_ sky130_fd_sc_hd__a22o_1
XTAP_778 VGND VPWR sky130_fd_sc_hd__tapvpwrvgnd_1
XTAP_789 VGND VPWR sky130_fd_sc_hd__tapvpwrvgnd_1
XFILLER_0_76_701 VGND VGND VPWR VPWR sky130_fd_sc_hd__decap_4
X_6973_ net881 _3472_ _3476_ VGND VGND VPWR VPWR _0799_ sky130_fd_sc_hd__o21a_1
XFILLER_0_75_222 VGND VGND VPWR VPWR sky130_fd_sc_hd__fill_2
X_5924_ u_pe_array.act_from_up\[4\]\[0\] _2341_ VGND VGND VPWR VPWR _2694_ sky130_fd_sc_hd__or2_1
X_5855_ u_pe_array.g_pe_row\[1\].g_pe_col\[0\].u_pe.psum_out\[5\] _1108_ _1110_ _2645_
+ VGND VGND VPWR VPWR _2646_ sky130_fd_sc_hd__o211a_1
XFILLER_0_118_335 VGND VGND VPWR VPWR sky130_fd_sc_hd__fill_1
XFILLER_0_61_72 VGND VGND VPWR VPWR sky130_fd_sc_hd__fill_1
XFILLER_0_8_555 VGND VGND VPWR VPWR sky130_fd_sc_hd__decap_4
XFILLER_0_8_533 VGND VGND VPWR VPWR sky130_fd_sc_hd__fill_2
XFILLER_0_0_97 VPWR VGND VPWR VGND sky130_ef_sc_hd__decap_12
X_4806_ _1814_ _1826_ VGND VGND VPWR VPWR _1827_ sky130_fd_sc_hd__and2_1
X_5786_ _2571_ _2572_ _2587_ _2588_ VGND VGND VPWR VPWR _2589_ sky130_fd_sc_hd__a31o_1
XFILLER_0_114_530 VGND VGND VPWR VPWR sky130_fd_sc_hd__fill_2
X_7525_ clknet_leaf_94_clk _0431_ net949 VGND VGND VPWR VPWR u_pe_array.act_from_left\[7\]\[6\]
+ sky130_fd_sc_hd__dfrtp_1
X_4737_ u_pe_array.g_pe_row\[2\].g_pe_col\[2\].u_pe.act_val\[2\] u_pe_array.g_pe_row\[2\].g_pe_col\[2\].u_pe.w_out\[0\]
+ VGND VGND VPWR VPWR _1764_ sky130_fd_sc_hd__nand2_1
XFILLER_0_9_51 VGND VGND VPWR VPWR sky130_fd_sc_hd__decap_4
X_7456_ clknet_leaf_29_clk _0362_ net71 VGND VGND VPWR VPWR u_pe_array.g_pe_row\[2\].g_pe_col\[0\].u_pe.psum_out\[6\]
+ sky130_fd_sc_hd__dfrtp_1
X_4668_ _0977_ VGND VGND VPWR VPWR _1726_ sky130_fd_sc_hd__buf_8
XFILLER_0_16_399 VGND VGND VPWR VPWR sky130_fd_sc_hd__fill_2
X_3619_ u_pe_array.u_fifo2.count\[0\] u_pe_array.u_fifo2.count\[3\] VGND VGND VPWR
+ VPWR _0913_ sky130_fd_sc_hd__nand2_1
XFILLER_0_31_358 VGND VGND VPWR VPWR sky130_fd_sc_hd__fill_2
XFILLER_0_31_369 VGND VGND VPWR VPWR sky130_fd_sc_hd__fill_1
X_6407_ _3064_ _3067_ _3072_ _0879_ VGND VGND VPWR VPWR _3074_ sky130_fd_sc_hd__a31o_1
X_7387_ clknet_leaf_27_clk _0293_ net942 VGND VGND VPWR VPWR u_pe_array.act_from_right\[8\]\[4\]
+ sky130_fd_sc_hd__dfrtp_1
X_4599_ _1661_ _1663_ VGND VGND VPWR VPWR _1664_ sky130_fd_sc_hd__xor2_1
X_6338_ _3008_ u_pe_array.g_pe_row\[0\].g_pe_col\[2\].u_pe.psum_out\[3\] _2130_ VGND
+ VGND VPWR VPWR _3010_ sky130_fd_sc_hd__and3_1
X_6269_ net29 u_pe_array.g_pe_row\[0\].g_pe_col\[1\].u_pe.w_out\[0\] net63 VGND VGND
+ VPWR VPWR _2972_ sky130_fd_sc_hd__mux2_1
XFILLER_0_98_358 VGND VGND VPWR VPWR sky130_fd_sc_hd__decap_6
XFILLER_0_82_704 VGND VGND VPWR VPWR sky130_fd_sc_hd__fill_1
XFILLER_0_109_335 VGND VGND VPWR VPWR sky130_fd_sc_hd__fill_1
XFILLER_0_66_277 VGND VGND VPWR VPWR sky130_fd_sc_hd__fill_1
XFILLER_0_26_119 VGND VGND VPWR VPWR sky130_fd_sc_hd__fill_1
XFILLER_0_81_225 VGND VGND VPWR VPWR sky130_fd_sc_hd__decap_8
XFILLER_0_62_450 VGND VGND VPWR VPWR sky130_fd_sc_hd__fill_1
XFILLER_0_105_574 VGND VGND VPWR VPWR sky130_fd_sc_hd__fill_2
XFILLER_0_50_645 VGND VGND VPWR VPWR sky130_fd_sc_hd__decap_4
XFILLER_0_50_667 VPWR VGND VPWR VGND sky130_ef_sc_hd__decap_12
XFILLER_0_58_701 VGND VGND VPWR VPWR sky130_fd_sc_hd__decap_4
X_3970_ u_pe_array.g_pe_row\[3\].g_pe_col\[2\].u_pe.act_val\[0\] u_pe_array.g_pe_row\[3\].g_pe_col\[2\].u_pe.w_out\[0\]
+ u_pe_array.g_pe_row\[3\].g_pe_col\[2\].u_pe.psum_out\[0\] VGND VGND VPWR VPWR _1176_
+ sky130_fd_sc_hd__a21o_1
XFILLER_0_97_391 VGND VGND VPWR VPWR sky130_fd_sc_hd__fill_1
XFILLER_0_115_305 VPWR VGND VPWR VGND sky130_ef_sc_hd__decap_12
X_5640_ _2476_ _2480_ VGND VGND VPWR VPWR _2481_ sky130_fd_sc_hd__xor2_1
XFILLER_0_26_653 VGND VGND VPWR VPWR sky130_fd_sc_hd__decap_8
XFILLER_0_31_75 VPWR VGND VPWR VGND sky130_ef_sc_hd__decap_12
X_5571_ _2417_ _2418_ VGND VGND VPWR VPWR _2419_ sky130_fd_sc_hd__or2_1
XFILLER_0_25_185 VGND VGND VPWR VPWR sky130_fd_sc_hd__decap_8
XFILLER_0_26_697 VGND VGND VPWR VPWR sky130_fd_sc_hd__decap_3
X_4522_ net391 _1605_ _1305_ _1609_ VGND VGND VPWR VPWR _0215_ sky130_fd_sc_hd__a22o_1
X_7310_ clknet_leaf_7_clk _0216_ net945 VGND VGND VPWR VPWR u_pe_array.act_from_right\[10\]\[9\]
+ sky130_fd_sc_hd__dfrtp_1
Xhold204 _0349_ VGND VGND VPWR VPWR net278 sky130_fd_sc_hd__dlygate4sd3_1
X_7241_ clknet_leaf_14_clk _0147_ net942 VGND VGND VPWR VPWR u_pe_array.g_pe_row\[3\].g_pe_col\[1\].u_pe.psum_out\[9\]
+ sky130_fd_sc_hd__dfrtp_1
Xhold226 _0542_ VGND VGND VPWR VPWR net300 sky130_fd_sc_hd__dlygate4sd3_1
X_4453_ _1487_ _1555_ _1556_ _1356_ net928 VGND VGND VPWR VPWR _0199_ sky130_fd_sc_hd__a32o_1
XFILLER_0_41_656 VPWR VGND VPWR VGND sky130_ef_sc_hd__decap_12
Xhold215 u_pe_array.g_pe_row\[2\].g_pe_col\[2\].u_pe.move_reg\[10\] VGND VGND VPWR
+ VPWR net289 sky130_fd_sc_hd__dlygate4sd3_1
Xhold237 _0232_ VGND VGND VPWR VPWR net311 sky130_fd_sc_hd__dlygate4sd3_1
Xhold259 u_pe_array.act_from_right\[10\]\[0\] VGND VGND VPWR VPWR net333 sky130_fd_sc_hd__dlygate4sd3_1
XFILLER_0_40_177 VPWR VGND VPWR VGND sky130_ef_sc_hd__decap_12
Xhold248 _0223_ VGND VGND VPWR VPWR net322 sky130_fd_sc_hd__dlygate4sd3_1
X_4384_ _1487_ _1492_ _1493_ _1356_ net687 VGND VGND VPWR VPWR _0193_ sky130_fd_sc_hd__a32o_1
X_7172_ clknet_leaf_96_clk _0078_ net945 VGND VGND VPWR VPWR u_pe_array.act_from_left\[15\]\[7\]
+ sky130_fd_sc_hd__dfrtp_1
X_6123_ u_pe_array.g_pe_row\[0\].g_pe_col\[3\].u_pe.psum_out\[9\] u_pe_array.g_pe_row\[0\].g_pe_col\[3\].u_pe.move_reg\[9\]
+ _2844_ VGND VGND VPWR VPWR _2856_ sky130_fd_sc_hd__mux2_1
XTAP_520 VGND VPWR sky130_fd_sc_hd__tapvpwrvgnd_1
XTAP_531 VGND VPWR sky130_fd_sc_hd__tapvpwrvgnd_1
XTAP_542 VGND VPWR sky130_fd_sc_hd__tapvpwrvgnd_1
XTAP_553 VGND VPWR sky130_fd_sc_hd__tapvpwrvgnd_1
XTAP_564 VGND VPWR sky130_fd_sc_hd__tapvpwrvgnd_1
XTAP_575 VGND VPWR sky130_fd_sc_hd__tapvpwrvgnd_1
X_6054_ _2795_ _2802_ _2803_ _2621_ net927 VGND VGND VPWR VPWR _0553_ sky130_fd_sc_hd__a32o_1
X_5005_ _1981_ _1982_ VGND VGND VPWR VPWR _1983_ sky130_fd_sc_hd__nand2_1
XFILLER_0_56_72 VGND VGND VPWR VPWR sky130_fd_sc_hd__fill_1
XTAP_597 VGND VPWR sky130_fd_sc_hd__tapvpwrvgnd_1
XTAP_586 VGND VPWR sky130_fd_sc_hd__tapvpwrvgnd_1
XTAP_1719 VGND VPWR sky130_fd_sc_hd__tapvpwrvgnd_1
XTAP_1708 VGND VPWR sky130_fd_sc_hd__tapvpwrvgnd_1
X_6956_ _2676_ _3463_ VGND VGND VPWR VPWR _3464_ sky130_fd_sc_hd__nand2_1
XFILLER_0_48_211 VGND VGND VPWR VPWR sky130_fd_sc_hd__fill_1
XFILLER_0_76_531 VGND VGND VPWR VPWR sky130_fd_sc_hd__fill_1
X_5907_ u_pe_array.u_fifo1.rd_ptr\[2\] _2675_ u_pe_array.u_fifo1.rd_ptr\[3\] VGND
+ VGND VPWR VPWR _2677_ sky130_fd_sc_hd__o21ba_1
XFILLER_0_76_586 VGND VGND VPWR VPWR sky130_fd_sc_hd__fill_2
X_6887_ _3424_ VGND VGND VPWR VPWR _0765_ sky130_fd_sc_hd__clkbuf_1
X_5838_ net926 _2632_ _2273_ VGND VGND VPWR VPWR _2633_ sky130_fd_sc_hd__mux2_1
X_5769_ _2558_ _2560_ _2573_ VGND VGND VPWR VPWR _2574_ sky130_fd_sc_hd__a21oi_1
XFILLER_0_91_578 VPWR VGND VPWR VGND sky130_ef_sc_hd__decap_12
X_7508_ clknet_leaf_38_clk _0414_ net947 VGND VGND VPWR VPWR u_pe_array.act_from_right\[5\]\[2\]
+ sky130_fd_sc_hd__dfrtp_1
XFILLER_0_16_185 VGND VGND VPWR VPWR sky130_fd_sc_hd__fill_1
XFILLER_0_17_697 VGND VGND VPWR VPWR sky130_fd_sc_hd__decap_8
XFILLER_0_71_291 VGND VGND VPWR VPWR sky130_fd_sc_hd__fill_2
XFILLER_0_32_645 VPWR VGND VPWR VGND sky130_ef_sc_hd__decap_12
XFILLER_0_114_393 VPWR VGND VPWR VGND sky130_ef_sc_hd__decap_12
XFILLER_0_102_533 VGND VGND VPWR VPWR sky130_fd_sc_hd__decap_3
X_7439_ clknet_leaf_35_clk net182 net951 VGND VGND VPWR VPWR u_pe_array.g_pe_row\[2\].g_pe_col\[0\].u_pe.act_val\[2\]
+ sky130_fd_sc_hd__dfrtp_2
XFILLER_0_31_177 VGND VGND VPWR VPWR sky130_fd_sc_hd__decap_3
Xhold771 net60 VGND VGND VPWR VPWR net845 sky130_fd_sc_hd__dlygate4sd3_1
Xhold782 u_pe_array.g_pe_row\[3\].g_pe_col\[3\].u_pe.move_reg\[8\] VGND VGND VPWR
+ VPWR net856 sky130_fd_sc_hd__dlygate4sd3_1
XFILLER_0_12_391 VGND VGND VPWR VPWR sky130_fd_sc_hd__decap_3
Xhold760 u_pe_array.u_fifo1.buffer\[8\]\[2\] VGND VGND VPWR VPWR net834 sky130_fd_sc_hd__dlygate4sd3_1
Xhold793 u_pe_array.u_fifo2.wr_ptr\[1\] VGND VGND VPWR VPWR net867 sky130_fd_sc_hd__dlygate4sd3_1
XFILLER_0_39_222 VGND VGND VPWR VPWR sky130_fd_sc_hd__fill_2
XFILLER_0_39_266 VGND VGND VPWR VPWR sky130_fd_sc_hd__fill_1
XFILLER_0_109_143 VGND VGND VPWR VPWR sky130_fd_sc_hd__decap_4
XFILLER_0_27_439 VGND VGND VPWR VPWR sky130_fd_sc_hd__decap_6
XFILLER_0_109_187 VGND VGND VPWR VPWR sky130_fd_sc_hd__decap_3
XFILLER_0_105_393 VGND VGND VPWR VPWR sky130_fd_sc_hd__decap_4
XFILLER_0_93_15 VPWR VGND VPWR VGND sky130_ef_sc_hd__decap_12
XFILLER_0_117_55 VGND VGND VPWR VPWR sky130_fd_sc_hd__fill_1
X_6810_ _3376_ _3377_ VGND VGND VPWR VPWR _0735_ sky130_fd_sc_hd__nor2_1
X_7790_ clknet_leaf_65_clk _0696_ net946 VGND VGND VPWR VPWR u_pe_array.act_from_up\[4\]\[12\]
+ sky130_fd_sc_hd__dfrtp_1
XFILLER_0_9_105 VGND VGND VPWR VPWR sky130_fd_sc_hd__decap_6
X_6741_ u_pe_array.g_pe_row\[0\].g_pe_col\[0\].u_pe.psum_out\[9\] _2488_ VGND VGND
+ VPWR VPWR _3325_ sky130_fd_sc_hd__or2_1
XFILLER_0_92_309 VGND VGND VPWR VPWR sky130_fd_sc_hd__decap_4
XFILLER_0_85_372 VGND VGND VPWR VPWR sky130_fd_sc_hd__fill_1
X_3953_ net772 _1167_ _1169_ _1170_ VGND VGND VPWR VPWR _0085_ sky130_fd_sc_hd__a22o_1
X_6672_ _3253_ _3251_ _3260_ _3261_ VGND VGND VPWR VPWR _3263_ sky130_fd_sc_hd__a211o_1
X_3884_ u_pe_array.g_pe_row\[3\].g_pe_col\[2\].u_pe.act_val\[3\] VGND VGND VPWR VPWR
+ _1126_ sky130_fd_sc_hd__inv_2
XFILLER_0_45_225 VGND VGND VPWR VPWR sky130_fd_sc_hd__decap_4
XFILLER_0_116_625 VPWR VGND VPWR VGND sky130_ef_sc_hd__decap_12
XFILLER_0_115_113 VPWR VGND VPWR VGND sky130_ef_sc_hd__decap_12
XFILLER_0_26_450 VGND VGND VPWR VPWR sky130_fd_sc_hd__fill_1
X_5623_ _2458_ _2460_ _2465_ VGND VGND VPWR VPWR _2466_ sky130_fd_sc_hd__o21ai_1
XFILLER_0_116_669 VPWR VGND VPWR VGND sky130_ef_sc_hd__decap_12
XFILLER_0_73_589 VGND VGND VPWR VPWR sky130_fd_sc_hd__decap_4
XFILLER_0_5_333 VGND VGND VPWR VPWR sky130_fd_sc_hd__decap_3
XFILLER_0_13_133 VGND VGND VPWR VPWR sky130_fd_sc_hd__fill_1
X_5554_ _2395_ _2396_ _2401_ VGND VGND VPWR VPWR _2403_ sky130_fd_sc_hd__o21ai_1
XFILLER_0_13_177 VGND VGND VPWR VPWR sky130_fd_sc_hd__fill_2
X_5485_ u_pe_array.u_fifo2.buffer\[8\]\[1\] _2322_ _2344_ _2348_ _0857_ VGND VGND
+ VPWR VPWR _2349_ sky130_fd_sc_hd__a221o_1
X_4505_ net333 _1301_ _1305_ _1600_ VGND VGND VPWR VPWR _0207_ sky130_fd_sc_hd__a22o_1
X_7224_ clknet_leaf_17_clk net749 net943 VGND VGND VPWR VPWR u_pe_array.g_pe_row\[3\].g_pe_col\[1\].u_pe.act_val\[5\]
+ sky130_fd_sc_hd__dfrtp_1
X_4436_ _1538_ _1540_ VGND VGND VPWR VPWR _1541_ sky130_fd_sc_hd__xnor2_1
XFILLER_0_13_188 VGND VGND VPWR VPWR sky130_fd_sc_hd__decap_6
XFILLER_0_6_41 VPWR VGND VPWR VGND sky130_ef_sc_hd__decap_12
XFILLER_0_1_561 VPWR VGND VPWR VGND sky130_ef_sc_hd__decap_12
XFILLER_0_41_497 VGND VGND VPWR VPWR sky130_fd_sc_hd__decap_6
X_4367_ net362 _1310_ _1175_ u_pe_array.g_pe_row\[3\].g_pe_col\[0\].u_pe.move_reg\[8\]
+ VGND VGND VPWR VPWR _0187_ sky130_fd_sc_hd__a22o_1
X_7155_ clknet_leaf_6_clk _0061_ net945 VGND VGND VPWR VPWR u_pe_array.act_from_right\[13\]\[3\]
+ sky130_fd_sc_hd__dfrtp_1
X_6106_ net326 _2499_ _2491_ _2846_ VGND VGND VPWR VPWR _0562_ sky130_fd_sc_hd__a22o_1
XTAP_350 VGND VPWR sky130_fd_sc_hd__tapvpwrvgnd_1
XFILLER_0_6_85 VPWR VGND VPWR VGND sky130_ef_sc_hd__decap_12
X_4298_ net56 _1443_ _1116_ VGND VGND VPWR VPWR _1444_ sky130_fd_sc_hd__mux2_1
XTAP_394 VGND VPWR sky130_fd_sc_hd__tapvpwrvgnd_1
XTAP_383 VGND VPWR sky130_fd_sc_hd__tapvpwrvgnd_1
XTAP_372 VGND VPWR sky130_fd_sc_hd__tapvpwrvgnd_1
XTAP_361 VGND VPWR sky130_fd_sc_hd__tapvpwrvgnd_1
X_7086_ _3540_ VGND VGND VPWR VPWR _0848_ sky130_fd_sc_hd__clkbuf_1
X_6037_ _2751_ _2759_ _2758_ VGND VGND VPWR VPWR _2788_ sky130_fd_sc_hd__a21o_1
XTAP_1505 VGND VPWR sky130_fd_sc_hd__tapvpwrvgnd_1
XFILLER_0_96_637 VGND VGND VPWR VPWR sky130_fd_sc_hd__decap_6
XPHY_12 VGND VGND VPWR VPWR sky130_fd_sc_hd__decap_3
XTAP_1538 VGND VPWR sky130_fd_sc_hd__tapvpwrvgnd_1
XTAP_1527 VGND VPWR sky130_fd_sc_hd__tapvpwrvgnd_1
XTAP_1516 VGND VPWR sky130_fd_sc_hd__tapvpwrvgnd_1
XPHY_23 VGND VGND VPWR VPWR sky130_fd_sc_hd__decap_3
XPHY_34 VGND VGND VPWR VPWR sky130_fd_sc_hd__decap_3
XPHY_45 VGND VGND VPWR VPWR sky130_fd_sc_hd__decap_3
XPHY_56 VGND VGND VPWR VPWR sky130_fd_sc_hd__decap_3
XTAP_1549 VGND VPWR sky130_fd_sc_hd__tapvpwrvgnd_1
XFILLER_0_95_169 VGND VGND VPWR VPWR sky130_fd_sc_hd__fill_1
XFILLER_0_76_361 VGND VGND VPWR VPWR sky130_fd_sc_hd__decap_3
X_6939_ _1424_ u_pe_array.g_pe_row\[3\].g_pe_col\[3\].u_pe.w_out\[0\] net63 VGND VGND
+ VPWR VPWR _3453_ sky130_fd_sc_hd__mux2_1
XPHY_67 VGND VGND VPWR VPWR sky130_fd_sc_hd__decap_3
XFILLER_0_37_704 VGND VGND VPWR VPWR sky130_fd_sc_hd__fill_1
XPHY_78 VGND VGND VPWR VPWR sky130_fd_sc_hd__decap_3
XPHY_89 VGND VGND VPWR VPWR sky130_fd_sc_hd__decap_3
XFILLER_0_51_228 VGND VGND VPWR VPWR sky130_fd_sc_hd__decap_6
XFILLER_0_32_431 VGND VGND VPWR VPWR sky130_fd_sc_hd__decap_4
XFILLER_0_32_475 VGND VGND VPWR VPWR sky130_fd_sc_hd__fill_1
XFILLER_0_102_352 VGND VGND VPWR VPWR sky130_fd_sc_hd__decap_4
Xhold590 u_pe_array.u_fifo1.buffer\[5\]\[5\] VGND VGND VPWR VPWR net664 sky130_fd_sc_hd__dlygate4sd3_1
XFILLER_0_99_431 VGND VGND VPWR VPWR sky130_fd_sc_hd__decap_8
XFILLER_0_59_328 VGND VGND VPWR VPWR sky130_fd_sc_hd__decap_8
XFILLER_0_74_309 VGND VGND VPWR VPWR sky130_fd_sc_hd__decap_4
XFILLER_0_27_225 VGND VGND VPWR VPWR sky130_fd_sc_hd__decap_8
XFILLER_0_103_57 VPWR VGND VPWR VGND sky130_ef_sc_hd__decap_12
XFILLER_0_88_15 VPWR VGND VPWR VGND sky130_ef_sc_hd__decap_12
X_5270_ u_pe_array.g_pe_row\[1\].g_pe_col\[3\].u_pe.psum_out\[1\] _1426_ VGND VGND
+ VPWR VPWR _2174_ sky130_fd_sc_hd__nand2_1
X_4221_ u_pe_array.g_pe_row\[3\].g_pe_col\[1\].u_pe.psum_out\[7\] VGND VGND VPWR VPWR
+ _1379_ sky130_fd_sc_hd__inv_2
X_4152_ _1312_ _1313_ _1314_ VGND VGND VPWR VPWR _1316_ sky130_fd_sc_hd__or3_1
X_4083_ u_pe_array.g_pe_row\[3\].g_pe_col\[2\].u_pe.psum_out\[11\] _1277_ _1267_ VGND
+ VGND VPWR VPWR _1278_ sky130_fd_sc_hd__mux2_1
X_7911_ clknet_leaf_76_clk _0816_ VGND VGND VPWR VPWR u_pe_array.u_fifo1.buffer\[2\]\[1\]
+ sky130_fd_sc_hd__dfxtp_1
X_7842_ clknet_leaf_98_clk _0747_ VGND VGND VPWR VPWR u_pe_array.u_fifo2.buffer\[1\]\[0\]
+ sky130_fd_sc_hd__dfxtp_1
X_4985_ u_pe_array.g_pe_row\[2\].g_pe_col\[1\].u_pe.psum_out\[8\] _1105_ VGND VGND
+ VPWR VPWR _1965_ sky130_fd_sc_hd__nand2_1
X_7773_ clknet_leaf_44_clk _0679_ net947 VGND VGND VPWR VPWR u_pe_array.g_pe_row\[0\].g_pe_col\[1\].u_pe.psum_out\[10\]
+ sky130_fd_sc_hd__dfrtp_2
XFILLER_0_77_169 VPWR VGND VPWR VGND sky130_ef_sc_hd__decap_12
XFILLER_0_77_158 VGND VGND VPWR VPWR sky130_fd_sc_hd__decap_8
X_6724_ _3297_ VGND VGND VPWR VPWR _3310_ sky130_fd_sc_hd__inv_2
X_3936_ _1131_ net861 _1159_ VGND VGND VPWR VPWR _1164_ sky130_fd_sc_hd__mux2_1
XFILLER_0_6_620 VGND VGND VPWR VPWR sky130_fd_sc_hd__fill_1
XFILLER_0_46_567 VGND VGND VPWR VPWR sky130_fd_sc_hd__fill_1
X_6655_ u_pe_array.g_pe_row\[0\].g_pe_col\[0\].u_pe.psum_out\[1\] _2488_ VGND VGND
+ VPWR VPWR _3247_ sky130_fd_sc_hd__xor2_1
XFILLER_0_6_653 VGND VGND VPWR VPWR sky130_fd_sc_hd__decap_6
X_3867_ _0946_ VGND VGND VPWR VPWR _1112_ sky130_fd_sc_hd__buf_8
XFILLER_0_116_477 VGND VGND VPWR VPWR sky130_fd_sc_hd__decap_3
XFILLER_0_103_105 VGND VGND VPWR VPWR sky130_fd_sc_hd__decap_6
X_6586_ _3203_ _3204_ _3209_ _3206_ _3201_ VGND VGND VPWR VPWR _3210_ sky130_fd_sc_hd__a32o_1
X_3798_ _1026_ _1027_ _1037_ _1039_ VGND VGND VPWR VPWR _1052_ sky130_fd_sc_hd__o22a_1
XFILLER_0_6_697 VGND VGND VPWR VPWR sky130_fd_sc_hd__decap_3
X_5606_ _2426_ _2427_ _2437_ _2447_ VGND VGND VPWR VPWR _2450_ sky130_fd_sc_hd__or4_1
XFILLER_0_14_453 VGND VGND VPWR VPWR sky130_fd_sc_hd__decap_8
X_5537_ u_pe_array.g_pe_row\[1\].g_pe_col\[2\].u_pe.act_val\[2\] _1595_ VGND VGND
+ VPWR VPWR _2387_ sky130_fd_sc_hd__nand2_1
X_7207_ clknet_leaf_22_clk _0113_ net942 VGND VGND VPWR VPWR u_pe_array.act_from_down\[9\]\[1\]
+ sky130_fd_sc_hd__dfrtp_1
XFILLER_0_78_70 VGND VGND VPWR VPWR sky130_fd_sc_hd__fill_2
X_5468_ u_pe_array.u_fifo2.rd_ptr\[1\] u_pe_array.u_fifo2.rd_ptr\[3\] u_pe_array.u_fifo2.rd_ptr\[2\]
+ u_pe_array.u_fifo2.rd_ptr\[0\] VGND VGND VPWR VPWR _2333_ sky130_fd_sc_hd__and4bb_2
XFILLER_0_10_681 VPWR VGND VPWR VGND sky130_ef_sc_hd__decap_12
X_5399_ u_pe_array.g_pe_row\[1\].g_pe_col\[2\].u_pe.act_val\[4\] _1118_ VGND VGND
+ VPWR VPWR _2286_ sky130_fd_sc_hd__or2_1
X_4419_ _1516_ _1524_ _1003_ VGND VGND VPWR VPWR _1526_ sky130_fd_sc_hd__a21o_1
X_7138_ clknet_leaf_4_clk _0044_ net945 VGND VGND VPWR VPWR u_pe_array.g_pe_row\[3\].g_pe_col\[3\].u_pe.psum_out\[1\]
+ sky130_fd_sc_hd__dfrtp_1
X_7069_ _3531_ VGND VGND VPWR VPWR _0840_ sky130_fd_sc_hd__clkbuf_1
XTAP_1313 VGND VPWR sky130_fd_sc_hd__tapvpwrvgnd_1
XTAP_1302 VGND VPWR sky130_fd_sc_hd__tapvpwrvgnd_1
XFILLER_0_96_489 VGND VGND VPWR VPWR sky130_fd_sc_hd__fill_1
XTAP_1357 VGND VPWR sky130_fd_sc_hd__tapvpwrvgnd_1
XTAP_1346 VGND VPWR sky130_fd_sc_hd__tapvpwrvgnd_1
XTAP_1324 VGND VPWR sky130_fd_sc_hd__tapvpwrvgnd_1
XTAP_1335 VGND VPWR sky130_fd_sc_hd__tapvpwrvgnd_1
XFILLER_0_83_106 VGND VGND VPWR VPWR sky130_fd_sc_hd__decap_6
XFILLER_0_56_309 VPWR VGND VPWR VGND sky130_ef_sc_hd__decap_12
XTAP_1379 VGND VPWR sky130_fd_sc_hd__tapvpwrvgnd_1
XTAP_1368 VGND VPWR sky130_fd_sc_hd__tapvpwrvgnd_1
XFILLER_0_77_681 VGND VGND VPWR VPWR sky130_fd_sc_hd__decap_3
XFILLER_0_37_534 VGND VGND VPWR VPWR sky130_fd_sc_hd__decap_3
XFILLER_0_107_422 VGND VGND VPWR VPWR sky130_fd_sc_hd__decap_3
Xinput19 v_in0[4] VGND VGND VPWR VPWR net19 sky130_fd_sc_hd__clkbuf_2
XFILLER_0_58_29 VGND VGND VPWR VPWR sky130_fd_sc_hd__fill_2
XFILLER_0_102_193 VGND VGND VPWR VPWR sky130_fd_sc_hd__decap_3
XFILLER_0_90_27 VGND VGND VPWR VPWR sky130_fd_sc_hd__fill_1
XFILLER_0_59_125 VGND VGND VPWR VPWR sky130_fd_sc_hd__fill_1
XFILLER_0_74_139 VGND VGND VPWR VPWR sky130_fd_sc_hd__fill_1
XFILLER_0_55_353 VGND VGND VPWR VPWR sky130_fd_sc_hd__decap_4
XFILLER_0_7_428 VPWR VGND VPWR VGND sky130_ef_sc_hd__decap_12
X_4770_ u_pe_array.g_pe_row\[2\].g_pe_col\[2\].u_pe.act_val\[5\] u_pe_array.g_pe_row\[2\].g_pe_col\[2\].u_pe.w_out\[0\]
+ VGND VGND VPWR VPWR _1794_ sky130_fd_sc_hd__nand2_1
XFILLER_0_83_673 VPWR VGND VPWR VGND sky130_ef_sc_hd__decap_12
XFILLER_0_82_172 VGND VGND VPWR VPWR sky130_fd_sc_hd__decap_8
X_3721_ _0980_ VGND VGND VPWR VPWR _0981_ sky130_fd_sc_hd__inv_2
XFILLER_0_23_98 VGND VGND VPWR VPWR sky130_fd_sc_hd__decap_6
X_6440_ _3100_ VGND VGND VPWR VPWR _0642_ sky130_fd_sc_hd__clkbuf_1
XFILLER_0_99_69 VPWR VGND VPWR VGND sky130_ef_sc_hd__decap_12
X_3652_ _0937_ VGND VGND VPWR VPWR _0938_ sky130_fd_sc_hd__buf_6
X_3583_ u_fsm.cnt\[0\] u_fsm.cnt\[1\] VGND VGND VPWR VPWR _0888_ sky130_fd_sc_hd__or2_1
X_6371_ _3029_ _3030_ _3027_ VGND VGND VPWR VPWR _3041_ sky130_fd_sc_hd__o21ba_1
X_5322_ _2194_ _2201_ _2210_ _2221_ _2209_ VGND VGND VPWR VPWR _2222_ sky130_fd_sc_hd__o32a_1
XFILLER_0_2_133 VGND VGND VPWR VPWR sky130_fd_sc_hd__decap_6
XFILLER_0_2_177 VPWR VGND VPWR VGND sky130_ef_sc_hd__decap_12
X_5253_ net489 _0939_ VGND VGND VPWR VPWR _2160_ sky130_fd_sc_hd__and2_1
X_5184_ _1286_ u_pe_array.g_pe_row\[2\].g_pe_col\[0\].u_pe.psum_out\[11\] VGND VGND
+ VPWR VPWR _2120_ sky130_fd_sc_hd__and2b_1
X_4204_ _1362_ _1363_ VGND VGND VPWR VPWR _1364_ sky130_fd_sc_hd__nor2_1
X_4135_ u_pe_array.g_pe_row\[3\].g_pe_col\[1\].u_pe.act_val\[4\] _1301_ _1305_ net642
+ VGND VGND VPWR VPWR _0129_ sky130_fd_sc_hd__a22o_1
X_4066_ _1255_ _1257_ _1262_ VGND VGND VPWR VPWR _1263_ sky130_fd_sc_hd__o21ai_1
XFILLER_0_64_83 VGND VGND VPWR VPWR sky130_fd_sc_hd__fill_1
X_7825_ clknet_leaf_85_clk _0730_ net948 VGND VGND VPWR VPWR u_pe_array.u_fifo2.wr_ptr\[1\]
+ sky130_fd_sc_hd__dfrtp_4
XFILLER_0_19_512 VGND VGND VPWR VPWR sky130_fd_sc_hd__decap_4
X_4968_ _1944_ _1949_ VGND VGND VPWR VPWR _1950_ sky130_fd_sc_hd__or2_1
X_7756_ clknet_leaf_48_clk net203 net947 VGND VGND VPWR VPWR u_pe_array.g_pe_row\[0\].g_pe_col\[1\].u_pe.move_reg\[6\]
+ sky130_fd_sc_hd__dfrtp_1
XFILLER_0_58_180 VGND VGND VPWR VPWR sky130_fd_sc_hd__decap_6
XFILLER_0_19_567 VGND VGND VPWR VPWR sky130_fd_sc_hd__fill_1
XFILLER_0_46_331 VGND VGND VPWR VPWR sky130_fd_sc_hd__fill_2
X_6707_ _3291_ _3293_ VGND VGND VPWR VPWR _3295_ sky130_fd_sc_hd__or2_1
X_4899_ _1886_ VGND VGND VPWR VPWR _1887_ sky130_fd_sc_hd__inv_2
X_7687_ clknet_leaf_58_clk _0593_ net74 VGND VGND VPWR VPWR u_pe_array.g_pe_row\[0\].g_pe_col\[3\].u_pe.psum_out\[6\]
+ sky130_fd_sc_hd__dfrtp_1
XFILLER_0_74_695 VGND VGND VPWR VPWR sky130_fd_sc_hd__fill_1
XFILLER_0_61_301 VGND VGND VPWR VPWR sky130_fd_sc_hd__fill_1
X_3919_ u_pe_array.g_pe_row\[3\].g_pe_col\[2\].u_pe.psum_out\[11\] _1112_ _1109_ _1152_
+ VGND VGND VPWR VPWR _1153_ sky130_fd_sc_hd__o211a_1
X_6638_ u_pe_array.g_pe_row\[0\].g_pe_col\[0\].u_pe.act_val\[1\] _2343_ _2320_ net279
+ VGND VGND VPWR VPWR _0698_ sky130_fd_sc_hd__a22o_1
XFILLER_0_61_334 VGND VGND VPWR VPWR sky130_fd_sc_hd__fill_2
XFILLER_0_6_472 VGND VGND VPWR VPWR sky130_fd_sc_hd__decap_4
XFILLER_0_46_397 VGND VGND VPWR VPWR sky130_fd_sc_hd__fill_2
X_6569_ u_pe_array.g_pe_row\[0\].g_pe_col\[1\].u_pe.psum_out\[8\] _2268_ VGND VGND
+ VPWR VPWR _3195_ sky130_fd_sc_hd__nand2_1
XFILLER_0_100_653 VPWR VGND VPWR VGND sky130_ef_sc_hd__decap_12
XFILLER_0_100_631 VGND VGND VPWR VPWR sky130_fd_sc_hd__fill_2
XFILLER_0_100_697 VGND VGND VPWR VPWR sky130_fd_sc_hd__decap_3
XFILLER_0_96_253 VGND VGND VPWR VPWR sky130_fd_sc_hd__fill_1
XTAP_1132 VGND VPWR sky130_fd_sc_hd__tapvpwrvgnd_1
XTAP_1121 VGND VPWR sky130_fd_sc_hd__tapvpwrvgnd_1
XTAP_1110 VGND VPWR sky130_fd_sc_hd__tapvpwrvgnd_1
XFILLER_0_29_309 VGND VGND VPWR VPWR sky130_fd_sc_hd__fill_2
XTAP_1154 VGND VPWR sky130_fd_sc_hd__tapvpwrvgnd_1
XTAP_1165 VGND VPWR sky130_fd_sc_hd__tapvpwrvgnd_1
XTAP_1143 VGND VPWR sky130_fd_sc_hd__tapvpwrvgnd_1
XFILLER_0_57_629 VGND VGND VPWR VPWR sky130_fd_sc_hd__fill_2
XFILLER_0_56_128 VGND VGND VPWR VPWR sky130_fd_sc_hd__fill_1
XTAP_1198 VGND VPWR sky130_fd_sc_hd__tapvpwrvgnd_1
XTAP_1187 VGND VPWR sky130_fd_sc_hd__tapvpwrvgnd_1
XTAP_1176 VGND VPWR sky130_fd_sc_hd__tapvpwrvgnd_1
XFILLER_0_71_109 VGND VGND VPWR VPWR sky130_fd_sc_hd__decap_3
XFILLER_0_65_673 VGND VGND VPWR VPWR sky130_fd_sc_hd__fill_2
XFILLER_0_80_643 VGND VGND VPWR VPWR sky130_fd_sc_hd__fill_1
XFILLER_0_25_559 VGND VGND VPWR VPWR sky130_fd_sc_hd__fill_1
XFILLER_0_52_312 VGND VGND VPWR VPWR sky130_fd_sc_hd__fill_1
XFILLER_0_107_296 VGND VGND VPWR VPWR sky130_fd_sc_hd__fill_1
XFILLER_0_52_378 VGND VGND VPWR VPWR sky130_fd_sc_hd__decap_8
XFILLER_0_0_604 VPWR VGND VPWR VGND sky130_ef_sc_hd__decap_12
XFILLER_0_40_529 VGND VGND VPWR VPWR sky130_fd_sc_hd__decap_3
XFILLER_0_0_637 VGND VGND VPWR VPWR sky130_fd_sc_hd__fill_1
XFILLER_0_20_253 VGND VGND VPWR VPWR sky130_fd_sc_hd__decap_3
XTAP_916 VGND VPWR sky130_fd_sc_hd__tapvpwrvgnd_1
XTAP_905 VGND VPWR sky130_fd_sc_hd__tapvpwrvgnd_1
XTAP_949 VGND VPWR sky130_fd_sc_hd__tapvpwrvgnd_1
XTAP_938 VGND VPWR sky130_fd_sc_hd__tapvpwrvgnd_1
XTAP_927 VGND VPWR sky130_fd_sc_hd__tapvpwrvgnd_1
X_5940_ u_pe_array.act_from_up\[4\]\[2\] _2341_ VGND VGND VPWR VPWR _2708_ sky130_fd_sc_hd__or2_1
XFILLER_0_34_64 VPWR VGND VPWR VGND sky130_ef_sc_hd__decap_12
X_7610_ clknet_leaf_49_clk _0516_ net73 VGND VGND VPWR VPWR net48 sky130_fd_sc_hd__dfrtp_1
X_5871_ u_pe_array.g_pe_row\[1\].g_pe_col\[0\].u_pe.psum_out\[9\] _1112_ _1109_ _2657_
+ VGND VGND VPWR VPWR _2658_ sky130_fd_sc_hd__o211a_2
X_4822_ _1831_ _1839_ _1840_ _1841_ VGND VGND VPWR VPWR _1842_ sky130_fd_sc_hd__a31o_1
X_7541_ clknet_leaf_66_clk net201 net72 VGND VGND VPWR VPWR u_pe_array.g_pe_row\[1\].g_pe_col\[2\].u_pe.move_reg\[9\]
+ sky130_fd_sc_hd__dfrtp_1
X_4753_ _1776_ _1778_ VGND VGND VPWR VPWR _1779_ sky130_fd_sc_hd__nor2_1
XFILLER_0_7_225 VPWR VGND VPWR VGND sky130_ef_sc_hd__decap_12
XFILLER_0_114_701 VGND VGND VPWR VPWR sky130_fd_sc_hd__decap_4
X_7472_ clknet_leaf_64_clk net531 net946 VGND VGND VPWR VPWR u_pe_array.act_from_down\[3\]\[7\]
+ sky130_fd_sc_hd__dfrtp_1
X_3704_ _0970_ VGND VGND VPWR VPWR _0036_ sky130_fd_sc_hd__clkbuf_1
XFILLER_0_71_643 VPWR VGND VPWR VGND sky130_ef_sc_hd__decap_12
XFILLER_0_7_269 VGND VGND VPWR VPWR sky130_fd_sc_hd__decap_8
XFILLER_0_16_526 VGND VGND VPWR VPWR sky130_fd_sc_hd__decap_6
XFILLER_0_16_559 VGND VGND VPWR VPWR sky130_fd_sc_hd__fill_2
XFILLER_0_50_85 VPWR VGND VPWR VGND sky130_ef_sc_hd__decap_12
X_4684_ net564 _1732_ _1735_ _1737_ VGND VGND VPWR VPWR _0249_ sky130_fd_sc_hd__a22o_1
XFILLER_0_43_345 VGND VGND VPWR VPWR sky130_fd_sc_hd__decap_4
X_6423_ _3082_ _3086_ VGND VGND VPWR VPWR _3088_ sky130_fd_sc_hd__or2_1
XFILLER_0_71_698 VGND VGND VPWR VPWR sky130_fd_sc_hd__decap_6
X_3635_ _0925_ VGND VGND VPWR VPWR _0012_ sky130_fd_sc_hd__clkbuf_1
XFILLER_0_101_406 VPWR VGND VPWR VGND sky130_ef_sc_hd__decap_12
XFILLER_0_3_497 VGND VGND VPWR VPWR sky130_fd_sc_hd__decap_6
X_3566_ u_fsm.state\[1\] u_fsm.state\[0\] VGND VGND VPWR VPWR _0874_ sky130_fd_sc_hd__nor2_2
X_6354_ _3020_ _3024_ VGND VGND VPWR VPWR _3025_ sky130_fd_sc_hd__xnor2_1
X_5305_ u_pe_array.g_pe_row\[1\].g_pe_col\[3\].u_pe.act_val\[4\] _2164_ _2204_ _2205_
+ VGND VGND VPWR VPWR _2206_ sky130_fd_sc_hd__or4_2
X_6285_ u_pe_array.g_pe_row\[0\].g_pe_col\[2\].u_pe.psum_out\[6\] u_pe_array.g_pe_row\[0\].g_pe_col\[2\].u_pe.move_reg\[6\]
+ _2844_ VGND VGND VPWR VPWR _2980_ sky130_fd_sc_hd__mux2_1
X_5236_ net801 _2143_ _2132_ _2151_ VGND VGND VPWR VPWR _0387_ sky130_fd_sc_hd__a22o_1
XFILLER_0_52_3 VGND VGND VPWR VPWR sky130_fd_sc_hd__decap_8
X_5167_ u_pe_array.g_pe_row\[2\].g_pe_col\[0\].u_pe.psum_out\[9\] _1286_ VGND VGND
+ VPWR VPWR _2105_ sky130_fd_sc_hd__or2_1
XFILLER_0_98_529 VGND VGND VPWR VPWR sky130_fd_sc_hd__decap_3
X_5098_ _2034_ _2035_ _2041_ VGND VGND VPWR VPWR _2042_ sky130_fd_sc_hd__nor3_1
X_4118_ u_pe_array.g_pe_row\[3\].g_pe_col\[1\].u_pe.psum_out\[10\] u_pe_array.g_pe_row\[3\].g_pe_col\[1\].u_pe.move_reg\[10\]
+ _0947_ VGND VGND VPWR VPWR _1299_ sky130_fd_sc_hd__mux2_1
XFILLER_0_78_220 VPWR VGND VPWR VGND sky130_ef_sc_hd__decap_12
X_4049_ _1223_ _1224_ _1234_ _1244_ VGND VGND VPWR VPWR _1247_ sky130_fd_sc_hd__or4_1
XPHY_215 VGND VGND VPWR VPWR sky130_fd_sc_hd__decap_3
XPHY_204 VGND VGND VPWR VPWR sky130_fd_sc_hd__decap_3
XFILLER_0_93_223 VGND VGND VPWR VPWR sky130_fd_sc_hd__fill_1
XPHY_237 VGND VGND VPWR VPWR sky130_fd_sc_hd__decap_3
XPHY_226 VGND VGND VPWR VPWR sky130_fd_sc_hd__decap_3
XFILLER_0_109_517 VPWR VGND VPWR VGND sky130_ef_sc_hd__decap_12
X_7808_ clknet_leaf_55_clk _0713_ net74 VGND VGND VPWR VPWR u_pe_array.g_pe_row\[0\].g_pe_col\[0\].u_pe.psum_out\[3\]
+ sky130_fd_sc_hd__dfrtp_1
X_7739_ clknet_leaf_54_clk _0645_ net74 VGND VGND VPWR VPWR u_pe_array.act_from_right\[0\]\[2\]
+ sky130_fd_sc_hd__dfrtp_1
XFILLER_0_117_550 VGND VGND VPWR VPWR sky130_fd_sc_hd__fill_1
XFILLER_0_62_676 VGND VGND VPWR VPWR sky130_fd_sc_hd__fill_1
XFILLER_0_61_164 VGND VGND VPWR VPWR sky130_fd_sc_hd__decap_4
XFILLER_0_22_529 VGND VGND VPWR VPWR sky130_fd_sc_hd__decap_3
Xhold8 _0487_ VGND VGND VPWR VPWR net82 sky130_fd_sc_hd__dlygate4sd3_1
XFILLER_0_69_231 VGND VGND VPWR VPWR sky130_fd_sc_hd__fill_1
XFILLER_0_25_334 VGND VGND VPWR VPWR sky130_fd_sc_hd__fill_2
XFILLER_0_112_6 VPWR VGND VPWR VGND sky130_ef_sc_hd__decap_12
XFILLER_0_111_57 VPWR VGND VPWR VGND sky130_ef_sc_hd__decap_12
XFILLER_0_53_687 VGND VGND VPWR VPWR sky130_fd_sc_hd__decap_3
Xhold408 _0794_ VGND VGND VPWR VPWR net482 sky130_fd_sc_hd__dlygate4sd3_1
XFILLER_0_25_389 VGND VGND VPWR VPWR sky130_fd_sc_hd__decap_3
Xhold419 u_pe_array.act_from_up\[6\]\[4\] VGND VGND VPWR VPWR net493 sky130_fd_sc_hd__dlygate4sd3_1
XFILLER_0_0_445 VGND VGND VPWR VPWR sky130_fd_sc_hd__decap_3
XFILLER_0_0_489 VGND VGND VPWR VPWR sky130_fd_sc_hd__decap_8
XFILLER_0_21_595 VGND VGND VPWR VPWR sky130_fd_sc_hd__fill_1
XTAP_702 VGND VPWR sky130_fd_sc_hd__tapvpwrvgnd_1
XTAP_713 VGND VPWR sky130_fd_sc_hd__tapvpwrvgnd_1
XTAP_724 VGND VPWR sky130_fd_sc_hd__tapvpwrvgnd_1
X_6070_ u_pe_array.g_pe_row\[1\].g_pe_col\[0\].u_pe.psum_out\[9\] _1865_ VGND VGND
+ VPWR VPWR _2818_ sky130_fd_sc_hd__or2_1
XFILLER_0_29_64 VGND VGND VPWR VPWR sky130_fd_sc_hd__decap_4
XTAP_735 VGND VPWR sky130_fd_sc_hd__tapvpwrvgnd_1
XTAP_757 VGND VPWR sky130_fd_sc_hd__tapvpwrvgnd_1
XTAP_746 VGND VPWR sky130_fd_sc_hd__tapvpwrvgnd_1
XTAP_768 VGND VPWR sky130_fd_sc_hd__tapvpwrvgnd_1
X_5021_ _1995_ _1996_ VGND VGND VPWR VPWR _1997_ sky130_fd_sc_hd__xnor2_1
XFILLER_0_29_97 VPWR VGND VPWR VGND sky130_ef_sc_hd__decap_12
XTAP_779 VGND VPWR sky130_fd_sc_hd__tapvpwrvgnd_1
X_6972_ u_pe_array.u_fifo1.count\[0\] _3475_ VGND VGND VPWR VPWR _3476_ sky130_fd_sc_hd__nand2_1
XFILLER_0_88_595 VGND VGND VPWR VPWR sky130_fd_sc_hd__decap_6
XFILLER_0_75_212 VGND VGND VPWR VPWR sky130_fd_sc_hd__fill_1
X_5923_ u_pe_array.u_fifo1.buffer\[8\]\[0\] _2676_ _2679_ _2692_ _0857_ VGND VGND
+ VPWR VPWR _2693_ sky130_fd_sc_hd__a221o_1
XFILLER_0_48_415 VGND VGND VPWR VPWR sky130_fd_sc_hd__decap_4
XFILLER_0_118_303 VGND VGND VPWR VPWR sky130_fd_sc_hd__decap_4
XFILLER_0_75_234 VGND VGND VPWR VPWR sky130_fd_sc_hd__decap_6
XFILLER_0_0_54 VGND VGND VPWR VPWR sky130_fd_sc_hd__fill_2
X_5854_ _2644_ _0946_ VGND VGND VPWR VPWR _2645_ sky130_fd_sc_hd__nand2_1
X_4805_ _1810_ _1823_ VGND VGND VPWR VPWR _1826_ sky130_fd_sc_hd__and2b_1
XFILLER_0_29_673 VPWR VGND VPWR VGND sky130_ef_sc_hd__decap_12
X_5785_ _2574_ _2587_ VGND VGND VPWR VPWR _2588_ sky130_fd_sc_hd__and2_1
XFILLER_0_8_589 VGND VGND VPWR VPWR sky130_fd_sc_hd__decap_3
X_7524_ clknet_leaf_94_clk _0430_ net951 VGND VGND VPWR VPWR u_pe_array.act_from_left\[7\]\[5\]
+ sky130_fd_sc_hd__dfrtp_1
X_4736_ u_pe_array.g_pe_row\[2\].g_pe_col\[2\].u_pe.act_val\[1\] _0933_ VGND VGND
+ VPWR VPWR _1763_ sky130_fd_sc_hd__and2b_1
X_7455_ clknet_leaf_34_clk _0361_ net951 VGND VGND VPWR VPWR u_pe_array.g_pe_row\[2\].g_pe_col\[0\].u_pe.psum_out\[5\]
+ sky130_fd_sc_hd__dfrtp_1
X_4667_ _1723_ _1724_ VGND VGND VPWR VPWR _1725_ sky130_fd_sc_hd__xnor2_1
XFILLER_0_114_586 VGND VGND VPWR VPWR sky130_fd_sc_hd__fill_2
X_7386_ clknet_leaf_28_clk _0292_ net942 VGND VGND VPWR VPWR u_pe_array.act_from_right\[8\]\[3\]
+ sky130_fd_sc_hd__dfrtp_1
XFILLER_0_12_540 VPWR VGND VPWR VGND sky130_ef_sc_hd__decap_12
X_3618_ net948 VGND VGND VPWR VPWR _0912_ sky130_fd_sc_hd__inv_2
XFILLER_0_31_348 VGND VGND VPWR VPWR sky130_fd_sc_hd__decap_6
X_6406_ _3064_ _3067_ _3072_ VGND VGND VPWR VPWR _3073_ sky130_fd_sc_hd__a21oi_1
XFILLER_0_101_225 VGND VGND VPWR VPWR sky130_fd_sc_hd__fill_2
X_4598_ u_pe_array.g_pe_row\[2\].g_pe_col\[3\].u_pe.psum_out\[5\] _1662_ VGND VGND
+ VPWR VPWR _1663_ sky130_fd_sc_hd__xnor2_1
X_6337_ _3008_ _2130_ u_pe_array.g_pe_row\[0\].g_pe_col\[2\].u_pe.psum_out\[3\] VGND
+ VGND VPWR VPWR _3009_ sky130_fd_sc_hd__a21oi_1
X_3549_ _0856_ VGND VGND VPWR VPWR _0857_ sky130_fd_sc_hd__buf_12
X_6268_ net596 _2586_ _2971_ _0978_ VGND VGND VPWR VPWR _0599_ sky130_fd_sc_hd__a22o_1
X_5219_ net151 _1882_ _2132_ _2142_ VGND VGND VPWR VPWR _0379_ sky130_fd_sc_hd__a22o_1
X_6199_ _2898_ _2901_ _2909_ VGND VGND VPWR VPWR _2910_ sky130_fd_sc_hd__or3_1
XFILLER_0_79_584 VGND VGND VPWR VPWR sky130_fd_sc_hd__fill_1
XFILLER_0_66_201 VGND VGND VPWR VPWR sky130_fd_sc_hd__fill_1
XFILLER_0_94_565 VPWR VGND VPWR VGND sky130_ef_sc_hd__decap_12
XFILLER_0_81_204 VGND VGND VPWR VPWR sky130_fd_sc_hd__fill_1
XFILLER_0_62_473 VGND VGND VPWR VPWR sky130_fd_sc_hd__decap_3
XFILLER_0_22_326 VGND VGND VPWR VPWR sky130_fd_sc_hd__fill_1
XFILLER_0_50_635 VGND VGND VPWR VPWR sky130_fd_sc_hd__fill_2
XFILLER_0_50_679 VGND VGND VPWR VPWR sky130_fd_sc_hd__decap_8
XFILLER_0_66_29 VPWR VGND VPWR VGND sky130_ef_sc_hd__decap_12
XFILLER_0_89_337 VPWR VGND VPWR VGND sky130_ef_sc_hd__decap_12
XFILLER_0_15_55 VGND VGND VPWR VPWR sky130_fd_sc_hd__fill_1
XFILLER_0_115_317 VPWR VGND VPWR VGND sky130_ef_sc_hd__decap_12
XFILLER_0_110_3 VPWR VGND VPWR VGND sky130_ef_sc_hd__decap_12
X_5570_ _2406_ _2403_ _2402_ VGND VGND VPWR VPWR _2418_ sky130_fd_sc_hd__a21o_1
XFILLER_0_5_559 VGND VGND VPWR VPWR sky130_fd_sc_hd__fill_1
X_4521_ u_pe_array.g_pe_row\[2\].g_pe_col\[3\].u_pe.psum_out\[8\] u_pe_array.g_pe_row\[2\].g_pe_col\[3\].u_pe.move_reg\[8\]
+ _1599_ VGND VGND VPWR VPWR _1609_ sky130_fd_sc_hd__mux2_1
Xhold205 u_pe_array.act_from_right\[0\]\[1\] VGND VGND VPWR VPWR net279 sky130_fd_sc_hd__dlygate4sd3_1
X_7240_ clknet_leaf_15_clk _0146_ net942 VGND VGND VPWR VPWR u_pe_array.g_pe_row\[3\].g_pe_col\[1\].u_pe.psum_out\[8\]
+ sky130_fd_sc_hd__dfrtp_2
X_4452_ _1550_ _1554_ VGND VGND VPWR VPWR _1556_ sky130_fd_sc_hd__nand2_1
XFILLER_0_13_337 VGND VGND VPWR VPWR sky130_fd_sc_hd__fill_2
XFILLER_0_41_668 VGND VGND VPWR VPWR sky130_fd_sc_hd__decap_4
Xhold216 _0271_ VGND VGND VPWR VPWR net290 sky130_fd_sc_hd__dlygate4sd3_1
Xhold227 u_pe_array.act_from_down\[1\]\[3\] VGND VGND VPWR VPWR net301 sky130_fd_sc_hd__buf_1
Xhold238 u_pe_array.g_pe_row\[0\].g_pe_col\[3\].u_pe.move_reg\[7\] VGND VGND VPWR
+ VPWR net312 sky130_fd_sc_hd__dlygate4sd3_1
Xhold249 u_pe_array.g_pe_row\[0\].g_pe_col\[3\].u_pe.psum_out\[2\] VGND VGND VPWR
+ VPWR net323 sky130_fd_sc_hd__dlygate4sd3_1
XFILLER_0_111_567 VGND VGND VPWR VPWR sky130_fd_sc_hd__decap_6
X_4383_ u_pe_array.g_pe_row\[3\].g_pe_col\[0\].u_pe.psum_out\[1\] _1491_ VGND VGND
+ VPWR VPWR _1493_ sky130_fd_sc_hd__nand2_1
XFILLER_0_0_253 VPWR VGND VPWR VGND sky130_ef_sc_hd__decap_12
X_7171_ clknet_leaf_96_clk _0077_ net945 VGND VGND VPWR VPWR u_pe_array.act_from_left\[15\]\[6\]
+ sky130_fd_sc_hd__dfrtp_1
XFILLER_0_40_189 VGND VGND VPWR VPWR sky130_fd_sc_hd__decap_6
X_6122_ net403 _2853_ _2847_ _2855_ VGND VGND VPWR VPWR _0569_ sky130_fd_sc_hd__a22o_1
XTAP_510 VGND VPWR sky130_fd_sc_hd__tapvpwrvgnd_1
XTAP_521 VGND VPWR sky130_fd_sc_hd__tapvpwrvgnd_1
XTAP_532 VGND VPWR sky130_fd_sc_hd__tapvpwrvgnd_1
XTAP_543 VGND VPWR sky130_fd_sc_hd__tapvpwrvgnd_1
XTAP_554 VGND VPWR sky130_fd_sc_hd__tapvpwrvgnd_1
XTAP_565 VGND VPWR sky130_fd_sc_hd__tapvpwrvgnd_1
XTAP_576 VGND VPWR sky130_fd_sc_hd__tapvpwrvgnd_1
X_6053_ _2797_ _2801_ VGND VGND VPWR VPWR _2803_ sky130_fd_sc_hd__nand2_1
X_5004_ u_pe_array.g_pe_row\[2\].g_pe_col\[1\].u_pe.psum_out\[10\] _1105_ VGND VGND
+ VPWR VPWR _1982_ sky130_fd_sc_hd__or2_1
XTAP_598 VGND VPWR sky130_fd_sc_hd__tapvpwrvgnd_1
XTAP_587 VGND VPWR sky130_fd_sc_hd__tapvpwrvgnd_1
XFILLER_0_15_3 VPWR VGND VPWR VGND sky130_ef_sc_hd__decap_12
XTAP_1709 VGND VPWR sky130_fd_sc_hd__tapvpwrvgnd_1
XFILLER_0_76_510 VGND VGND VPWR VPWR sky130_fd_sc_hd__decap_6
X_6955_ u_pe_array.u_fifo1.count\[1\] u_pe_array.u_fifo1.count\[2\] u_pe_array.u_fifo1.count\[0\]
+ u_pe_array.u_fifo1.count\[3\] _2341_ VGND VGND VPWR VPWR _3463_ sky130_fd_sc_hd__o41a_2
XFILLER_0_49_702 VGND VGND VPWR VPWR sky130_fd_sc_hd__decap_3
X_5906_ u_pe_array.u_fifo1.rd_ptr\[2\] _2675_ u_pe_array.u_fifo1.rd_ptr\[3\] VGND
+ VGND VPWR VPWR _2676_ sky130_fd_sc_hd__nor3b_4
XFILLER_0_118_111 VGND VGND VPWR VPWR sky130_fd_sc_hd__fill_1
XFILLER_0_76_565 VGND VGND VPWR VPWR sky130_fd_sc_hd__fill_1
X_6886_ _0911_ net737 _3423_ VGND VGND VPWR VPWR _3424_ sky130_fd_sc_hd__mux2_1
XFILLER_0_48_256 VGND VGND VPWR VPWR sky130_fd_sc_hd__decap_6
XFILLER_0_29_470 VGND VGND VPWR VPWR sky130_fd_sc_hd__decap_3
X_5837_ u_pe_array.g_pe_row\[1\].g_pe_col\[0\].u_pe.psum_out\[1\] _1108_ _1110_ _2631_
+ VGND VGND VPWR VPWR _2632_ sky130_fd_sc_hd__o211a_1
X_5768_ _2548_ _2549_ _2558_ _2560_ VGND VGND VPWR VPWR _2573_ sky130_fd_sc_hd__o22a_1
XFILLER_0_71_270 VGND VGND VPWR VPWR sky130_fd_sc_hd__decap_3
XFILLER_0_16_164 VGND VGND VPWR VPWR sky130_fd_sc_hd__fill_2
XFILLER_0_16_175 VGND VGND VPWR VPWR sky130_fd_sc_hd__fill_2
X_7507_ clknet_leaf_91_clk _0413_ net949 VGND VGND VPWR VPWR u_pe_array.act_from_right\[5\]\[1\]
+ sky130_fd_sc_hd__dfrtp_1
X_4719_ u_pe_array.act_from_right\[10\]\[10\] _1750_ _1483_ net289 VGND VGND VPWR
+ VPWR _0271_ sky130_fd_sc_hd__a22o_1
X_7438_ clknet_leaf_28_clk net80 net951 VGND VGND VPWR VPWR u_pe_array.g_pe_row\[2\].g_pe_col\[0\].u_pe.act_val\[1\]
+ sky130_fd_sc_hd__dfrtp_2
XFILLER_0_71_281 VGND VGND VPWR VPWR sky130_fd_sc_hd__fill_2
X_5699_ net187 _2016_ _2511_ u_pe_array.g_pe_row\[1\].g_pe_col\[1\].u_pe.move_reg\[11\]
+ VGND VGND VPWR VPWR _0490_ sky130_fd_sc_hd__a22o_1
XFILLER_0_16_197 VGND VGND VPWR VPWR sky130_fd_sc_hd__fill_2
XFILLER_0_32_657 VPWR VGND VPWR VGND sky130_ef_sc_hd__decap_12
Xhold750 _3467_ VGND VGND VPWR VPWR net824 sky130_fd_sc_hd__dlygate4sd3_1
Xhold772 u_pe_array.g_pe_row\[3\].g_pe_col\[2\].u_pe.act_val\[3\] VGND VGND VPWR VPWR
+ net846 sky130_fd_sc_hd__dlygate4sd3_1
X_7369_ clknet_leaf_103_clk _0275_ net944 VGND VGND VPWR VPWR u_pe_array.g_pe_row\[2\].g_pe_col\[2\].u_pe.psum_out\[1\]
+ sky130_fd_sc_hd__dfrtp_1
Xhold761 u_pe_array.g_pe_row\[2\].g_pe_col\[3\].u_pe.psum_out\[6\] VGND VGND VPWR
+ VPWR net835 sky130_fd_sc_hd__dlygate4sd3_1
XFILLER_0_102_589 VPWR VGND VPWR VGND sky130_ef_sc_hd__decap_12
Xhold783 u_pe_array.g_pe_row\[3\].g_pe_col\[3\].u_pe.psum_out\[10\] VGND VGND VPWR
+ VPWR net857 sky130_fd_sc_hd__dlygate4sd3_1
Xhold794 net50 VGND VGND VPWR VPWR net868 sky130_fd_sc_hd__dlygate4sd3_1
XFILLER_0_98_156 VGND VGND VPWR VPWR sky130_fd_sc_hd__decap_8
XFILLER_0_109_122 VGND VGND VPWR VPWR sky130_fd_sc_hd__decap_6
XFILLER_0_109_111 VGND VGND VPWR VPWR sky130_fd_sc_hd__fill_1
XFILLER_0_54_226 VPWR VGND VPWR VGND sky130_ef_sc_hd__decap_12
XFILLER_0_54_259 VGND VGND VPWR VPWR sky130_fd_sc_hd__fill_2
XFILLER_0_35_440 VGND VGND VPWR VPWR sky130_fd_sc_hd__decap_8
XFILLER_0_23_613 VGND VGND VPWR VPWR sky130_fd_sc_hd__decap_3
XFILLER_0_112_309 VGND VGND VPWR VPWR sky130_fd_sc_hd__fill_1
XFILLER_0_50_421 VGND VGND VPWR VPWR sky130_fd_sc_hd__decap_6
XFILLER_0_50_443 VPWR VGND VPWR VGND sky130_ef_sc_hd__decap_12
XFILLER_0_93_27 VPWR VGND VPWR VGND sky130_ef_sc_hd__decap_12
XFILLER_0_117_23 VPWR VGND VPWR VGND sky130_ef_sc_hd__decap_12
XFILLER_0_26_54 VGND VGND VPWR VPWR sky130_fd_sc_hd__decap_8
XFILLER_0_89_189 VGND VGND VPWR VPWR sky130_fd_sc_hd__decap_4
X_6740_ u_pe_array.g_pe_row\[0\].g_pe_col\[0\].u_pe.psum_out\[9\] _2488_ VGND VGND
+ VPWR VPWR _3324_ sky130_fd_sc_hd__nand2_1
X_3952_ net22 net564 _0857_ VGND VGND VPWR VPWR _1170_ sky130_fd_sc_hd__mux2_1
X_6671_ _3260_ _3261_ _3253_ _3251_ VGND VGND VPWR VPWR _3262_ sky130_fd_sc_hd__o211ai_1
XFILLER_0_58_587 VGND VGND VPWR VPWR sky130_fd_sc_hd__fill_1
XFILLER_0_45_215 VGND VGND VPWR VPWR sky130_fd_sc_hd__fill_1
X_3883_ _1125_ VGND VGND VPWR VPWR _0060_ sky130_fd_sc_hd__clkbuf_1
XFILLER_0_116_637 VGND VGND VPWR VPWR sky130_fd_sc_hd__decap_6
X_5622_ _2455_ _2462_ _2463_ _2464_ VGND VGND VPWR VPWR _2465_ sky130_fd_sc_hd__a31o_1
XFILLER_0_115_125 VPWR VGND VPWR VGND sky130_ef_sc_hd__decap_12
XFILLER_0_60_229 VGND VGND VPWR VPWR sky130_fd_sc_hd__fill_2
X_5553_ _2395_ _2396_ _2401_ VGND VGND VPWR VPWR _2402_ sky130_fd_sc_hd__nor3_1
XFILLER_0_115_169 VPWR VGND VPWR VGND sky130_ef_sc_hd__decap_12
X_4504_ u_pe_array.g_pe_row\[2\].g_pe_col\[3\].u_pe.psum_out\[0\] u_pe_array.g_pe_row\[2\].g_pe_col\[3\].u_pe.act_val\[0\]
+ _1599_ VGND VGND VPWR VPWR _1600_ sky130_fd_sc_hd__mux2_1
XFILLER_0_41_421 VGND VGND VPWR VPWR sky130_fd_sc_hd__decap_6
XFILLER_0_53_270 VGND VGND VPWR VPWR sky130_fd_sc_hd__fill_1
X_5484_ u_pe_array.u_fifo2.buffer\[4\]\[1\] net68 _2345_ _2347_ VGND VGND VPWR VPWR
+ _2348_ sky130_fd_sc_hd__a211o_1
X_7223_ clknet_leaf_17_clk net643 net943 VGND VGND VPWR VPWR u_pe_array.g_pe_row\[3\].g_pe_col\[1\].u_pe.act_val\[4\]
+ sky130_fd_sc_hd__dfrtp_4
X_4435_ u_pe_array.g_pe_row\[3\].g_pe_col\[0\].u_pe.psum_out\[5\] _1529_ _1539_ VGND
+ VGND VPWR VPWR _1540_ sky130_fd_sc_hd__a21oi_1
X_4366_ net212 _1310_ _1175_ u_pe_array.g_pe_row\[3\].g_pe_col\[0\].u_pe.move_reg\[7\]
+ VGND VGND VPWR VPWR _0186_ sky130_fd_sc_hd__a22o_1
XFILLER_0_6_53 VPWR VGND VPWR VGND sky130_ef_sc_hd__decap_12
XFILLER_0_1_573 VPWR VGND VPWR VGND sky130_ef_sc_hd__decap_12
X_7154_ clknet_leaf_6_clk _0060_ net945 VGND VGND VPWR VPWR u_pe_array.act_from_right\[13\]\[2\]
+ sky130_fd_sc_hd__dfrtp_1
X_6105_ u_pe_array.g_pe_row\[0\].g_pe_col\[3\].u_pe.psum_out\[1\] u_pe_array.g_pe_row\[0\].g_pe_col\[3\].u_pe.act_val\[1\]
+ _2844_ VGND VGND VPWR VPWR _2846_ sky130_fd_sc_hd__mux2_1
XFILLER_0_67_83 VGND VGND VPWR VPWR sky130_fd_sc_hd__fill_2
XTAP_351 VGND VPWR sky130_fd_sc_hd__tapvpwrvgnd_1
XTAP_340 VGND VPWR sky130_fd_sc_hd__tapvpwrvgnd_1
XFILLER_0_6_97 VPWR VGND VPWR VGND sky130_ef_sc_hd__decap_12
X_4297_ u_pe_array.g_pe_row\[3\].g_pe_col\[0\].u_pe.psum_out\[4\] _1108_ _1110_ _1442_
+ VGND VGND VPWR VPWR _1443_ sky130_fd_sc_hd__o211a_2
XTAP_384 VGND VPWR sky130_fd_sc_hd__tapvpwrvgnd_1
XTAP_373 VGND VPWR sky130_fd_sc_hd__tapvpwrvgnd_1
XTAP_362 VGND VPWR sky130_fd_sc_hd__tapvpwrvgnd_1
X_7085_ net591 _3358_ _3536_ VGND VGND VPWR VPWR _3540_ sky130_fd_sc_hd__mux2_1
XTAP_395 VGND VPWR sky130_fd_sc_hd__tapvpwrvgnd_1
X_6036_ _2784_ _2786_ VGND VGND VPWR VPWR _2787_ sky130_fd_sc_hd__xnor2_1
XTAP_1506 VGND VPWR sky130_fd_sc_hd__tapvpwrvgnd_1
XFILLER_0_68_329 VGND VGND VPWR VPWR sky130_fd_sc_hd__decap_3
XPHY_13 VGND VGND VPWR VPWR sky130_fd_sc_hd__decap_3
XTAP_1539 VGND VPWR sky130_fd_sc_hd__tapvpwrvgnd_1
XTAP_1528 VGND VPWR sky130_fd_sc_hd__tapvpwrvgnd_1
XTAP_1517 VGND VPWR sky130_fd_sc_hd__tapvpwrvgnd_1
XPHY_24 VGND VGND VPWR VPWR sky130_fd_sc_hd__decap_3
XPHY_35 VGND VGND VPWR VPWR sky130_fd_sc_hd__decap_3
XPHY_46 VGND VGND VPWR VPWR sky130_fd_sc_hd__decap_3
XFILLER_0_95_159 VGND VGND VPWR VPWR sky130_fd_sc_hd__decap_8
XFILLER_0_76_351 VGND VGND VPWR VPWR sky130_fd_sc_hd__fill_2
X_6938_ _3452_ VGND VGND VPWR VPWR _0788_ sky130_fd_sc_hd__clkbuf_1
XPHY_57 VGND VGND VPWR VPWR sky130_fd_sc_hd__decap_3
XPHY_68 VGND VGND VPWR VPWR sky130_fd_sc_hd__decap_3
XPHY_79 VGND VGND VPWR VPWR sky130_fd_sc_hd__decap_3
X_6869_ net728 _0928_ _3408_ VGND VGND VPWR VPWR _3414_ sky130_fd_sc_hd__mux2_1
XFILLER_0_36_226 VGND VGND VPWR VPWR sky130_fd_sc_hd__decap_4
XFILLER_0_107_615 VGND VGND VPWR VPWR sky130_fd_sc_hd__fill_1
XFILLER_0_9_673 VPWR VGND VPWR VGND sky130_ef_sc_hd__decap_12
XFILLER_0_106_136 VGND VGND VPWR VPWR sky130_fd_sc_hd__decap_4
XFILLER_0_106_169 VPWR VGND VPWR VGND sky130_ef_sc_hd__decap_12
XFILLER_0_17_495 VGND VGND VPWR VPWR sky130_fd_sc_hd__fill_1
XFILLER_0_32_421 VGND VGND VPWR VPWR sky130_fd_sc_hd__fill_2
XFILLER_0_20_638 VGND VGND VPWR VPWR sky130_fd_sc_hd__fill_1
Xhold580 u_pe_array.u_fifo2.buffer\[3\]\[3\] VGND VGND VPWR VPWR net654 sky130_fd_sc_hd__dlygate4sd3_1
Xhold591 u_pe_array.g_pe_row\[2\].g_pe_col\[3\].u_pe.psum_out\[11\] VGND VGND VPWR
+ VPWR net665 sky130_fd_sc_hd__dlygate4sd3_1
XFILLER_0_95_671 VGND VGND VPWR VPWR sky130_fd_sc_hd__fill_1
XFILLER_0_6_109 VPWR VGND VPWR VGND sky130_ef_sc_hd__decap_12
XFILLER_0_103_69 VPWR VGND VPWR VGND sky130_ef_sc_hd__decap_12
XFILLER_0_82_365 VPWR VGND VPWR VGND sky130_ef_sc_hd__decap_12
XFILLER_0_88_27 VGND VGND VPWR VPWR sky130_fd_sc_hd__fill_1
XFILLER_0_112_139 VGND VGND VPWR VPWR sky130_fd_sc_hd__fill_1
XFILLER_0_106_681 VPWR VGND VPWR VGND sky130_ef_sc_hd__decap_12
X_4220_ _1373_ _1376_ _1372_ VGND VGND VPWR VPWR _1378_ sky130_fd_sc_hd__a21oi_1
X_4151_ _1313_ _1314_ _1312_ VGND VGND VPWR VPWR _1315_ sky130_fd_sc_hd__o21ai_1
X_4082_ _1275_ _1276_ VGND VGND VPWR VPWR _1277_ sky130_fd_sc_hd__or2_1
XFILLER_0_37_53 VGND VGND VPWR VPWR sky130_fd_sc_hd__decap_3
X_7910_ clknet_leaf_77_clk _0815_ VGND VGND VPWR VPWR u_pe_array.u_fifo1.buffer\[2\]\[0\]
+ sky130_fd_sc_hd__dfxtp_1
XFILLER_0_78_638 VGND VGND VPWR VPWR sky130_fd_sc_hd__decap_6
X_7841_ clknet_leaf_87_clk _0746_ VGND VGND VPWR VPWR u_pe_array.u_fifo2.buffer\[0\]\[5\]
+ sky130_fd_sc_hd__dfxtp_1
XFILLER_0_53_52 VGND VGND VPWR VPWR sky130_fd_sc_hd__decap_4
X_4984_ _1963_ _1939_ _1952_ _1956_ VGND VGND VPWR VPWR _1964_ sky130_fd_sc_hd__a22o_1
X_7772_ clknet_leaf_50_clk _0678_ net947 VGND VGND VPWR VPWR u_pe_array.g_pe_row\[0\].g_pe_col\[1\].u_pe.psum_out\[9\]
+ sky130_fd_sc_hd__dfrtp_2
X_6723_ _3307_ _3308_ VGND VGND VPWR VPWR _3309_ sky130_fd_sc_hd__and2_1
X_3935_ _1163_ VGND VGND VPWR VPWR _0074_ sky130_fd_sc_hd__clkbuf_1
XFILLER_0_46_513 VPWR VGND VPWR VGND sky130_ef_sc_hd__decap_12
X_6654_ _2488_ VGND VGND VPWR VPWR _3246_ sky130_fd_sc_hd__clkinv_4
XFILLER_0_61_505 VPWR VGND VPWR VGND sky130_ef_sc_hd__decap_12
X_3866_ u_pe_array.g_pe_row\[3\].g_pe_col\[2\].u_pe.act_val\[0\] VGND VGND VPWR VPWR
+ _1111_ sky130_fd_sc_hd__inv_2
X_5605_ _2233_ _2448_ _2449_ _2173_ net807 VGND VGND VPWR VPWR _0458_ sky130_fd_sc_hd__a32o_1
X_6585_ u_pe_array.g_pe_row\[0\].g_pe_col\[1\].u_pe.psum_out\[7\] u_pe_array.g_pe_row\[0\].g_pe_col\[1\].u_pe.psum_out\[8\]
+ _2268_ VGND VGND VPWR VPWR _3209_ sky130_fd_sc_hd__o21a_1
X_3797_ _1030_ _1040_ VGND VGND VPWR VPWR _1051_ sky130_fd_sc_hd__and2b_1
XFILLER_0_103_117 VGND VGND VPWR VPWR sky130_fd_sc_hd__fill_1
X_5536_ _2233_ _2385_ _2386_ _2173_ net735 VGND VGND VPWR VPWR _0452_ sky130_fd_sc_hd__a32o_1
X_5467_ u_pe_array.u_fifo2.rd_ptr\[0\] _2328_ u_pe_array.u_fifo2.rd_ptr\[1\] VGND
+ VGND VPWR VPWR _2332_ sky130_fd_sc_hd__and3b_2
XFILLER_0_111_150 VPWR VGND VPWR VGND sky130_ef_sc_hd__decap_12
X_7206_ clknet_leaf_22_clk _0112_ net943 VGND VGND VPWR VPWR u_pe_array.act_from_down\[9\]\[0\]
+ sky130_fd_sc_hd__dfrtp_1
X_4418_ _1516_ _1524_ VGND VGND VPWR VPWR _1525_ sky130_fd_sc_hd__nor2_1
X_5398_ _2285_ VGND VGND VPWR VPWR _0415_ sky130_fd_sc_hd__clkbuf_1
X_4349_ net153 _1166_ _1459_ _1476_ VGND VGND VPWR VPWR _0175_ sky130_fd_sc_hd__a22o_1
X_7137_ clknet_leaf_19_clk _0043_ net69 VGND VGND VPWR VPWR u_pe_array.g_pe_row\[3\].g_pe_col\[3\].u_pe.psum_out\[0\]
+ sky130_fd_sc_hd__dfrtp_1
XFILLER_0_10_693 VGND VGND VPWR VPWR sky130_fd_sc_hd__decap_6
X_7068_ net579 _3354_ _3529_ VGND VGND VPWR VPWR _3531_ sky130_fd_sc_hd__mux2_1
X_6019_ _2762_ _2770_ _1003_ VGND VGND VPWR VPWR _2772_ sky130_fd_sc_hd__a21o_1
XTAP_1314 VGND VPWR sky130_fd_sc_hd__tapvpwrvgnd_1
XTAP_1303 VGND VPWR sky130_fd_sc_hd__tapvpwrvgnd_1
XTAP_1347 VGND VPWR sky130_fd_sc_hd__tapvpwrvgnd_1
XTAP_1336 VGND VPWR sky130_fd_sc_hd__tapvpwrvgnd_1
XTAP_1325 VGND VPWR sky130_fd_sc_hd__tapvpwrvgnd_1
XTAP_1369 VGND VPWR sky130_fd_sc_hd__tapvpwrvgnd_1
XTAP_1358 VGND VPWR sky130_fd_sc_hd__tapvpwrvgnd_1
XFILLER_0_92_652 VPWR VGND VPWR VGND sky130_ef_sc_hd__decap_12
XFILLER_0_9_481 VPWR VGND VPWR VGND sky130_ef_sc_hd__decap_12
XFILLER_0_17_281 VPWR VGND VPWR VGND sky130_ef_sc_hd__decap_12
XFILLER_0_24_229 VPWR VGND VPWR VGND sky130_ef_sc_hd__decap_12
XFILLER_0_107_489 VGND VGND VPWR VPWR sky130_fd_sc_hd__decap_6
XFILLER_0_32_251 VGND VGND VPWR VPWR sky130_fd_sc_hd__fill_1
XFILLER_0_103_651 VPWR VGND VPWR VGND sky130_ef_sc_hd__decap_12
XFILLER_0_103_673 VPWR VGND VPWR VGND sky130_ef_sc_hd__decap_12
XFILLER_0_20_435 VGND VGND VPWR VPWR sky130_fd_sc_hd__decap_3
XFILLER_0_102_183 VGND VGND VPWR VPWR sky130_fd_sc_hd__decap_3
XFILLER_0_74_29 VGND VGND VPWR VPWR sky130_fd_sc_hd__decap_6
XFILLER_0_87_413 VGND VGND VPWR VPWR sky130_fd_sc_hd__decap_8
XFILLER_0_87_457 VGND VGND VPWR VPWR sky130_fd_sc_hd__fill_1
XFILLER_0_68_682 VGND VGND VPWR VPWR sky130_fd_sc_hd__decap_4
XFILLER_0_23_55 VGND VGND VPWR VPWR sky130_fd_sc_hd__fill_1
XFILLER_0_95_490 VGND VGND VPWR VPWR sky130_fd_sc_hd__fill_1
X_3720_ u_pe_array.g_pe_row\[3\].g_pe_col\[3\].u_pe.psum_out\[0\] u_pe_array.g_pe_row\[3\].g_pe_col\[3\].u_pe.act_val\[0\]
+ u_pe_array.g_pe_row\[3\].g_pe_col\[3\].u_pe.w_out\[0\] VGND VGND VPWR VPWR _0980_
+ sky130_fd_sc_hd__and3_1
XFILLER_0_55_343 VGND VGND VPWR VPWR sky130_fd_sc_hd__fill_1
XFILLER_0_99_15 VPWR VGND VPWR VGND sky130_ef_sc_hd__decap_12
Xclkbuf_leaf_40_clk clknet_3_6__leaf_clk VGND VGND VPWR VPWR clknet_leaf_40_clk sky130_fd_sc_hd__clkbuf_16
XFILLER_0_82_195 VGND VGND VPWR VPWR sky130_fd_sc_hd__fill_1
X_3651_ u_pe_array.g_pe_row\[0\].g_pe_col\[0\].u_pe.psum_shift_en_d _0936_ VGND VGND
+ VPWR VPWR _0937_ sky130_fd_sc_hd__nor2_1
X_3582_ _0884_ _0885_ VGND VGND VPWR VPWR _0887_ sky130_fd_sc_hd__and2_1
X_6370_ _3038_ _3039_ VGND VGND VPWR VPWR _3040_ sky130_fd_sc_hd__nor2_1
X_5321_ _2211_ _2208_ VGND VGND VPWR VPWR _2221_ sky130_fd_sc_hd__nor2_1
XFILLER_0_51_582 VPWR VGND VPWR VGND sky130_ef_sc_hd__decap_12
XFILLER_0_11_446 VGND VGND VPWR VPWR sky130_fd_sc_hd__fill_2
XFILLER_0_2_189 VGND VGND VPWR VPWR sky130_fd_sc_hd__decap_6
X_5252_ _2159_ VGND VGND VPWR VPWR _0395_ sky130_fd_sc_hd__clkbuf_1
X_5183_ u_pe_array.g_pe_row\[2\].g_pe_col\[0\].u_pe.psum_out\[11\] _1286_ VGND VGND
+ VPWR VPWR _2119_ sky130_fd_sc_hd__and2b_1
X_4203_ _1346_ _1357_ _1361_ VGND VGND VPWR VPWR _1363_ sky130_fd_sc_hd__nor3_1
XFILLER_0_48_85 VGND VGND VPWR VPWR sky130_fd_sc_hd__fill_1
X_4134_ net641 u_pe_array.act_from_left\[13\]\[4\] _0963_ VGND VGND VPWR VPWR _1308_
+ sky130_fd_sc_hd__mux2_1
XFILLER_0_64_73 VGND VGND VPWR VPWR sky130_fd_sc_hd__fill_1
X_4065_ _1252_ _1259_ _1260_ _1261_ VGND VGND VPWR VPWR _1262_ sky130_fd_sc_hd__a31o_1
XFILLER_0_78_468 VGND VGND VPWR VPWR sky130_fd_sc_hd__decap_8
X_7824_ clknet_leaf_86_clk _0729_ net948 VGND VGND VPWR VPWR u_pe_array.u_fifo2.wr_ptr\[0\]
+ sky130_fd_sc_hd__dfrtp_4
XFILLER_0_59_671 VGND VGND VPWR VPWR sky130_fd_sc_hd__fill_1
X_7755_ clknet_leaf_47_clk net284 net73 VGND VGND VPWR VPWR u_pe_array.g_pe_row\[0\].g_pe_col\[1\].u_pe.act_val\[5\]
+ sky130_fd_sc_hd__dfrtp_2
X_4967_ _1945_ _1946_ _1948_ VGND VGND VPWR VPWR _1949_ sky130_fd_sc_hd__a21oi_1
XFILLER_0_93_449 VGND VGND VPWR VPWR sky130_fd_sc_hd__decap_6
XFILLER_0_46_321 VGND VGND VPWR VPWR sky130_fd_sc_hd__fill_2
Xclkbuf_leaf_31_clk clknet_3_3__leaf_clk VGND VGND VPWR VPWR clknet_leaf_31_clk sky130_fd_sc_hd__clkbuf_16
X_6706_ _3291_ _3293_ VGND VGND VPWR VPWR _3294_ sky130_fd_sc_hd__nand2_1
X_4898_ u_pe_array.g_pe_row\[2\].g_pe_col\[1\].u_pe.psum_out\[0\] u_pe_array.g_pe_row\[2\].g_pe_col\[1\].u_pe.act_val\[0\]
+ u_pe_array.g_pe_row\[2\].g_pe_col\[1\].u_pe.w_out\[0\] VGND VGND VPWR VPWR _1886_
+ sky130_fd_sc_hd__and3_1
X_7686_ clknet_leaf_58_clk _0592_ net74 VGND VGND VPWR VPWR u_pe_array.g_pe_row\[0\].g_pe_col\[3\].u_pe.psum_out\[5\]
+ sky130_fd_sc_hd__dfrtp_2
XFILLER_0_73_140 VPWR VGND VPWR VGND sky130_ef_sc_hd__decap_12
X_3918_ u_pe_array.g_pe_row\[3\].g_pe_col\[2\].u_pe.move_reg\[11\] _1118_ VGND VGND
+ VPWR VPWR _1152_ sky130_fd_sc_hd__or2_1
XFILLER_0_46_365 VGND VGND VPWR VPWR sky130_fd_sc_hd__decap_8
XFILLER_0_116_253 VPWR VGND VPWR VGND sky130_ef_sc_hd__decap_12
X_6637_ u_pe_array.g_pe_row\[0\].g_pe_col\[0\].u_pe.act_val\[0\] _2343_ _2320_ net234
+ VGND VGND VPWR VPWR _0697_ sky130_fd_sc_hd__a22o_1
X_3849_ _1089_ _1091_ _1097_ VGND VGND VPWR VPWR _1098_ sky130_fd_sc_hd__o21ai_1
X_6568_ _3193_ _3169_ _3182_ _3186_ VGND VGND VPWR VPWR _3194_ sky130_fd_sc_hd__a22o_1
X_5519_ _2320_ _2377_ _2378_ _2343_ net606 VGND VGND VPWR VPWR _0443_ sky130_fd_sc_hd__a32o_1
X_6499_ u_pe_array.g_pe_row\[0\].g_pe_col\[1\].u_pe.psum_out\[2\] _3130_ VGND VGND
+ VPWR VPWR _3131_ sky130_fd_sc_hd__xnor2_1
XFILLER_0_100_610 VGND VGND VPWR VPWR sky130_fd_sc_hd__fill_1
XFILLER_0_100_643 VGND VGND VPWR VPWR sky130_fd_sc_hd__fill_1
XFILLER_0_100_665 VPWR VGND VPWR VGND sky130_ef_sc_hd__decap_12
Xclkbuf_leaf_98_clk clknet_3_1__leaf_clk VGND VGND VPWR VPWR clknet_leaf_98_clk sky130_fd_sc_hd__clkbuf_16
XFILLER_0_69_402 VGND VGND VPWR VPWR sky130_fd_sc_hd__fill_1
XTAP_1122 VGND VPWR sky130_fd_sc_hd__tapvpwrvgnd_1
XTAP_1111 VGND VPWR sky130_fd_sc_hd__tapvpwrvgnd_1
XTAP_1100 VGND VPWR sky130_fd_sc_hd__tapvpwrvgnd_1
XTAP_1155 VGND VPWR sky130_fd_sc_hd__tapvpwrvgnd_1
XTAP_1144 VGND VPWR sky130_fd_sc_hd__tapvpwrvgnd_1
XTAP_1133 VGND VPWR sky130_fd_sc_hd__tapvpwrvgnd_1
XFILLER_0_77_490 VGND VGND VPWR VPWR sky130_fd_sc_hd__decap_6
XTAP_1199 VGND VPWR sky130_fd_sc_hd__tapvpwrvgnd_1
XTAP_1188 VGND VPWR sky130_fd_sc_hd__tapvpwrvgnd_1
XTAP_1177 VGND VPWR sky130_fd_sc_hd__tapvpwrvgnd_1
XTAP_1166 VGND VPWR sky130_fd_sc_hd__tapvpwrvgnd_1
XFILLER_0_37_332 VGND VGND VPWR VPWR sky130_fd_sc_hd__decap_4
Xclkbuf_leaf_22_clk clknet_3_2__leaf_clk VGND VGND VPWR VPWR clknet_leaf_22_clk sky130_fd_sc_hd__clkbuf_16
XFILLER_0_64_195 VGND VGND VPWR VPWR sky130_fd_sc_hd__fill_1
XFILLER_0_100_15 VPWR VGND VPWR VGND sky130_ef_sc_hd__decap_12
XFILLER_0_110_418 VGND VGND VPWR VPWR sky130_fd_sc_hd__fill_2
XFILLER_0_33_593 VGND VGND VPWR VPWR sky130_fd_sc_hd__decap_3
XTAP_917 VGND VPWR sky130_fd_sc_hd__tapvpwrvgnd_1
XTAP_906 VGND VPWR sky130_fd_sc_hd__tapvpwrvgnd_1
XFILLER_0_85_28 VGND VGND VPWR VPWR sky130_fd_sc_hd__fill_2
XTAP_939 VGND VPWR sky130_fd_sc_hd__tapvpwrvgnd_1
XTAP_928 VGND VPWR sky130_fd_sc_hd__tapvpwrvgnd_1
XFILLER_0_109_57 VPWR VGND VPWR VGND sky130_ef_sc_hd__decap_12
Xclkbuf_leaf_89_clk clknet_3_4__leaf_clk VGND VGND VPWR VPWR clknet_leaf_89_clk sky130_fd_sc_hd__clkbuf_16
XFILLER_0_87_221 VGND VGND VPWR VPWR sky130_fd_sc_hd__decap_3
X_5870_ u_pe_array.g_pe_row\[1\].g_pe_col\[0\].u_pe.move_reg\[9\] net62 VGND VGND
+ VPWR VPWR _2657_ sky130_fd_sc_hd__or2_1
X_4821_ u_pe_array.g_pe_row\[2\].g_pe_col\[2\].u_pe.psum_out\[8\] u_pe_array.g_pe_row\[2\].g_pe_col\[2\].u_pe.psum_out\[9\]
+ _0933_ VGND VGND VPWR VPWR _1841_ sky130_fd_sc_hd__and3_1
XFILLER_0_34_76 VGND VGND VPWR VPWR sky130_fd_sc_hd__fill_1
XFILLER_0_118_518 VPWR VGND VPWR VGND sky130_ef_sc_hd__decap_12
XFILLER_0_75_449 VGND VGND VPWR VPWR sky130_fd_sc_hd__decap_8
Xclkbuf_leaf_13_clk clknet_3_3__leaf_clk VGND VGND VPWR VPWR clknet_leaf_13_clk sky130_fd_sc_hd__clkbuf_16
X_7540_ clknet_leaf_68_clk net115 net72 VGND VGND VPWR VPWR u_pe_array.g_pe_row\[1\].g_pe_col\[2\].u_pe.move_reg\[8\]
+ sky130_fd_sc_hd__dfrtp_1
X_4752_ u_pe_array.g_pe_row\[2\].g_pe_col\[2\].u_pe.psum_out\[2\] _1765_ _1777_ VGND
+ VGND VPWR VPWR _1778_ sky130_fd_sc_hd__a21oi_1
XFILLER_0_7_237 VGND VGND VPWR VPWR sky130_fd_sc_hd__decap_4
XFILLER_0_28_365 VGND VGND VPWR VPWR sky130_fd_sc_hd__decap_3
X_3703_ net787 _0939_ VGND VGND VPWR VPWR _0970_ sky130_fd_sc_hd__and2_1
X_7471_ clknet_leaf_64_clk net520 net946 VGND VGND VPWR VPWR u_pe_array.act_from_down\[3\]\[6\]
+ sky130_fd_sc_hd__dfrtp_1
XFILLER_0_55_173 VGND VGND VPWR VPWR sky130_fd_sc_hd__fill_1
X_4683_ u_pe_array.g_pe_row\[2\].g_pe_col\[2\].u_pe.psum_out\[1\] u_pe_array.g_pe_row\[2\].g_pe_col\[2\].u_pe.act_val\[1\]
+ _1599_ VGND VGND VPWR VPWR _1737_ sky130_fd_sc_hd__mux2_1
XFILLER_0_16_549 VGND VGND VPWR VPWR sky130_fd_sc_hd__fill_1
XFILLER_0_43_335 VGND VGND VPWR VPWR sky130_fd_sc_hd__fill_1
XFILLER_0_71_655 VPWR VGND VPWR VGND sky130_ef_sc_hd__decap_12
X_3634_ _0924_ net632 _0918_ VGND VGND VPWR VPWR _0925_ sky130_fd_sc_hd__mux2_1
XFILLER_0_50_97 VPWR VGND VPWR VGND sky130_ef_sc_hd__decap_12
X_6422_ _3082_ _3086_ VGND VGND VPWR VPWR _3087_ sky130_fd_sc_hd__nand2_1
XFILLER_0_101_418 VGND VGND VPWR VPWR sky130_fd_sc_hd__decap_4
X_3565_ _0870_ _0871_ _0872_ VGND VGND VPWR VPWR _0873_ sky130_fd_sc_hd__or3b_1
X_6353_ _3022_ _3023_ VGND VGND VPWR VPWR _3024_ sky130_fd_sc_hd__nor2_1
X_5304_ u_pe_array.g_pe_row\[1\].g_pe_col\[3\].u_pe.psum_out\[5\] u_pe_array.g_pe_row\[1\].g_pe_col\[3\].u_pe.act_val\[5\]
+ _1423_ VGND VGND VPWR VPWR _2205_ sky130_fd_sc_hd__and3_1
X_6284_ net414 _2006_ _2009_ _2979_ VGND VGND VPWR VPWR _0607_ sky130_fd_sc_hd__a22o_1
X_5235_ net4 u_pe_array.act_from_left\[7\]\[3\] _0963_ VGND VGND VPWR VPWR _2151_
+ sky130_fd_sc_hd__mux2_1
XFILLER_0_45_3 VGND VGND VPWR VPWR sky130_fd_sc_hd__decap_4
X_5166_ u_pe_array.g_pe_row\[2\].g_pe_col\[0\].u_pe.psum_out\[9\] _1286_ VGND VGND
+ VPWR VPWR _2104_ sky130_fd_sc_hd__nand2_1
X_5097_ _2036_ _2040_ VGND VGND VPWR VPWR _2041_ sky130_fd_sc_hd__xnor2_1
X_4117_ net437 _1167_ _1169_ _1298_ VGND VGND VPWR VPWR _0121_ sky130_fd_sc_hd__a22o_1
X_4048_ _1033_ _1245_ _1246_ _0986_ u_pe_array.g_pe_row\[3\].g_pe_col\[2\].u_pe.psum_out\[7\]
+ VGND VGND VPWR VPWR _0104_ sky130_fd_sc_hd__a32o_1
XFILLER_0_78_232 VPWR VGND VPWR VGND sky130_ef_sc_hd__decap_12
XPHY_216 VGND VGND VPWR VPWR sky130_fd_sc_hd__decap_3
XPHY_205 VGND VGND VPWR VPWR sky130_fd_sc_hd__decap_3
XFILLER_0_78_276 VGND VGND VPWR VPWR sky130_fd_sc_hd__decap_3
XPHY_227 VGND VGND VPWR VPWR sky130_fd_sc_hd__decap_3
XFILLER_0_109_529 VGND VGND VPWR VPWR sky130_fd_sc_hd__decap_8
X_7807_ clknet_leaf_55_clk _0712_ net74 VGND VGND VPWR VPWR u_pe_array.g_pe_row\[0\].g_pe_col\[0\].u_pe.psum_out\[2\]
+ sky130_fd_sc_hd__dfrtp_1
X_5999_ _2634_ u_pe_array.g_pe_row\[1\].g_pe_col\[0\].u_pe.act_val\[3\] u_pe_array.g_pe_row\[1\].g_pe_col\[0\].u_pe.w_out\[0\]
+ _1865_ VGND VGND VPWR VPWR _2753_ sky130_fd_sc_hd__nand4_1
X_7738_ clknet_leaf_52_clk _0644_ net74 VGND VGND VPWR VPWR u_pe_array.act_from_right\[0\]\[1\]
+ sky130_fd_sc_hd__dfrtp_1
XFILLER_0_47_663 VGND VGND VPWR VPWR sky130_fd_sc_hd__fill_1
XFILLER_0_62_611 VGND VGND VPWR VPWR sky130_fd_sc_hd__fill_2
X_7669_ clknet_leaf_63_clk net172 net74 VGND VGND VPWR VPWR u_pe_array.g_pe_row\[0\].g_pe_col\[3\].u_pe.act_val\[1\]
+ sky130_fd_sc_hd__dfrtp_1
XFILLER_0_34_357 VGND VGND VPWR VPWR sky130_fd_sc_hd__decap_6
XFILLER_0_104_223 VGND VGND VPWR VPWR sky130_fd_sc_hd__fill_2
XFILLER_0_104_289 VGND VGND VPWR VPWR sky130_fd_sc_hd__fill_2
Xhold9 u_pe_array.act_from_right\[5\]\[6\] VGND VGND VPWR VPWR net83 sky130_fd_sc_hd__dlygate4sd3_1
XFILLER_0_72_419 VGND VGND VPWR VPWR sky130_fd_sc_hd__fill_1
XFILLER_0_53_666 VGND VGND VPWR VPWR sky130_fd_sc_hd__decap_6
XFILLER_0_37_195 VGND VGND VPWR VPWR sky130_fd_sc_hd__fill_2
XFILLER_0_111_69 VPWR VGND VPWR VGND sky130_ef_sc_hd__decap_12
Xhold409 u_pe_array.g_pe_row\[1\].g_pe_col\[3\].u_pe.move_reg\[8\] VGND VGND VPWR
+ VPWR net483 sky130_fd_sc_hd__dlygate4sd3_1
XFILLER_0_80_463 VGND VGND VPWR VPWR sky130_fd_sc_hd__decap_6
XFILLER_0_52_154 VGND VGND VPWR VPWR sky130_fd_sc_hd__fill_1
XFILLER_0_52_187 VGND VGND VPWR VPWR sky130_fd_sc_hd__fill_2
XFILLER_0_0_413 VGND VGND VPWR VPWR sky130_fd_sc_hd__decap_6
XFILLER_0_33_390 VGND VGND VPWR VPWR sky130_fd_sc_hd__fill_2
XFILLER_0_96_27 VGND VGND VPWR VPWR sky130_fd_sc_hd__fill_1
XFILLER_0_0_457 VGND VGND VPWR VPWR sky130_fd_sc_hd__fill_1
XTAP_703 VGND VPWR sky130_fd_sc_hd__tapvpwrvgnd_1
XTAP_714 VGND VPWR sky130_fd_sc_hd__tapvpwrvgnd_1
XTAP_725 VGND VPWR sky130_fd_sc_hd__tapvpwrvgnd_1
X_5020_ u_pe_array.g_pe_row\[2\].g_pe_col\[1\].u_pe.psum_out\[12\] _1988_ VGND VGND
+ VPWR VPWR _1996_ sky130_fd_sc_hd__xnor2_1
XFILLER_0_29_76 VGND VGND VPWR VPWR sky130_fd_sc_hd__fill_2
XTAP_736 VGND VPWR sky130_fd_sc_hd__tapvpwrvgnd_1
XTAP_758 VGND VPWR sky130_fd_sc_hd__tapvpwrvgnd_1
XTAP_747 VGND VPWR sky130_fd_sc_hd__tapvpwrvgnd_1
Xclkbuf_leaf_2_clk clknet_3_0__leaf_clk VGND VGND VPWR VPWR clknet_leaf_2_clk sky130_fd_sc_hd__clkbuf_16
XTAP_769 VGND VPWR sky130_fd_sc_hd__tapvpwrvgnd_1
X_6971_ _3472_ _3474_ VGND VGND VPWR VPWR _3475_ sky130_fd_sc_hd__or2_1
XFILLER_0_45_86 VGND VGND VPWR VPWR sky130_fd_sc_hd__fill_1
X_5922_ u_pe_array.u_fifo1.buffer\[4\]\[0\] _2680_ _2684_ _2691_ VGND VGND VPWR VPWR
+ _2692_ sky130_fd_sc_hd__a211o_1
XFILLER_0_0_77 VGND VGND VPWR VPWR sky130_fd_sc_hd__decap_3
X_5853_ u_pe_array.g_pe_row\[1\].g_pe_col\[0\].u_pe.act_val\[5\] VGND VGND VPWR VPWR
+ _2644_ sky130_fd_sc_hd__inv_2
XFILLER_0_118_337 VGND VGND VPWR VPWR sky130_fd_sc_hd__decap_8
X_5784_ _2570_ _2583_ VGND VGND VPWR VPWR _2587_ sky130_fd_sc_hd__and2b_1
X_4804_ _1487_ _1824_ _1825_ _1803_ net443 VGND VGND VPWR VPWR _0281_ sky130_fd_sc_hd__a32o_1
X_4735_ u_pe_array.g_pe_row\[2\].g_pe_col\[2\].u_pe.act_val\[0\] _1754_ _0933_ VGND
+ VGND VPWR VPWR _1762_ sky130_fd_sc_hd__a21bo_1
XFILLER_0_28_162 VPWR VGND VPWR VGND sky130_ef_sc_hd__decap_12
XFILLER_0_29_685 VPWR VGND VPWR VGND sky130_ef_sc_hd__decap_12
X_7523_ clknet_leaf_95_clk _0429_ net951 VGND VGND VPWR VPWR u_pe_array.act_from_left\[7\]\[4\]
+ sky130_fd_sc_hd__dfrtp_1
XFILLER_0_114_510 VPWR VGND VPWR VGND sky130_ef_sc_hd__decap_12
XFILLER_0_71_441 VGND VGND VPWR VPWR sky130_fd_sc_hd__decap_6
X_7454_ clknet_leaf_33_clk _0360_ net71 VGND VGND VPWR VPWR u_pe_array.g_pe_row\[2\].g_pe_col\[0\].u_pe.psum_out\[4\]
+ sky130_fd_sc_hd__dfrtp_1
X_4666_ u_pe_array.g_pe_row\[2\].g_pe_col\[3\].u_pe.psum_out\[12\] _1717_ VGND VGND
+ VPWR VPWR _1724_ sky130_fd_sc_hd__xnor2_1
XFILLER_0_16_379 VGND VGND VPWR VPWR sky130_fd_sc_hd__fill_1
XFILLER_0_44_699 VGND VGND VPWR VPWR sky130_fd_sc_hd__fill_1
X_7385_ clknet_leaf_28_clk _0291_ net942 VGND VGND VPWR VPWR u_pe_array.act_from_right\[8\]\[2\]
+ sky130_fd_sc_hd__dfrtp_1
X_3617_ u_pe_array.act_from_up\[14\]\[0\] _0869_ _0854_ VGND VGND VPWR VPWR _0911_
+ sky130_fd_sc_hd__and3_2
X_4597_ u_pe_array.g_pe_row\[2\].g_pe_col\[3\].u_pe.act_val\[4\] _1427_ VGND VGND
+ VPWR VPWR _1662_ sky130_fd_sc_hd__and2b_1
X_6405_ _3056_ _3070_ _3071_ VGND VGND VPWR VPWR _3072_ sky130_fd_sc_hd__a21o_1
XFILLER_0_12_552 VPWR VGND VPWR VGND sky130_ef_sc_hd__decap_12
X_3548_ _0853_ _0855_ VGND VGND VPWR VPWR _0856_ sky130_fd_sc_hd__nand2_1
X_6336_ u_pe_array.g_pe_row\[0\].g_pe_col\[2\].u_pe.act_val\[2\] VGND VGND VPWR VPWR
+ _3008_ sky130_fd_sc_hd__inv_2
XFILLER_0_86_82 VGND VGND VPWR VPWR sky130_fd_sc_hd__fill_2
X_6267_ _2969_ _2970_ VGND VGND VPWR VPWR _2971_ sky130_fd_sc_hd__xnor2_1
X_5218_ u_pe_array.g_pe_row\[1\].g_pe_col\[3\].u_pe.psum_out\[8\] net483 _2133_ VGND
+ VGND VPWR VPWR _2142_ sky130_fd_sc_hd__mux2_1
X_6198_ _2906_ _2908_ VGND VGND VPWR VPWR _2909_ sky130_fd_sc_hd__xor2_1
X_5149_ _2084_ _2088_ _2073_ VGND VGND VPWR VPWR _2089_ sky130_fd_sc_hd__mux2_1
XFILLER_0_79_574 VGND VGND VPWR VPWR sky130_fd_sc_hd__fill_1
XFILLER_0_39_449 VPWR VGND VPWR VGND sky130_ef_sc_hd__decap_12
XFILLER_0_109_337 VGND VGND VPWR VPWR sky130_fd_sc_hd__decap_4
XFILLER_0_94_577 VGND VGND VPWR VPWR sky130_fd_sc_hd__decap_4
XFILLER_0_117_381 VGND VGND VPWR VPWR sky130_fd_sc_hd__fill_2
XFILLER_0_100_281 VGND VGND VPWR VPWR sky130_fd_sc_hd__decap_8
XFILLER_0_89_305 VGND VGND VPWR VPWR sky130_fd_sc_hd__fill_1
XFILLER_0_89_316 VGND VGND VPWR VPWR sky130_fd_sc_hd__fill_2
XFILLER_0_89_349 VPWR VGND VPWR VGND sky130_ef_sc_hd__decap_12
XFILLER_0_97_393 VPWR VGND VPWR VGND sky130_ef_sc_hd__decap_12
XFILLER_0_31_22 VGND VGND VPWR VPWR sky130_fd_sc_hd__decap_4
XFILLER_0_115_329 VGND VGND VPWR VPWR sky130_fd_sc_hd__decap_6
XFILLER_0_65_290 VGND VGND VPWR VPWR sky130_fd_sc_hd__decap_4
XFILLER_0_31_55 VGND VGND VPWR VPWR sky130_fd_sc_hd__fill_1
X_4520_ net346 _1605_ _1305_ _1608_ VGND VGND VPWR VPWR _0214_ sky130_fd_sc_hd__a22o_1
XFILLER_0_41_614 VGND VGND VPWR VPWR sky130_fd_sc_hd__fill_2
XFILLER_0_53_474 VGND VGND VPWR VPWR sky130_fd_sc_hd__decap_8
XFILLER_0_103_3 VPWR VGND VPWR VGND sky130_ef_sc_hd__decap_12
Xhold206 _0698_ VGND VGND VPWR VPWR net280 sky130_fd_sc_hd__dlygate4sd3_1
Xhold217 u_pe_array.g_pe_row\[0\].g_pe_col\[2\].u_pe.move_reg\[7\] VGND VGND VPWR
+ VPWR net291 sky130_fd_sc_hd__dlygate4sd3_1
X_4451_ _1550_ _1554_ VGND VGND VPWR VPWR _1555_ sky130_fd_sc_hd__or2_1
Xhold228 _0659_ VGND VGND VPWR VPWR net302 sky130_fd_sc_hd__dlygate4sd3_1
Xhold239 _0581_ VGND VGND VPWR VPWR net313 sky130_fd_sc_hd__dlygate4sd3_1
X_7170_ clknet_leaf_19_clk _0076_ net70 VGND VGND VPWR VPWR u_pe_array.act_from_left\[15\]\[5\]
+ sky130_fd_sc_hd__dfrtp_1
XFILLER_0_40_168 VGND VGND VPWR VPWR sky130_fd_sc_hd__fill_2
X_6121_ u_pe_array.g_pe_row\[0\].g_pe_col\[3\].u_pe.psum_out\[8\] u_pe_array.g_pe_row\[0\].g_pe_col\[3\].u_pe.move_reg\[8\]
+ _2844_ VGND VGND VPWR VPWR _2855_ sky130_fd_sc_hd__mux2_1
X_4382_ u_pe_array.g_pe_row\[3\].g_pe_col\[0\].u_pe.psum_out\[1\] _1491_ VGND VGND
+ VPWR VPWR _1492_ sky130_fd_sc_hd__or2_1
XTAP_500 VGND VPWR sky130_fd_sc_hd__tapvpwrvgnd_1
XFILLER_0_0_265 VGND VGND VPWR VPWR sky130_fd_sc_hd__decap_4
XTAP_511 VGND VPWR sky130_fd_sc_hd__tapvpwrvgnd_1
XFILLER_0_21_393 VGND VGND VPWR VPWR sky130_fd_sc_hd__decap_6
XTAP_522 VGND VPWR sky130_fd_sc_hd__tapvpwrvgnd_1
XTAP_533 VGND VPWR sky130_fd_sc_hd__tapvpwrvgnd_1
XTAP_544 VGND VPWR sky130_fd_sc_hd__tapvpwrvgnd_1
XTAP_555 VGND VPWR sky130_fd_sc_hd__tapvpwrvgnd_1
XTAP_566 VGND VPWR sky130_fd_sc_hd__tapvpwrvgnd_1
X_6052_ _2797_ _2801_ VGND VGND VPWR VPWR _2802_ sky130_fd_sc_hd__or2_1
X_5003_ u_pe_array.g_pe_row\[2\].g_pe_col\[1\].u_pe.psum_out\[10\] _1105_ VGND VGND
+ VPWR VPWR _1981_ sky130_fd_sc_hd__nand2_1
XTAP_588 VGND VPWR sky130_fd_sc_hd__tapvpwrvgnd_1
XTAP_577 VGND VPWR sky130_fd_sc_hd__tapvpwrvgnd_1
XTAP_599 VGND VPWR sky130_fd_sc_hd__tapvpwrvgnd_1
XFILLER_0_56_85 VGND VGND VPWR VPWR sky130_fd_sc_hd__decap_3
XFILLER_0_72_40 VGND VGND VPWR VPWR sky130_fd_sc_hd__decap_4
X_6954_ net481 _3460_ _3462_ VGND VGND VPWR VPWR _0794_ sky130_fd_sc_hd__a21oi_1
XFILLER_0_76_544 VGND VGND VPWR VPWR sky130_fd_sc_hd__decap_4
X_5905_ u_pe_array.u_fifo1.rd_ptr\[1\] u_pe_array.u_fifo1.rd_ptr\[0\] VGND VGND VPWR
+ VPWR _2675_ sky130_fd_sc_hd__or2_2
XFILLER_0_91_503 VGND VGND VPWR VPWR sky130_fd_sc_hd__fill_1
X_6885_ _0916_ _3422_ VGND VGND VPWR VPWR _3423_ sky130_fd_sc_hd__or2_2
XFILLER_0_36_419 VGND VGND VPWR VPWR sky130_fd_sc_hd__fill_1
XFILLER_0_8_354 VGND VGND VPWR VPWR sky130_fd_sc_hd__fill_1
X_5836_ u_pe_array.g_pe_row\[1\].g_pe_col\[0\].u_pe.act_val\[1\] _1118_ VGND VGND
+ VPWR VPWR _2631_ sky130_fd_sc_hd__or2_1
XFILLER_0_118_167 VGND VGND VPWR VPWR sky130_fd_sc_hd__fill_1
X_5767_ _2552_ _2561_ VGND VGND VPWR VPWR _2572_ sky130_fd_sc_hd__and2b_1
XFILLER_0_106_307 VGND VGND VPWR VPWR sky130_fd_sc_hd__fill_1
XFILLER_0_16_110 VGND VGND VPWR VPWR sky130_fd_sc_hd__fill_2
X_5698_ net95 _2016_ _2511_ u_pe_array.g_pe_row\[1\].g_pe_col\[1\].u_pe.move_reg\[10\]
+ VGND VGND VPWR VPWR _0489_ sky130_fd_sc_hd__a22o_1
X_7506_ clknet_leaf_94_clk _0412_ net951 VGND VGND VPWR VPWR u_pe_array.act_from_right\[5\]\[0\]
+ sky130_fd_sc_hd__dfrtp_1
XFILLER_0_32_614 VGND VGND VPWR VPWR sky130_fd_sc_hd__decap_3
X_4718_ u_pe_array.act_from_right\[10\]\[9\] _1750_ _1483_ net432 VGND VGND VPWR VPWR
+ _0270_ sky130_fd_sc_hd__a22o_1
X_7437_ clknet_leaf_28_clk _0343_ net71 VGND VGND VPWR VPWR u_pe_array.g_pe_row\[2\].g_pe_col\[0\].u_pe.act_val\[0\]
+ sky130_fd_sc_hd__dfrtp_4
XFILLER_0_31_113 VGND VGND VPWR VPWR sky130_fd_sc_hd__decap_8
X_4649_ _1702_ _1703_ _1708_ _1705_ _1700_ VGND VGND VPWR VPWR _1709_ sky130_fd_sc_hd__a32o_1
XFILLER_0_31_157 VGND VGND VPWR VPWR sky130_fd_sc_hd__decap_8
XFILLER_0_32_669 VPWR VGND VPWR VGND sky130_ef_sc_hd__decap_12
Xhold773 net61 VGND VGND VPWR VPWR net847 sky130_fd_sc_hd__dlygate4sd3_1
Xhold740 u_pe_array.g_pe_row\[1\].g_pe_col\[1\].u_pe.psum_out\[7\] VGND VGND VPWR
+ VPWR net814 sky130_fd_sc_hd__dlygate4sd3_1
XFILLER_0_102_557 VPWR VGND VPWR VGND sky130_ef_sc_hd__decap_12
Xhold751 u_pe_array.g_pe_row\[3\].g_pe_col\[3\].u_pe.move_reg\[9\] VGND VGND VPWR
+ VPWR net825 sky130_fd_sc_hd__dlygate4sd3_1
Xhold762 u_pe_array.g_pe_row\[3\].g_pe_col\[0\].u_pe.act_val\[5\] VGND VGND VPWR VPWR
+ net836 sky130_fd_sc_hd__dlygate4sd3_1
XFILLER_0_12_360 VGND VGND VPWR VPWR sky130_fd_sc_hd__fill_1
X_7368_ clknet_leaf_104_clk _0274_ net944 VGND VGND VPWR VPWR u_pe_array.g_pe_row\[2\].g_pe_col\[2\].u_pe.psum_out\[0\]
+ sky130_fd_sc_hd__dfrtp_1
XFILLER_0_40_691 VGND VGND VPWR VPWR sky130_fd_sc_hd__fill_1
Xhold795 net38 VGND VGND VPWR VPWR net869 sky130_fd_sc_hd__dlygate4sd3_1
Xhold784 u_pe_array.g_pe_row\[2\].g_pe_col\[2\].u_pe.psum_out\[3\] VGND VGND VPWR
+ VPWR net858 sky130_fd_sc_hd__dlygate4sd3_1
X_7299_ clknet_leaf_98_clk _0205_ net951 VGND VGND VPWR VPWR u_pe_array.g_pe_row\[2\].g_pe_col\[2\].u_pe.w_out\[0\]
+ sky130_fd_sc_hd__dfrtp_4
X_6319_ _2989_ _2990_ _2991_ VGND VGND VPWR VPWR _2993_ sky130_fd_sc_hd__or3_1
XFILLER_0_79_393 VGND VGND VPWR VPWR sky130_fd_sc_hd__fill_2
XFILLER_0_118_690 VGND VGND VPWR VPWR sky130_fd_sc_hd__decap_8
XFILLER_0_90_580 VGND VGND VPWR VPWR sky130_fd_sc_hd__decap_8
XFILLER_0_77_18 VPWR VGND VPWR VGND sky130_ef_sc_hd__decap_12
XFILLER_0_50_455 VGND VGND VPWR VPWR sky130_fd_sc_hd__decap_8
XFILLER_0_93_39 VPWR VGND VPWR VGND sky130_ef_sc_hd__decap_12
XFILLER_0_117_35 VPWR VGND VPWR VGND sky130_ef_sc_hd__decap_12
XFILLER_0_26_22 VGND VGND VPWR VPWR sky130_fd_sc_hd__decap_6
XFILLER_0_117_57 VPWR VGND VPWR VGND sky130_ef_sc_hd__decap_12
X_3951_ _0943_ VGND VGND VPWR VPWR _1169_ sky130_fd_sc_hd__buf_8
XFILLER_0_58_533 VGND VGND VPWR VPWR sky130_fd_sc_hd__decap_8
XFILLER_0_58_511 VGND VGND VPWR VPWR sky130_fd_sc_hd__fill_1
X_6670_ net65 _3259_ _3255_ _3249_ VGND VGND VPWR VPWR _3261_ sky130_fd_sc_hd__o211a_1
X_3882_ net919 _1124_ _1116_ VGND VGND VPWR VPWR _1125_ sky130_fd_sc_hd__mux2_1
X_5621_ u_pe_array.g_pe_row\[1\].g_pe_col\[2\].u_pe.psum_out\[8\] u_pe_array.g_pe_row\[1\].g_pe_col\[2\].u_pe.psum_out\[9\]
+ _1597_ VGND VGND VPWR VPWR _2464_ sky130_fd_sc_hd__and3_1
XFILLER_0_115_137 VPWR VGND VPWR VGND sky130_ef_sc_hd__decap_12
XFILLER_0_5_346 VPWR VGND VPWR VGND sky130_ef_sc_hd__decap_12
XFILLER_0_14_614 VGND VGND VPWR VPWR sky130_fd_sc_hd__fill_1
X_5552_ _2397_ _2400_ VGND VGND VPWR VPWR _2401_ sky130_fd_sc_hd__xnor2_1
XFILLER_0_13_113 VPWR VGND VPWR VGND sky130_ef_sc_hd__decap_12
X_4503_ _0946_ VGND VGND VPWR VPWR _1599_ sky130_fd_sc_hd__clkbuf_16
X_5483_ u_pe_array.u_fifo2.buffer\[3\]\[1\] _2331_ _2332_ u_pe_array.u_fifo2.buffer\[2\]\[1\]
+ _2346_ VGND VGND VPWR VPWR _2347_ sky130_fd_sc_hd__a221o_1
X_4434_ u_pe_array.g_pe_row\[3\].g_pe_col\[0\].u_pe.act_val\[5\] u_pe_array.g_pe_row\[3\].g_pe_col\[0\].u_pe.w_out\[0\]
+ _1528_ VGND VGND VPWR VPWR _1539_ sky130_fd_sc_hd__and3_1
X_7222_ clknet_leaf_6_clk _0128_ net945 VGND VGND VPWR VPWR u_pe_array.g_pe_row\[3\].g_pe_col\[1\].u_pe.act_val\[3\]
+ sky130_fd_sc_hd__dfrtp_4
XFILLER_0_1_541 VPWR VGND VPWR VGND sky130_ef_sc_hd__decap_12
Xwire7 net947 VGND VGND VPWR VPWR net946 sky130_fd_sc_hd__buf_12
X_4365_ net198 _1310_ _1175_ u_pe_array.g_pe_row\[3\].g_pe_col\[0\].u_pe.move_reg\[6\]
+ VGND VGND VPWR VPWR _0185_ sky130_fd_sc_hd__a22o_1
XFILLER_0_6_65 VPWR VGND VPWR VGND sky130_ef_sc_hd__decap_12
XFILLER_0_1_585 VPWR VGND VPWR VGND sky130_ef_sc_hd__decap_12
X_7153_ clknet_leaf_0_clk _0059_ net944 VGND VGND VPWR VPWR u_pe_array.act_from_right\[13\]\[1\]
+ sky130_fd_sc_hd__dfrtp_1
X_6104_ net192 _2499_ _2491_ _2845_ VGND VGND VPWR VPWR _0561_ sky130_fd_sc_hd__a22o_1
XTAP_330 VGND VPWR sky130_fd_sc_hd__tapvpwrvgnd_1
XTAP_341 VGND VPWR sky130_fd_sc_hd__tapvpwrvgnd_1
X_7084_ _3539_ VGND VGND VPWR VPWR _0847_ sky130_fd_sc_hd__clkbuf_1
X_4296_ u_pe_array.g_pe_row\[3\].g_pe_col\[0\].u_pe.act_val\[4\] net62 VGND VGND VPWR
+ VPWR _1442_ sky130_fd_sc_hd__or2_1
XTAP_385 VGND VPWR sky130_fd_sc_hd__tapvpwrvgnd_1
XTAP_374 VGND VPWR sky130_fd_sc_hd__tapvpwrvgnd_1
XTAP_363 VGND VPWR sky130_fd_sc_hd__tapvpwrvgnd_1
XTAP_352 VGND VPWR sky130_fd_sc_hd__tapvpwrvgnd_1
X_6035_ u_pe_array.g_pe_row\[1\].g_pe_col\[0\].u_pe.psum_out\[5\] _2775_ _2785_ VGND
+ VGND VPWR VPWR _2786_ sky130_fd_sc_hd__a21oi_1
XTAP_396 VGND VPWR sky130_fd_sc_hd__tapvpwrvgnd_1
XFILLER_0_95_105 VGND VGND VPWR VPWR sky130_fd_sc_hd__decap_6
XTAP_1529 VGND VPWR sky130_fd_sc_hd__tapvpwrvgnd_1
XTAP_1518 VGND VPWR sky130_fd_sc_hd__tapvpwrvgnd_1
XTAP_1507 VGND VPWR sky130_fd_sc_hd__tapvpwrvgnd_1
XPHY_25 VGND VGND VPWR VPWR sky130_fd_sc_hd__decap_3
XPHY_14 VGND VGND VPWR VPWR sky130_fd_sc_hd__decap_3
XPHY_36 VGND VGND VPWR VPWR sky130_fd_sc_hd__decap_3
XPHY_47 VGND VGND VPWR VPWR sky130_fd_sc_hd__decap_3
XFILLER_0_76_330 VGND VGND VPWR VPWR sky130_fd_sc_hd__decap_4
X_6937_ _0928_ net669 _3446_ VGND VGND VPWR VPWR _3452_ sky130_fd_sc_hd__mux2_1
XPHY_58 VGND VGND VPWR VPWR sky130_fd_sc_hd__decap_3
XPHY_69 VGND VGND VPWR VPWR sky130_fd_sc_hd__decap_3
XFILLER_0_9_630 VPWR VGND VPWR VGND sky130_ef_sc_hd__decap_12
X_6868_ _3413_ VGND VGND VPWR VPWR _0757_ sky130_fd_sc_hd__clkbuf_1
X_5819_ _2611_ _2613_ _2618_ VGND VGND VPWR VPWR _2619_ sky130_fd_sc_hd__o21ai_1
XFILLER_0_64_569 VGND VGND VPWR VPWR sky130_fd_sc_hd__decap_6
XFILLER_0_9_685 VPWR VGND VPWR VGND sky130_ef_sc_hd__decap_12
XFILLER_0_8_195 VGND VGND VPWR VPWR sky130_fd_sc_hd__fill_1
X_6799_ net390 _3368_ _0917_ VGND VGND VPWR VPWR _3370_ sky130_fd_sc_hd__o21ai_1
XFILLER_0_72_580 VGND VGND VPWR VPWR sky130_fd_sc_hd__fill_1
XFILLER_0_32_411 VGND VGND VPWR VPWR sky130_fd_sc_hd__decap_8
XFILLER_0_115_671 VGND VGND VPWR VPWR sky130_fd_sc_hd__fill_1
Xhold581 u_pe_array.u_fifo2.buffer\[3\]\[5\] VGND VGND VPWR VPWR net655 sky130_fd_sc_hd__dlygate4sd3_1
Xhold570 u_pe_array.u_fifo1.buffer\[5\]\[0\] VGND VGND VPWR VPWR net644 sky130_fd_sc_hd__dlygate4sd3_1
XFILLER_0_102_398 VGND VGND VPWR VPWR sky130_fd_sc_hd__fill_1
Xhold592 u_pe_array.g_pe_row\[1\].g_pe_col\[0\].u_pe.psum_out\[1\] VGND VGND VPWR
+ VPWR net666 sky130_fd_sc_hd__dlygate4sd3_1
XFILLER_0_87_606 VGND VGND VPWR VPWR sky130_fd_sc_hd__decap_8
XFILLER_0_103_15 VPWR VGND VPWR VGND sky130_ef_sc_hd__decap_12
XFILLER_0_55_558 VGND VGND VPWR VPWR sky130_fd_sc_hd__fill_2
XFILLER_0_82_377 VGND VGND VPWR VPWR sky130_fd_sc_hd__decap_6
XFILLER_0_70_506 VGND VGND VPWR VPWR sky130_fd_sc_hd__fill_2
XFILLER_0_35_260 VGND VGND VPWR VPWR sky130_fd_sc_hd__fill_1
XFILLER_0_106_693 VGND VGND VPWR VPWR sky130_fd_sc_hd__decap_6
XFILLER_0_23_444 VGND VGND VPWR VPWR sky130_fd_sc_hd__decap_4
XFILLER_0_11_617 VPWR VGND VPWR VGND sky130_ef_sc_hd__decap_12
XFILLER_0_50_274 VGND VGND VPWR VPWR sky130_fd_sc_hd__decap_6
X_4150_ u_pe_array.g_pe_row\[3\].g_pe_col\[1\].u_pe.act_val\[0\] u_pe_array.g_pe_row\[3\].g_pe_col\[1\].u_pe.psum_out\[1\]
+ _1106_ VGND VGND VPWR VPWR _1314_ sky130_fd_sc_hd__and3_1
X_4081_ _0934_ u_pe_array.g_pe_row\[3\].g_pe_col\[2\].u_pe.psum_out\[11\] VGND VGND
+ VPWR VPWR _1276_ sky130_fd_sc_hd__and2b_1
X_7840_ clknet_leaf_88_clk _0745_ VGND VGND VPWR VPWR u_pe_array.u_fifo2.buffer\[0\]\[4\]
+ sky130_fd_sc_hd__dfxtp_1
X_4983_ u_pe_array.g_pe_row\[2\].g_pe_col\[1\].u_pe.psum_out\[7\] VGND VGND VPWR VPWR
+ _1963_ sky130_fd_sc_hd__inv_2
X_7771_ clknet_leaf_50_clk _0677_ net947 VGND VGND VPWR VPWR u_pe_array.g_pe_row\[0\].g_pe_col\[1\].u_pe.psum_out\[8\]
+ sky130_fd_sc_hd__dfrtp_2
X_6722_ u_pe_array.g_pe_row\[0\].g_pe_col\[0\].u_pe.psum_out\[7\] _2488_ VGND VGND
+ VPWR VPWR _3308_ sky130_fd_sc_hd__or2_1
X_3934_ _1128_ net882 _1159_ VGND VGND VPWR VPWR _1163_ sky130_fd_sc_hd__mux2_1
XFILLER_0_46_525 VGND VGND VPWR VPWR sky130_fd_sc_hd__decap_6
X_6653_ _1092_ _3243_ _3245_ _1005_ net522 VGND VGND VPWR VPWR _0710_ sky130_fd_sc_hd__a32o_1
XFILLER_0_73_344 VPWR VGND VPWR VGND sky130_ef_sc_hd__decap_12
X_3865_ _1109_ VGND VGND VPWR VPWR _1110_ sky130_fd_sc_hd__buf_12
XFILLER_0_61_517 VGND VGND VPWR VPWR sky130_fd_sc_hd__decap_3
X_5604_ _2441_ _2447_ VGND VGND VPWR VPWR _2449_ sky130_fd_sc_hd__or2_1
X_6584_ _1092_ _3207_ _3208_ _1005_ net891 VGND VGND VPWR VPWR _0678_ sky130_fd_sc_hd__a32o_1
XFILLER_0_73_399 VGND VGND VPWR VPWR sky130_fd_sc_hd__fill_1
X_3796_ _1009_ _1018_ _1017_ VGND VGND VPWR VPWR _1050_ sky130_fd_sc_hd__a21o_1
XFILLER_0_14_400 VGND VGND VPWR VPWR sky130_fd_sc_hd__decap_6
XFILLER_0_14_466 VGND VGND VPWR VPWR sky130_fd_sc_hd__decap_8
X_5535_ u_pe_array.g_pe_row\[1\].g_pe_col\[2\].u_pe.act_val\[1\] _1595_ _2383_ _2384_
+ VGND VGND VPWR VPWR _2386_ sky130_fd_sc_hd__a22o_1
X_5466_ u_pe_array.u_fifo2.rd_ptr\[1\] u_pe_array.u_fifo2.rd_ptr\[0\] _2328_ VGND
+ VGND VPWR VPWR _2331_ sky130_fd_sc_hd__and3_2
XFILLER_0_14_477 VGND VGND VPWR VPWR sky130_fd_sc_hd__decap_8
XFILLER_0_111_162 VGND VGND VPWR VPWR sky130_fd_sc_hd__decap_6
X_7205_ clknet_leaf_36_clk _0111_ net942 VGND VGND VPWR VPWR u_pe_array.g_pe_row\[3\].g_pe_col\[0\].u_pe.w_out\[1\]
+ sky130_fd_sc_hd__dfrtp_1
X_4417_ _1522_ _1523_ VGND VGND VPWR VPWR _1524_ sky130_fd_sc_hd__or2_1
X_5397_ net910 _2284_ _2273_ VGND VGND VPWR VPWR _2285_ sky130_fd_sc_hd__mux2_1
XFILLER_0_1_393 VPWR VGND VPWR VGND sky130_ef_sc_hd__decap_12
X_7136_ clknet_leaf_18_clk _0042_ net943 VGND VGND VPWR VPWR u_pe_array.g_pe_row\[3\].g_pe_col\[3\].u_pe.move_reg\[12\]
+ sky130_fd_sc_hd__dfrtp_1
X_4348_ net170 _1166_ _1456_ _1476_ VGND VGND VPWR VPWR _0174_ sky130_fd_sc_hd__a22o_1
X_4279_ u_pe_array.g_pe_row\[3\].g_pe_col\[0\].u_pe.act_val\[0\] net62 VGND VGND VPWR
+ VPWR _1429_ sky130_fd_sc_hd__or2_1
X_7067_ _3530_ VGND VGND VPWR VPWR _0839_ sky130_fd_sc_hd__clkbuf_1
X_6018_ _2762_ _2770_ VGND VGND VPWR VPWR _2771_ sky130_fd_sc_hd__nor2_1
XTAP_1304 VGND VPWR sky130_fd_sc_hd__tapvpwrvgnd_1
XTAP_1348 VGND VPWR sky130_fd_sc_hd__tapvpwrvgnd_1
XTAP_1337 VGND VPWR sky130_fd_sc_hd__tapvpwrvgnd_1
XTAP_1315 VGND VPWR sky130_fd_sc_hd__tapvpwrvgnd_1
XTAP_1326 VGND VPWR sky130_fd_sc_hd__tapvpwrvgnd_1
XFILLER_0_84_609 VGND VGND VPWR VPWR sky130_fd_sc_hd__decap_4
XFILLER_0_49_330 VGND VGND VPWR VPWR sky130_fd_sc_hd__decap_6
XTAP_1359 VGND VPWR sky130_fd_sc_hd__tapvpwrvgnd_1
XFILLER_0_83_119 VPWR VGND VPWR VGND sky130_ef_sc_hd__decap_12
XFILLER_0_64_300 VGND VGND VPWR VPWR sky130_fd_sc_hd__decap_8
XFILLER_0_92_642 VGND VGND VPWR VPWR sky130_fd_sc_hd__fill_2
XFILLER_0_37_558 VGND VGND VPWR VPWR sky130_fd_sc_hd__fill_2
XFILLER_0_92_664 VPWR VGND VPWR VGND sky130_ef_sc_hd__decap_12
XFILLER_0_52_506 VGND VGND VPWR VPWR sky130_fd_sc_hd__decap_3
XFILLER_0_17_271 VGND VGND VPWR VPWR sky130_fd_sc_hd__decap_8
XFILLER_0_17_293 VGND VGND VPWR VPWR sky130_fd_sc_hd__decap_4
XFILLER_0_103_685 VPWR VGND VPWR VGND sky130_ef_sc_hd__decap_12
XFILLER_0_103_663 VGND VGND VPWR VPWR sky130_fd_sc_hd__decap_8
XFILLER_0_32_296 VPWR VGND VPWR VGND sky130_ef_sc_hd__decap_12
XFILLER_0_90_29 VPWR VGND VPWR VGND sky130_ef_sc_hd__decap_12
XFILLER_0_87_447 VGND VGND VPWR VPWR sky130_fd_sc_hd__fill_1
XFILLER_0_55_300 VGND VGND VPWR VPWR sky130_fd_sc_hd__decap_6
XFILLER_0_23_23 VGND VGND VPWR VPWR sky130_fd_sc_hd__fill_1
XFILLER_0_99_27 VPWR VGND VPWR VGND sky130_ef_sc_hd__decap_12
XFILLER_0_55_366 VGND VGND VPWR VPWR sky130_fd_sc_hd__decap_6
X_3650_ _0853_ _0855_ VGND VGND VPWR VPWR _0936_ sky130_fd_sc_hd__or2_1
X_3581_ net318 _0886_ VGND VGND VPWR VPWR _0000_ sky130_fd_sc_hd__nor2_1
X_5320_ _2218_ _2219_ VGND VGND VPWR VPWR _2220_ sky130_fd_sc_hd__or2_1
XFILLER_0_23_263 VGND VGND VPWR VPWR sky130_fd_sc_hd__decap_8
X_5251_ net509 _0939_ VGND VGND VPWR VPWR _2159_ sky130_fd_sc_hd__and2_1
XFILLER_0_51_594 VGND VGND VPWR VPWR sky130_fd_sc_hd__decap_4
X_4202_ _1346_ _1357_ _1361_ VGND VGND VPWR VPWR _1362_ sky130_fd_sc_hd__o21a_1
X_5182_ u_pe_array.g_pe_row\[2\].g_pe_col\[0\].u_pe.psum_out\[10\] _2104_ _2111_ _2115_
+ VGND VGND VPWR VPWR _2118_ sky130_fd_sc_hd__a2bb2o_1
XFILLER_0_48_75 VGND VGND VPWR VPWR sky130_fd_sc_hd__decap_8
X_4133_ u_pe_array.g_pe_row\[3\].g_pe_col\[1\].u_pe.act_val\[3\] _1301_ _1305_ _1307_
+ VGND VGND VPWR VPWR _0128_ sky130_fd_sc_hd__a22o_1
XFILLER_0_3_55 VGND VGND VPWR VPWR sky130_fd_sc_hd__fill_1
X_4064_ u_pe_array.g_pe_row\[3\].g_pe_col\[2\].u_pe.psum_out\[8\] u_pe_array.g_pe_row\[3\].g_pe_col\[2\].u_pe.psum_out\[9\]
+ _0934_ VGND VGND VPWR VPWR _1261_ sky130_fd_sc_hd__and3_1
XFILLER_0_64_52 VGND VGND VPWR VPWR sky130_fd_sc_hd__fill_2
XFILLER_0_64_85 VGND VGND VPWR VPWR sky130_fd_sc_hd__decap_8
X_7823_ clknet_leaf_90_clk _0728_ VGND VGND VPWR VPWR u_pe_array.u_fifo1.buffer\[8\]\[5\]
+ sky130_fd_sc_hd__dfxtp_1
X_7754_ clknet_leaf_48_clk net254 net73 VGND VGND VPWR VPWR u_pe_array.g_pe_row\[0\].g_pe_col\[1\].u_pe.act_val\[4\]
+ sky130_fd_sc_hd__dfrtp_1
XFILLER_0_93_428 VGND VGND VPWR VPWR sky130_fd_sc_hd__fill_2
X_4966_ _1932_ _1934_ _1947_ VGND VGND VPWR VPWR _1948_ sky130_fd_sc_hd__a21oi_1
X_6705_ _3275_ _3282_ _3292_ VGND VGND VPWR VPWR _3293_ sky130_fd_sc_hd__o21ba_1
X_4897_ u_pe_array.g_pe_row\[2\].g_pe_col\[1\].u_pe.act_val\[0\] u_pe_array.g_pe_row\[2\].g_pe_col\[1\].u_pe.w_out\[0\]
+ u_pe_array.g_pe_row\[2\].g_pe_col\[1\].u_pe.psum_out\[0\] VGND VGND VPWR VPWR _1885_
+ sky130_fd_sc_hd__a21o_1
X_7685_ clknet_leaf_58_clk _0591_ net74 VGND VGND VPWR VPWR u_pe_array.g_pe_row\[0\].g_pe_col\[3\].u_pe.psum_out\[4\]
+ sky130_fd_sc_hd__dfrtp_1
XFILLER_0_74_675 VGND VGND VPWR VPWR sky130_fd_sc_hd__fill_1
XFILLER_0_73_152 VPWR VGND VPWR VGND sky130_ef_sc_hd__decap_12
X_3917_ _1151_ VGND VGND VPWR VPWR _0068_ sky130_fd_sc_hd__clkbuf_1
XFILLER_0_46_355 VGND VGND VPWR VPWR sky130_fd_sc_hd__fill_2
X_3848_ u_pe_array.g_pe_row\[3\].g_pe_col\[3\].u_pe.psum_out\[11\] _1096_ _1086_ VGND
+ VGND VPWR VPWR _1097_ sky130_fd_sc_hd__mux2_1
X_6636_ net387 _1731_ _1734_ _3242_ VGND VGND VPWR VPWR _0696_ sky130_fd_sc_hd__a22o_1
XFILLER_0_116_265 VPWR VGND VPWR VGND sky130_ef_sc_hd__decap_12
X_6567_ u_pe_array.g_pe_row\[0\].g_pe_col\[1\].u_pe.psum_out\[7\] VGND VGND VPWR VPWR
+ _3193_ sky130_fd_sc_hd__inv_2
X_3779_ u_pe_array.g_pe_row\[3\].g_pe_col\[3\].u_pe.act_val\[4\] _0988_ VGND VGND
+ VPWR VPWR _1034_ sky130_fd_sc_hd__and2b_1
XFILLER_0_30_701 VGND VGND VPWR VPWR sky130_fd_sc_hd__decap_4
X_5518_ u_pe_array.act_from_up\[6\]\[5\] _2341_ VGND VGND VPWR VPWR _2378_ sky130_fd_sc_hd__or2_1
X_6498_ _3128_ _3129_ VGND VGND VPWR VPWR _3130_ sky130_fd_sc_hd__xnor2_1
X_5449_ net158 _1166_ _2297_ _1476_ VGND VGND VPWR VPWR _0432_ sky130_fd_sc_hd__a22o_1
XFILLER_0_100_677 VPWR VGND VPWR VGND sky130_ef_sc_hd__decap_12
X_7119_ clknet_leaf_4_clk net361 net945 VGND VGND VPWR VPWR u_pe_array.act_from_down\[11\]\[8\]
+ sky130_fd_sc_hd__dfrtp_1
XFILLER_0_97_701 VGND VGND VPWR VPWR sky130_fd_sc_hd__decap_4
XTAP_1123 VGND VPWR sky130_fd_sc_hd__tapvpwrvgnd_1
XTAP_1112 VGND VPWR sky130_fd_sc_hd__tapvpwrvgnd_1
XTAP_1101 VGND VPWR sky130_fd_sc_hd__tapvpwrvgnd_1
XTAP_1156 VGND VPWR sky130_fd_sc_hd__tapvpwrvgnd_1
XTAP_1145 VGND VPWR sky130_fd_sc_hd__tapvpwrvgnd_1
XTAP_1134 VGND VPWR sky130_fd_sc_hd__tapvpwrvgnd_1
XTAP_1189 VGND VPWR sky130_fd_sc_hd__tapvpwrvgnd_1
XTAP_1178 VGND VPWR sky130_fd_sc_hd__tapvpwrvgnd_1
XTAP_1167 VGND VPWR sky130_fd_sc_hd__tapvpwrvgnd_1
XFILLER_0_25_539 VGND VGND VPWR VPWR sky130_fd_sc_hd__fill_1
XFILLER_0_80_667 VGND VGND VPWR VPWR sky130_fd_sc_hd__decap_8
XFILLER_0_100_27 VGND VGND VPWR VPWR sky130_fd_sc_hd__fill_1
XFILLER_0_80_689 VGND VGND VPWR VPWR sky130_fd_sc_hd__fill_2
XFILLER_0_21_701 VGND VGND VPWR VPWR sky130_fd_sc_hd__decap_4
XFILLER_0_33_550 VGND VGND VPWR VPWR sky130_fd_sc_hd__fill_1
XFILLER_0_0_617 VPWR VGND VPWR VGND sky130_ef_sc_hd__decap_12
XFILLER_0_20_211 VGND VGND VPWR VPWR sky130_fd_sc_hd__decap_4
XFILLER_0_20_233 VGND VGND VPWR VPWR sky130_fd_sc_hd__decap_3
XTAP_907 VGND VPWR sky130_fd_sc_hd__tapvpwrvgnd_1
XTAP_929 VGND VPWR sky130_fd_sc_hd__tapvpwrvgnd_1
XTAP_918 VGND VPWR sky130_fd_sc_hd__tapvpwrvgnd_1
XFILLER_0_109_69 VPWR VGND VPWR VGND sky130_ef_sc_hd__decap_12
XFILLER_0_88_701 VGND VGND VPWR VPWR sky130_fd_sc_hd__decap_4
X_4820_ u_pe_array.g_pe_row\[2\].g_pe_col\[2\].u_pe.psum_out\[9\] _0933_ VGND VGND
+ VPWR VPWR _1840_ sky130_fd_sc_hd__or2_1
XFILLER_0_7_205 VGND VGND VPWR VPWR sky130_fd_sc_hd__decap_4
XTAP_1690 VGND VPWR sky130_fd_sc_hd__tapvpwrvgnd_1
X_4751_ u_pe_array.g_pe_row\[2\].g_pe_col\[2\].u_pe.act_val\[2\] u_pe_array.g_pe_row\[2\].g_pe_col\[2\].u_pe.w_out\[0\]
+ _1763_ VGND VGND VPWR VPWR _1777_ sky130_fd_sc_hd__and3_1
X_7470_ clknet_leaf_64_clk _0376_ net946 VGND VGND VPWR VPWR u_pe_array.act_from_down\[3\]\[5\]
+ sky130_fd_sc_hd__dfrtp_1
X_3702_ net918 _0949_ _0944_ _0969_ VGND VGND VPWR VPWR _0035_ sky130_fd_sc_hd__a22o_1
X_4682_ u_pe_array.act_from_up\[14\]\[0\] _1732_ _1735_ _1736_ VGND VGND VPWR VPWR
+ _0248_ sky130_fd_sc_hd__a22o_1
XFILLER_0_71_667 VGND VGND VPWR VPWR sky130_fd_sc_hd__decap_4
XFILLER_0_70_133 VGND VGND VPWR VPWR sky130_fd_sc_hd__fill_1
X_3633_ u_pe_array.act_from_up\[14\]\[3\] _0869_ _0854_ VGND VGND VPWR VPWR _0924_
+ sky130_fd_sc_hd__and3_2
XFILLER_0_31_509 VGND VGND VPWR VPWR sky130_fd_sc_hd__fill_1
X_6421_ u_pe_array.g_pe_row\[0\].g_pe_col\[2\].u_pe.psum_out\[10\] _3085_ _3075_ VGND
+ VGND VPWR VPWR _3086_ sky130_fd_sc_hd__mux2_1
XFILLER_0_12_701 VGND VGND VPWR VPWR sky130_fd_sc_hd__decap_4
XFILLER_0_113_279 VGND VGND VPWR VPWR sky130_fd_sc_hd__fill_1
XFILLER_0_11_211 VPWR VGND VPWR VGND sky130_ef_sc_hd__decap_12
X_3564_ u_fsm.h_cnt\[1\] u_fsm.v_cnt\[0\] u_fsm.v_cnt\[1\] u_fsm.v_cnt\[2\] VGND VGND
+ VPWR VPWR _0872_ sky130_fd_sc_hd__or4_1
X_6352_ _3021_ u_pe_array.g_pe_row\[0\].g_pe_col\[2\].u_pe.psum_out\[4\] _2130_ VGND
+ VGND VPWR VPWR _3023_ sky130_fd_sc_hd__and3_1
X_5303_ u_pe_array.g_pe_row\[1\].g_pe_col\[3\].u_pe.act_val\[5\] _1423_ u_pe_array.g_pe_row\[1\].g_pe_col\[3\].u_pe.psum_out\[5\]
+ VGND VGND VPWR VPWR _2204_ sky130_fd_sc_hd__a21oi_1
XFILLER_0_11_255 VGND VGND VPWR VPWR sky130_fd_sc_hd__fill_1
X_6283_ u_pe_array.g_pe_row\[0\].g_pe_col\[2\].u_pe.psum_out\[5\] u_pe_array.g_pe_row\[0\].g_pe_col\[2\].u_pe.act_val\[5\]
+ _2844_ VGND VGND VPWR VPWR _2979_ sky130_fd_sc_hd__mux2_1
X_5234_ u_pe_array.g_pe_row\[1\].g_pe_col\[3\].u_pe.act_val\[2\] _2143_ _2132_ _2150_
+ VGND VGND VPWR VPWR _0386_ sky130_fd_sc_hd__a22o_1
X_5165_ _2102_ _2103_ net922 _1006_ VGND VGND VPWR VPWR _0364_ sky130_fd_sc_hd__a2bb2o_1
X_4116_ u_pe_array.g_pe_row\[3\].g_pe_col\[1\].u_pe.psum_out\[9\] u_pe_array.g_pe_row\[3\].g_pe_col\[1\].u_pe.move_reg\[9\]
+ _0947_ VGND VGND VPWR VPWR _1298_ sky130_fd_sc_hd__mux2_1
XFILLER_0_75_62 VGND VGND VPWR VPWR sky130_fd_sc_hd__decap_3
XFILLER_0_38_3 VGND VGND VPWR VPWR sky130_fd_sc_hd__decap_6
X_5096_ _2038_ _2039_ VGND VGND VPWR VPWR _2040_ sky130_fd_sc_hd__nor2_1
X_4047_ _1238_ _1244_ VGND VGND VPWR VPWR _1246_ sky130_fd_sc_hd__or2_1
XFILLER_0_78_244 VGND VGND VPWR VPWR sky130_fd_sc_hd__fill_1
XPHY_206 VGND VGND VPWR VPWR sky130_fd_sc_hd__decap_3
XFILLER_0_93_203 VGND VGND VPWR VPWR sky130_fd_sc_hd__decap_4
X_7806_ clknet_leaf_56_clk _0711_ net74 VGND VGND VPWR VPWR u_pe_array.g_pe_row\[0\].g_pe_col\[0\].u_pe.psum_out\[1\]
+ sky130_fd_sc_hd__dfrtp_1
XPHY_228 VGND VGND VPWR VPWR sky130_fd_sc_hd__decap_3
XPHY_217 VGND VGND VPWR VPWR sky130_fd_sc_hd__decap_3
XFILLER_0_93_225 VGND VGND VPWR VPWR sky130_fd_sc_hd__fill_2
XFILLER_0_19_333 VGND VGND VPWR VPWR sky130_fd_sc_hd__decap_3
X_5998_ u_pe_array.g_pe_row\[1\].g_pe_col\[0\].u_pe.act_val\[3\] u_pe_array.g_pe_row\[1\].g_pe_col\[0\].u_pe.w_out\[0\]
+ _1865_ _2634_ VGND VGND VPWR VPWR _2752_ sky130_fd_sc_hd__a22o_1
XFILLER_0_47_642 VGND VGND VPWR VPWR sky130_fd_sc_hd__decap_8
X_4949_ u_pe_array.g_pe_row\[2\].g_pe_col\[1\].u_pe.psum_out\[5\] _1931_ VGND VGND
+ VPWR VPWR _1932_ sky130_fd_sc_hd__xnor2_2
X_7737_ clknet_leaf_52_clk _0643_ net74 VGND VGND VPWR VPWR u_pe_array.act_from_right\[0\]\[0\]
+ sky130_fd_sc_hd__dfrtp_1
X_7668_ clknet_leaf_63_clk _0574_ net74 VGND VGND VPWR VPWR u_pe_array.g_pe_row\[0\].g_pe_col\[3\].u_pe.act_val\[0\]
+ sky130_fd_sc_hd__dfrtp_2
X_6619_ u_pe_array.g_pe_row\[0\].g_pe_col\[0\].u_pe.psum_out\[4\] u_pe_array.g_pe_row\[0\].g_pe_col\[0\].u_pe.act_val\[4\]
+ _3102_ VGND VGND VPWR VPWR _3234_ sky130_fd_sc_hd__mux2_1
X_7599_ clknet_leaf_26_clk _0505_ net943 VGND VGND VPWR VPWR u_pe_array.g_pe_row\[0\].g_pe_col\[3\].u_pe.w_out\[0\]
+ sky130_fd_sc_hd__dfrtp_4
XFILLER_0_6_282 VGND VGND VPWR VPWR sky130_fd_sc_hd__fill_1
XFILLER_0_15_572 VPWR VGND VPWR VGND sky130_ef_sc_hd__decap_12
XFILLER_0_100_430 VGND VGND VPWR VPWR sky130_fd_sc_hd__decap_8
XFILLER_0_30_586 VGND VGND VPWR VPWR sky130_fd_sc_hd__fill_2
XFILLER_0_89_509 VGND VGND VPWR VPWR sky130_fd_sc_hd__fill_1
XFILLER_0_65_494 VGND VGND VPWR VPWR sky130_fd_sc_hd__decap_8
XFILLER_0_25_325 VGND VGND VPWR VPWR sky130_fd_sc_hd__fill_1
XFILLER_0_111_15 VPWR VGND VPWR VGND sky130_ef_sc_hd__decap_12
XFILLER_0_21_531 VGND VGND VPWR VPWR sky130_fd_sc_hd__decap_3
XFILLER_0_21_586 VGND VGND VPWR VPWR sky130_fd_sc_hd__fill_2
XTAP_704 VGND VPWR sky130_fd_sc_hd__tapvpwrvgnd_1
XTAP_715 VGND VPWR sky130_fd_sc_hd__tapvpwrvgnd_1
XTAP_726 VGND VPWR sky130_fd_sc_hd__tapvpwrvgnd_1
XTAP_737 VGND VPWR sky130_fd_sc_hd__tapvpwrvgnd_1
XTAP_759 VGND VPWR sky130_fd_sc_hd__tapvpwrvgnd_1
XTAP_748 VGND VPWR sky130_fd_sc_hd__tapvpwrvgnd_1
X_6970_ u_pe_array.u_fifo1.count\[1\] _3348_ _3473_ _2341_ VGND VGND VPWR VPWR _3474_
+ sky130_fd_sc_hd__and4bb_1
XFILLER_0_45_54 VGND VGND VPWR VPWR sky130_fd_sc_hd__fill_2
XFILLER_0_45_65 VGND VGND VPWR VPWR sky130_fd_sc_hd__decap_6
XFILLER_0_88_553 VGND VGND VPWR VPWR sky130_fd_sc_hd__decap_3
X_5921_ u_pe_array.u_fifo1.buffer\[3\]\[0\] _2685_ _2686_ u_pe_array.u_fifo1.buffer\[2\]\[0\]
+ _2690_ VGND VGND VPWR VPWR _2691_ sky130_fd_sc_hd__a221o_1
XFILLER_0_0_34 VPWR VGND VPWR VGND sky130_ef_sc_hd__decap_12
XFILLER_0_75_225 VGND VGND VPWR VPWR sky130_fd_sc_hd__fill_1
X_5852_ _2643_ VGND VGND VPWR VPWR _0511_ sky130_fd_sc_hd__clkbuf_1
XFILLER_0_61_64 VGND VGND VPWR VPWR sky130_fd_sc_hd__decap_8
X_4803_ _1819_ _1823_ VGND VGND VPWR VPWR _1825_ sky130_fd_sc_hd__nand2_1
X_5783_ _0985_ VGND VGND VPWR VPWR _2586_ sky130_fd_sc_hd__clkbuf_16
XFILLER_0_56_461 VGND VGND VPWR VPWR sky130_fd_sc_hd__fill_1
X_4734_ u_pe_array.g_pe_row\[2\].g_pe_col\[2\].u_pe.psum_out\[1\] _1757_ _1760_ VGND
+ VGND VPWR VPWR _1761_ sky130_fd_sc_hd__a21bo_1
XFILLER_0_29_697 VGND VGND VPWR VPWR sky130_fd_sc_hd__decap_8
X_7522_ clknet_leaf_93_clk _0428_ net949 VGND VGND VPWR VPWR u_pe_array.act_from_left\[7\]\[3\]
+ sky130_fd_sc_hd__dfrtp_1
XFILLER_0_114_533 VGND VGND VPWR VPWR sky130_fd_sc_hd__decap_4
XFILLER_0_114_522 VGND VGND VPWR VPWR sky130_fd_sc_hd__decap_8
X_7453_ clknet_leaf_33_clk _0359_ net951 VGND VGND VPWR VPWR u_pe_array.g_pe_row\[2\].g_pe_col\[0\].u_pe.psum_out\[3\]
+ sky130_fd_sc_hd__dfrtp_1
XFILLER_0_71_464 VGND VGND VPWR VPWR sky130_fd_sc_hd__decap_3
X_4665_ _1709_ _1713_ _1720_ _1722_ _1719_ VGND VGND VPWR VPWR _1723_ sky130_fd_sc_hd__a32o_1
XFILLER_0_114_577 VGND VGND VPWR VPWR sky130_fd_sc_hd__fill_2
X_7384_ clknet_leaf_27_clk _0290_ net942 VGND VGND VPWR VPWR u_pe_array.act_from_right\[8\]\[1\]
+ sky130_fd_sc_hd__dfrtp_1
XFILLER_0_12_531 VGND VGND VPWR VPWR sky130_fd_sc_hd__fill_1
X_3616_ net197 _0909_ _0910_ VGND VGND VPWR VPWR _0008_ sky130_fd_sc_hd__a21oi_1
X_4596_ u_pe_array.g_pe_row\[2\].g_pe_col\[3\].u_pe.act_val\[5\] _1424_ VGND VGND
+ VPWR VPWR _1661_ sky130_fd_sc_hd__nand2_1
X_6404_ u_pe_array.g_pe_row\[0\].g_pe_col\[2\].u_pe.psum_out\[8\] _3056_ VGND VGND
+ VPWR VPWR _3071_ sky130_fd_sc_hd__nor2_1
XFILLER_0_101_238 VPWR VGND VPWR VGND sky130_ef_sc_hd__decap_12
XFILLER_0_101_216 VGND VGND VPWR VPWR sky130_fd_sc_hd__decap_8
XFILLER_0_101_81 VGND VGND VPWR VPWR sky130_fd_sc_hd__decap_4
XFILLER_0_12_564 VGND VGND VPWR VPWR sky130_fd_sc_hd__decap_8
X_3547_ u_fsm.state\[0\] u_fsm.state\[1\] VGND VGND VPWR VPWR _0855_ sky130_fd_sc_hd__and2b_1
X_6335_ u_pe_array.g_pe_row\[0\].g_pe_col\[2\].u_pe.act_val\[3\] _2128_ VGND VGND
+ VPWR VPWR _3007_ sky130_fd_sc_hd__nand2_1
XFILLER_0_12_575 VGND VGND VPWR VPWR sky130_fd_sc_hd__decap_4
XFILLER_0_86_61 VGND VGND VPWR VPWR sky130_fd_sc_hd__decap_4
X_6266_ u_pe_array.g_pe_row\[0\].g_pe_col\[3\].u_pe.psum_out\[12\] _2962_ VGND VGND
+ VPWR VPWR _2970_ sky130_fd_sc_hd__xnor2_1
X_5217_ net530 _1882_ _2132_ _2141_ VGND VGND VPWR VPWR _0378_ sky130_fd_sc_hd__a22o_1
X_6197_ u_pe_array.g_pe_row\[0\].g_pe_col\[3\].u_pe.psum_out\[4\] _2895_ _2907_ VGND
+ VGND VPWR VPWR _2908_ sky130_fd_sc_hd__a21oi_2
X_5148_ _2087_ VGND VGND VPWR VPWR _2088_ sky130_fd_sc_hd__inv_2
XFILLER_0_98_306 VGND VGND VPWR VPWR sky130_fd_sc_hd__fill_2
X_5079_ _1884_ _2023_ _2024_ _1803_ net705 VGND VGND VPWR VPWR _0357_ sky130_fd_sc_hd__a32o_1
XFILLER_0_39_428 VPWR VGND VPWR VGND sky130_ef_sc_hd__decap_12
XFILLER_0_94_556 VGND VGND VPWR VPWR sky130_fd_sc_hd__decap_6
XFILLER_0_35_612 VGND VGND VPWR VPWR sky130_fd_sc_hd__decap_4
XFILLER_0_47_472 VGND VGND VPWR VPWR sky130_fd_sc_hd__fill_2
XFILLER_0_34_144 VGND VGND VPWR VPWR sky130_fd_sc_hd__decap_6
XFILLER_0_34_155 VGND VGND VPWR VPWR sky130_fd_sc_hd__fill_1
XFILLER_0_106_15 VPWR VGND VPWR VGND sky130_ef_sc_hd__decap_12
XFILLER_0_57_203 VGND VGND VPWR VPWR sky130_fd_sc_hd__decap_6
XFILLER_0_15_57 VGND VGND VPWR VPWR sky130_fd_sc_hd__decap_3
XFILLER_0_25_133 VGND VGND VPWR VPWR sky130_fd_sc_hd__decap_6
XFILLER_0_53_420 VGND VGND VPWR VPWR sky130_fd_sc_hd__decap_6
XFILLER_0_53_442 VGND VGND VPWR VPWR sky130_fd_sc_hd__decap_6
XFILLER_0_108_371 VGND VGND VPWR VPWR sky130_fd_sc_hd__fill_1
XFILLER_0_26_678 VGND VGND VPWR VPWR sky130_fd_sc_hd__decap_4
XFILLER_0_53_453 VGND VGND VPWR VPWR sky130_fd_sc_hd__fill_1
XFILLER_0_111_503 VGND VGND VPWR VPWR sky130_fd_sc_hd__fill_1
Xhold207 u_pe_array.g_pe_row\[0\].g_pe_col\[1\].u_pe.move_reg\[12\] VGND VGND VPWR
+ VPWR net281 sky130_fd_sc_hd__dlygate4sd3_1
X_4450_ _1553_ u_pe_array.g_pe_row\[3\].g_pe_col\[0\].u_pe.psum_out\[7\] _1536_ VGND
+ VGND VPWR VPWR _1554_ sky130_fd_sc_hd__mux2_1
Xhold229 u_pe_array.g_pe_row\[1\].g_pe_col\[0\].u_pe.move_reg\[12\] VGND VGND VPWR
+ VPWR net303 sky130_fd_sc_hd__dlygate4sd3_1
X_4381_ _1486_ _1490_ VGND VGND VPWR VPWR _1491_ sky130_fd_sc_hd__xnor2_1
Xhold218 _0622_ VGND VGND VPWR VPWR net292 sky130_fd_sc_hd__dlygate4sd3_1
XFILLER_0_111_558 VGND VGND VPWR VPWR sky130_fd_sc_hd__fill_2
X_6120_ net524 _2853_ _2847_ _2854_ VGND VGND VPWR VPWR _0568_ sky130_fd_sc_hd__a22o_1
XTAP_501 VGND VPWR sky130_fd_sc_hd__tapvpwrvgnd_1
XTAP_512 VGND VPWR sky130_fd_sc_hd__tapvpwrvgnd_1
XTAP_523 VGND VPWR sky130_fd_sc_hd__tapvpwrvgnd_1
XTAP_534 VGND VPWR sky130_fd_sc_hd__tapvpwrvgnd_1
XTAP_545 VGND VPWR sky130_fd_sc_hd__tapvpwrvgnd_1
XTAP_556 VGND VPWR sky130_fd_sc_hd__tapvpwrvgnd_1
XTAP_567 VGND VPWR sky130_fd_sc_hd__tapvpwrvgnd_1
X_6051_ _2800_ u_pe_array.g_pe_row\[1\].g_pe_col\[0\].u_pe.psum_out\[7\] _2782_ VGND
+ VGND VPWR VPWR _2801_ sky130_fd_sc_hd__mux2_1
X_5002_ _1973_ _1974_ _1979_ _1976_ _1971_ VGND VGND VPWR VPWR _1980_ sky130_fd_sc_hd__a32o_1
XFILLER_0_56_42 VGND VGND VPWR VPWR sky130_fd_sc_hd__fill_2
XTAP_589 VGND VPWR sky130_fd_sc_hd__tapvpwrvgnd_1
XTAP_578 VGND VPWR sky130_fd_sc_hd__tapvpwrvgnd_1
XFILLER_0_76_501 VGND VGND VPWR VPWR sky130_fd_sc_hd__fill_1
X_6953_ net481 _3460_ _3351_ VGND VGND VPWR VPWR _3462_ sky130_fd_sc_hd__o21ai_1
X_5904_ net167 _1159_ _2667_ _0983_ VGND VGND VPWR VPWR _0532_ sky130_fd_sc_hd__a22o_1
X_6884_ _0912_ u_pe_array.u_fifo2.wr_ptr\[3\] u_pe_array.u_fifo2.wr_ptr\[2\] _0914_
+ VGND VGND VPWR VPWR _3422_ sky130_fd_sc_hd__or4bb_2
Xclkbuf_3_5__f_clk clknet_0_clk VGND VGND VPWR VPWR clknet_3_5__leaf_clk sky130_fd_sc_hd__clkbuf_16
XFILLER_0_118_113 VPWR VGND VPWR VGND sky130_ef_sc_hd__decap_12
X_5835_ _2630_ VGND VGND VPWR VPWR _0507_ sky130_fd_sc_hd__clkbuf_1
XFILLER_0_76_589 VPWR VGND VPWR VGND sky130_ef_sc_hd__decap_12
XFILLER_0_63_217 VGND VGND VPWR VPWR sky130_fd_sc_hd__fill_1
XFILLER_0_29_483 VGND VGND VPWR VPWR sky130_fd_sc_hd__decap_4
X_5766_ _2532_ _2541_ _2540_ VGND VGND VPWR VPWR _2571_ sky130_fd_sc_hd__a21o_1
XFILLER_0_91_559 VGND VGND VPWR VPWR sky130_fd_sc_hd__fill_1
X_7505_ clknet_leaf_30_clk _0411_ net71 VGND VGND VPWR VPWR u_pe_array.g_pe_row\[1\].g_pe_col\[1\].u_pe.w_out\[1\]
+ sky130_fd_sc_hd__dfrtp_1
X_5697_ _0939_ VGND VGND VPWR VPWR _2511_ sky130_fd_sc_hd__clkbuf_8
XFILLER_0_71_250 VPWR VGND VPWR VGND sky130_ef_sc_hd__decap_12
X_4717_ net391 _1750_ _1483_ net412 VGND VGND VPWR VPWR _0269_ sky130_fd_sc_hd__a22o_1
XFILLER_0_44_475 VGND VGND VPWR VPWR sky130_fd_sc_hd__fill_1
X_7436_ clknet_leaf_13_clk _0342_ net951 VGND VGND VPWR VPWR u_pe_array.act_from_up\[12\]\[12\]
+ sky130_fd_sc_hd__dfrtp_1
X_4648_ u_pe_array.g_pe_row\[2\].g_pe_col\[3\].u_pe.psum_out\[7\] u_pe_array.g_pe_row\[2\].g_pe_col\[3\].u_pe.psum_out\[8\]
+ _1427_ VGND VGND VPWR VPWR _1708_ sky130_fd_sc_hd__o21a_1
XFILLER_0_31_169 VGND VGND VPWR VPWR sky130_fd_sc_hd__decap_8
Xhold730 u_pe_array.g_pe_row\[3\].g_pe_col\[2\].u_pe.psum_out\[10\] VGND VGND VPWR
+ VPWR net804 sky130_fd_sc_hd__dlygate4sd3_1
XFILLER_0_102_569 VPWR VGND VPWR VGND sky130_ef_sc_hd__decap_12
Xhold763 net47 VGND VGND VPWR VPWR net837 sky130_fd_sc_hd__dlygate4sd3_1
X_4579_ _1644_ _1640_ _1642_ VGND VGND VPWR VPWR _1646_ sky130_fd_sc_hd__or3_1
Xhold741 net55 VGND VGND VPWR VPWR net815 sky130_fd_sc_hd__dlygate4sd3_1
Xhold752 u_pe_array.act_from_right\[13\]\[0\] VGND VGND VPWR VPWR net826 sky130_fd_sc_hd__dlygate4sd3_1
X_7367_ clknet_leaf_9_clk net94 net945 VGND VGND VPWR VPWR u_pe_array.g_pe_row\[2\].g_pe_col\[2\].u_pe.move_reg\[12\]
+ sky130_fd_sc_hd__dfrtp_1
Xhold785 net58 VGND VGND VPWR VPWR net859 sky130_fd_sc_hd__dlygate4sd3_1
Xhold796 u_pe_array.g_pe_row\[1\].g_pe_col\[1\].u_pe.act_val\[1\] VGND VGND VPWR VPWR
+ net870 sky130_fd_sc_hd__dlygate4sd3_1
Xhold774 u_pe_array.act_from_up\[12\]\[3\] VGND VGND VPWR VPWR net848 sky130_fd_sc_hd__dlygate4sd3_1
X_7298_ clknet_leaf_95_clk _0204_ net951 VGND VGND VPWR VPWR u_pe_array.g_pe_row\[3\].g_pe_col\[0\].u_pe.psum_out\[12\]
+ sky130_fd_sc_hd__dfrtp_1
X_6318_ _2990_ _2991_ _2989_ VGND VGND VPWR VPWR _2992_ sky130_fd_sc_hd__o21ai_1
X_6249_ u_pe_array.g_pe_row\[0\].g_pe_col\[3\].u_pe.psum_out\[10\] _1999_ VGND VGND
+ VPWR VPWR _2955_ sky130_fd_sc_hd__nand2_1
XFILLER_0_99_626 VGND VGND VPWR VPWR sky130_fd_sc_hd__decap_4
XFILLER_0_98_147 VGND VGND VPWR VPWR sky130_fd_sc_hd__fill_1
XFILLER_0_86_309 VGND VGND VPWR VPWR sky130_fd_sc_hd__fill_2
XFILLER_0_79_372 VPWR VGND VPWR VGND sky130_ef_sc_hd__decap_12
XFILLER_0_94_386 VGND VGND VPWR VPWR sky130_fd_sc_hd__decap_4
XFILLER_0_82_515 VGND VGND VPWR VPWR sky130_fd_sc_hd__decap_3
XFILLER_0_62_250 VGND VGND VPWR VPWR sky130_fd_sc_hd__fill_2
XFILLER_0_62_283 VGND VGND VPWR VPWR sky130_fd_sc_hd__fill_1
XFILLER_0_22_158 VPWR VGND VPWR VGND sky130_ef_sc_hd__decap_12
XFILLER_0_117_69 VPWR VGND VPWR VGND sky130_ef_sc_hd__decap_12
XFILLER_0_117_47 VGND VGND VPWR VPWR sky130_fd_sc_hd__decap_8
XFILLER_0_89_147 VGND VGND VPWR VPWR sky130_fd_sc_hd__fill_1
XFILLER_0_26_45 VGND VGND VPWR VPWR sky130_fd_sc_hd__fill_2
Xhold90 u_pe_array.act_from_left\[5\]\[6\] VGND VGND VPWR VPWR net164 sky130_fd_sc_hd__dlygate4sd3_1
XFILLER_0_97_180 VGND VGND VPWR VPWR sky130_fd_sc_hd__fill_1
X_3950_ u_pe_array.g_pe_row\[3\].g_pe_col\[2\].u_pe.act_val\[0\] _1167_ _0944_ _1168_
+ VGND VGND VPWR VPWR _0084_ sky130_fd_sc_hd__a22o_1
XFILLER_0_85_386 VGND VGND VPWR VPWR sky130_fd_sc_hd__decap_6
XFILLER_0_58_589 VGND VGND VPWR VPWR sky130_fd_sc_hd__decap_6
X_3881_ u_pe_array.g_pe_row\[3\].g_pe_col\[2\].u_pe.psum_out\[2\] _1108_ _1110_ _1123_
+ VGND VGND VPWR VPWR _1124_ sky130_fd_sc_hd__o211a_1
XFILLER_0_115_105 VGND VGND VPWR VPWR sky130_fd_sc_hd__decap_6
X_5620_ u_pe_array.g_pe_row\[1\].g_pe_col\[2\].u_pe.psum_out\[9\] _1597_ VGND VGND
+ VPWR VPWR _2463_ sky130_fd_sc_hd__or2_1
X_5551_ _2398_ _2399_ VGND VGND VPWR VPWR _2400_ sky130_fd_sc_hd__nor2_1
XFILLER_0_115_149 VPWR VGND VPWR VGND sky130_ef_sc_hd__decap_12
XFILLER_0_13_125 VGND VGND VPWR VPWR sky130_fd_sc_hd__decap_8
XFILLER_0_5_358 VGND VGND VPWR VPWR sky130_fd_sc_hd__fill_1
X_4502_ _1598_ VGND VGND VPWR VPWR _0206_ sky130_fd_sc_hd__clkbuf_1
X_7221_ clknet_leaf_17_clk net629 net943 VGND VGND VPWR VPWR u_pe_array.g_pe_row\[3\].g_pe_col\[1\].u_pe.act_val\[2\]
+ sky130_fd_sc_hd__dfrtp_2
X_5482_ u_pe_array.u_fifo2.buffer\[5\]\[1\] _2333_ _2334_ u_pe_array.u_fifo2.buffer\[6\]\[1\]
+ _2335_ VGND VGND VPWR VPWR _2346_ sky130_fd_sc_hd__a221o_1
XFILLER_0_111_333 VGND VGND VPWR VPWR sky130_fd_sc_hd__decap_3
X_4433_ _1536_ _1537_ VGND VGND VPWR VPWR _1538_ sky130_fd_sc_hd__or2_1
XFILLER_0_13_169 VGND VGND VPWR VPWR sky130_fd_sc_hd__decap_8
XFILLER_0_1_553 VGND VGND VPWR VPWR sky130_fd_sc_hd__decap_6
X_4364_ net836 _1301_ _1305_ _1482_ VGND VGND VPWR VPWR _0184_ sky130_fd_sc_hd__a22o_1
X_7152_ clknet_leaf_9_clk _0058_ net945 VGND VGND VPWR VPWR u_pe_array.act_from_right\[13\]\[0\]
+ sky130_fd_sc_hd__dfrtp_1
X_6103_ u_pe_array.g_pe_row\[0\].g_pe_col\[3\].u_pe.psum_out\[0\] u_pe_array.g_pe_row\[0\].g_pe_col\[3\].u_pe.act_val\[0\]
+ _2844_ VGND VGND VPWR VPWR _2845_ sky130_fd_sc_hd__mux2_1
XTAP_331 VGND VPWR sky130_fd_sc_hd__tapvpwrvgnd_1
XTAP_342 VGND VPWR sky130_fd_sc_hd__tapvpwrvgnd_1
XFILLER_0_6_77 VGND VGND VPWR VPWR sky130_fd_sc_hd__decap_6
XTAP_320 VGND VPWR sky130_fd_sc_hd__tapvpwrvgnd_1
XFILLER_0_1_597 VPWR VGND VPWR VGND sky130_ef_sc_hd__decap_12
X_7083_ net567 _3356_ _3536_ VGND VGND VPWR VPWR _3539_ sky130_fd_sc_hd__mux2_1
X_4295_ _1441_ VGND VGND VPWR VPWR _0156_ sky130_fd_sc_hd__clkbuf_1
XTAP_375 VGND VPWR sky130_fd_sc_hd__tapvpwrvgnd_1
XTAP_364 VGND VPWR sky130_fd_sc_hd__tapvpwrvgnd_1
XTAP_353 VGND VPWR sky130_fd_sc_hd__tapvpwrvgnd_1
X_6034_ u_pe_array.g_pe_row\[1\].g_pe_col\[0\].u_pe.act_val\[5\] u_pe_array.g_pe_row\[1\].g_pe_col\[0\].u_pe.w_out\[0\]
+ _2773_ VGND VGND VPWR VPWR _2785_ sky130_fd_sc_hd__and3_1
XTAP_397 VGND VPWR sky130_fd_sc_hd__tapvpwrvgnd_1
XTAP_386 VGND VPWR sky130_fd_sc_hd__tapvpwrvgnd_1
XFILLER_0_20_3 VPWR VGND VPWR VGND sky130_ef_sc_hd__decap_12
XTAP_1519 VGND VPWR sky130_fd_sc_hd__tapvpwrvgnd_1
XTAP_1508 VGND VPWR sky130_fd_sc_hd__tapvpwrvgnd_1
XPHY_26 VGND VGND VPWR VPWR sky130_fd_sc_hd__decap_3
XPHY_15 VGND VGND VPWR VPWR sky130_fd_sc_hd__decap_3
XPHY_37 VGND VGND VPWR VPWR sky130_fd_sc_hd__decap_3
X_6936_ _3451_ VGND VGND VPWR VPWR _0787_ sky130_fd_sc_hd__clkbuf_1
XPHY_48 VGND VGND VPWR VPWR sky130_fd_sc_hd__decap_3
XPHY_59 VGND VGND VPWR VPWR sky130_fd_sc_hd__decap_3
XFILLER_0_9_642 VPWR VGND VPWR VGND sky130_ef_sc_hd__decap_12
X_6867_ net580 _0926_ _3408_ VGND VGND VPWR VPWR _3413_ sky130_fd_sc_hd__mux2_1
XFILLER_0_107_617 VPWR VGND VPWR VGND sky130_ef_sc_hd__decap_12
X_5818_ u_pe_array.g_pe_row\[1\].g_pe_col\[1\].u_pe.psum_out\[11\] _2617_ _2608_ VGND
+ VGND VPWR VPWR _2618_ sky130_fd_sc_hd__mux2_1
XFILLER_0_91_345 VGND VGND VPWR VPWR sky130_fd_sc_hd__fill_2
XFILLER_0_91_334 VGND VGND VPWR VPWR sky130_fd_sc_hd__fill_2
XFILLER_0_64_548 VGND VGND VPWR VPWR sky130_fd_sc_hd__fill_1
XFILLER_0_8_141 VGND VGND VPWR VPWR sky130_fd_sc_hd__decap_6
X_6798_ _3368_ _3369_ VGND VGND VPWR VPWR _0731_ sky130_fd_sc_hd__nor2_1
X_5749_ u_pe_array.g_pe_row\[1\].g_pe_col\[1\].u_pe.act_val\[4\] _1728_ VGND VGND
+ VPWR VPWR _2555_ sky130_fd_sc_hd__and2b_1
XFILLER_0_9_697 VGND VGND VPWR VPWR sky130_fd_sc_hd__decap_8
XFILLER_0_17_453 VGND VGND VPWR VPWR sky130_fd_sc_hd__decap_6
XFILLER_0_32_456 VGND VGND VPWR VPWR sky130_fd_sc_hd__fill_2
X_7419_ clknet_leaf_29_clk _0325_ net71 VGND VGND VPWR VPWR u_pe_array.g_pe_row\[2\].g_pe_col\[1\].u_pe.psum_out\[10\]
+ sky130_fd_sc_hd__dfrtp_2
Xhold571 u_pe_array.g_pe_row\[0\].g_pe_col\[3\].u_pe.psum_out\[1\] VGND VGND VPWR
+ VPWR net645 sky130_fd_sc_hd__dlygate4sd3_1
Xhold560 u_pe_array.u_fifo1.buffer\[4\]\[3\] VGND VGND VPWR VPWR net634 sky130_fd_sc_hd__dlygate4sd3_1
Xhold593 u_pe_array.u_fifo2.buffer\[3\]\[0\] VGND VGND VPWR VPWR net667 sky130_fd_sc_hd__dlygate4sd3_1
Xhold582 u_pe_array.u_fifo1.buffer\[6\]\[5\] VGND VGND VPWR VPWR net656 sky130_fd_sc_hd__dlygate4sd3_1
XFILLER_0_86_128 VPWR VGND VPWR VGND sky130_ef_sc_hd__decap_12
XFILLER_0_95_673 VPWR VGND VPWR VGND sky130_ef_sc_hd__decap_12
XFILLER_0_103_27 VPWR VGND VPWR VGND sky130_ef_sc_hd__decap_12
XFILLER_0_82_356 VGND VGND VPWR VPWR sky130_fd_sc_hd__fill_2
XFILLER_0_88_29 VGND VGND VPWR VPWR sky130_fd_sc_hd__decap_6
XFILLER_0_11_629 VPWR VGND VPWR VGND sky130_ef_sc_hd__decap_12
XFILLER_0_50_253 VGND VGND VPWR VPWR sky130_fd_sc_hd__decap_3
XFILLER_0_50_264 VGND VGND VPWR VPWR sky130_fd_sc_hd__fill_2
XFILLER_0_10_139 VGND VGND VPWR VPWR sky130_fd_sc_hd__fill_1
XFILLER_0_37_22 VPWR VGND VPWR VGND sky130_ef_sc_hd__decap_12
X_4080_ u_pe_array.g_pe_row\[3\].g_pe_col\[2\].u_pe.psum_out\[11\] _0934_ VGND VGND
+ VPWR VPWR _1275_ sky130_fd_sc_hd__and2b_1
XFILLER_0_37_44 VGND VGND VPWR VPWR sky130_fd_sc_hd__fill_1
XFILLER_0_77_128 VGND VGND VPWR VPWR sky130_fd_sc_hd__decap_6
X_4982_ _1945_ _1946_ _1960_ _1961_ VGND VGND VPWR VPWR _1962_ sky130_fd_sc_hd__a31o_1
X_7770_ clknet_leaf_48_clk _0676_ net947 VGND VGND VPWR VPWR u_pe_array.g_pe_row\[0\].g_pe_col\[1\].u_pe.psum_out\[7\]
+ sky130_fd_sc_hd__dfrtp_4
X_6721_ u_pe_array.g_pe_row\[0\].g_pe_col\[0\].u_pe.psum_out\[7\] _2488_ VGND VGND
+ VPWR VPWR _3307_ sky130_fd_sc_hd__nand2_1
X_3933_ _1162_ VGND VGND VPWR VPWR _0073_ sky130_fd_sc_hd__clkbuf_1
X_6652_ _3244_ VGND VGND VPWR VPWR _3245_ sky130_fd_sc_hd__inv_2
X_3864_ u_pe_array.g_pe_row\[0\].g_pe_col\[0\].u_pe.psum_shift_en_d _0865_ VGND VGND
+ VPWR VPWR _1109_ sky130_fd_sc_hd__nand2_8
XFILLER_0_73_356 VPWR VGND VPWR VGND sky130_ef_sc_hd__decap_12
XFILLER_0_5_111 VGND VGND VPWR VPWR sky130_fd_sc_hd__fill_1
X_5603_ _2441_ _2447_ VGND VGND VPWR VPWR _2448_ sky130_fd_sc_hd__nand2_1
XFILLER_0_116_447 VGND VGND VPWR VPWR sky130_fd_sc_hd__decap_3
X_6583_ _3198_ _3201_ _3206_ VGND VGND VPWR VPWR _3208_ sky130_fd_sc_hd__or3_1
X_3795_ _1046_ _1048_ VGND VGND VPWR VPWR _1049_ sky130_fd_sc_hd__xnor2_1
XFILLER_0_14_412 VGND VGND VPWR VPWR sky130_fd_sc_hd__decap_8
XFILLER_0_26_261 VGND VGND VPWR VPWR sky130_fd_sc_hd__decap_4
XFILLER_0_6_689 VGND VGND VPWR VPWR sky130_fd_sc_hd__decap_8
X_5534_ u_pe_array.g_pe_row\[1\].g_pe_col\[2\].u_pe.act_val\[1\] _1595_ _2383_ _2384_
+ VGND VGND VPWR VPWR _2385_ sky130_fd_sc_hd__nand4_1
X_5465_ u_pe_array.u_fifo2.buffer\[7\]\[0\] _2327_ _2329_ u_pe_array.u_fifo2.buffer\[1\]\[0\]
+ VGND VGND VPWR VPWR _2330_ sky130_fd_sc_hd__a22o_1
X_7204_ clknet_leaf_14_clk _0110_ net942 VGND VGND VPWR VPWR u_pe_array.g_pe_row\[3\].g_pe_col\[0\].u_pe.w_out\[0\]
+ sky130_fd_sc_hd__dfrtp_4
XFILLER_0_68_3 VPWR VGND VPWR VGND sky130_ef_sc_hd__decap_12
X_4416_ _1520_ _1521_ VGND VGND VPWR VPWR _1523_ sky130_fd_sc_hd__and2_1
X_7135_ clknet_leaf_21_clk _0041_ net943 VGND VGND VPWR VPWR u_pe_array.g_pe_row\[3\].g_pe_col\[3\].u_pe.move_reg\[11\]
+ sky130_fd_sc_hd__dfrtp_1
X_5396_ u_pe_array.g_pe_row\[1\].g_pe_col\[2\].u_pe.psum_out\[3\] _1108_ _1110_ _2283_
+ VGND VGND VPWR VPWR _2284_ sky130_fd_sc_hd__o211a_1
X_4347_ net160 _1166_ _1453_ _1476_ VGND VGND VPWR VPWR _0173_ sky130_fd_sc_hd__a22o_1
X_4278_ _1428_ VGND VGND VPWR VPWR _0152_ sky130_fd_sc_hd__clkbuf_1
X_7066_ net589 _3347_ _3529_ VGND VGND VPWR VPWR _3530_ sky130_fd_sc_hd__mux2_1
XFILLER_0_94_83 VGND VGND VPWR VPWR sky130_fd_sc_hd__fill_1
X_6017_ _2768_ _2769_ VGND VGND VPWR VPWR _2770_ sky130_fd_sc_hd__or2_1
XFILLER_0_96_404 VPWR VGND VPWR VGND sky130_ef_sc_hd__decap_12
XTAP_1305 VGND VPWR sky130_fd_sc_hd__tapvpwrvgnd_1
XTAP_1338 VGND VPWR sky130_fd_sc_hd__tapvpwrvgnd_1
XTAP_1316 VGND VPWR sky130_fd_sc_hd__tapvpwrvgnd_1
XTAP_1327 VGND VPWR sky130_fd_sc_hd__tapvpwrvgnd_1
XFILLER_0_49_320 VGND VGND VPWR VPWR sky130_fd_sc_hd__decap_6
XTAP_1349 VGND VPWR sky130_fd_sc_hd__tapvpwrvgnd_1
XFILLER_0_77_673 VGND VGND VPWR VPWR sky130_fd_sc_hd__decap_8
X_6919_ _3442_ VGND VGND VPWR VPWR _0779_ sky130_fd_sc_hd__clkbuf_1
X_7899_ clknet_leaf_82_clk _0804_ VGND VGND VPWR VPWR u_pe_array.u_fifo1.buffer\[0\]\[1\]
+ sky130_fd_sc_hd__dfxtp_1
XFILLER_0_107_414 VGND VGND VPWR VPWR sky130_fd_sc_hd__decap_8
XFILLER_0_92_676 VPWR VGND VPWR VGND sky130_ef_sc_hd__decap_12
XFILLER_0_107_458 VGND VGND VPWR VPWR sky130_fd_sc_hd__fill_1
XFILLER_0_102_141 VGND VGND VPWR VPWR sky130_fd_sc_hd__decap_4
XFILLER_0_103_697 VGND VGND VPWR VPWR sky130_fd_sc_hd__decap_8
Xhold390 u_pe_array.g_pe_row\[3\].g_pe_col\[3\].u_pe.psum_out\[2\] VGND VGND VPWR
+ VPWR net464 sky130_fd_sc_hd__dlygate4sd3_1
XFILLER_0_99_242 VGND VGND VPWR VPWR sky130_fd_sc_hd__fill_1
XFILLER_0_114_15 VPWR VGND VPWR VGND sky130_ef_sc_hd__decap_12
XFILLER_0_67_150 VPWR VGND VPWR VGND sky130_ef_sc_hd__decap_12
XFILLER_0_68_695 VGND VGND VPWR VPWR sky130_fd_sc_hd__decap_4
XFILLER_0_23_57 VGND VGND VPWR VPWR sky130_fd_sc_hd__decap_4
XFILLER_0_99_39 VPWR VGND VPWR VGND sky130_ef_sc_hd__decap_12
XFILLER_0_3_615 VGND VGND VPWR VPWR sky130_fd_sc_hd__fill_1
X_3580_ _0884_ _0885_ VGND VGND VPWR VPWR _0886_ sky130_fd_sc_hd__nand2_1
XFILLER_0_51_551 VGND VGND VPWR VPWR sky130_fd_sc_hd__fill_1
X_5250_ _2158_ VGND VGND VPWR VPWR _0394_ sky130_fd_sc_hd__clkbuf_1
XFILLER_0_23_286 VGND VGND VPWR VPWR sky130_fd_sc_hd__fill_2
X_4201_ _1358_ _1360_ VGND VGND VPWR VPWR _1361_ sky130_fd_sc_hd__xor2_1
X_5181_ _1884_ _2116_ _2117_ _1803_ net755 VGND VGND VPWR VPWR _0366_ sky130_fd_sc_hd__a32o_1
X_4132_ u_pe_array.act_from_right\[13\]\[3\] net878 _0963_ VGND VGND VPWR VPWR _1307_
+ sky130_fd_sc_hd__mux2_1
X_4063_ u_pe_array.g_pe_row\[3\].g_pe_col\[2\].u_pe.psum_out\[9\] _0934_ VGND VGND
+ VPWR VPWR _1260_ sky130_fd_sc_hd__or2_1
Xwire68 _2326_ VGND VGND VPWR VPWR net68 sky130_fd_sc_hd__clkbuf_2
X_7822_ clknet_leaf_89_clk _0727_ VGND VGND VPWR VPWR u_pe_array.u_fifo1.buffer\[8\]\[4\]
+ sky130_fd_sc_hd__dfxtp_1
X_7753_ clknet_leaf_53_clk net302 net74 VGND VGND VPWR VPWR u_pe_array.g_pe_row\[0\].g_pe_col\[1\].u_pe.act_val\[3\]
+ sky130_fd_sc_hd__dfrtp_1
X_4965_ _1922_ _1923_ _1932_ _1934_ VGND VGND VPWR VPWR _1947_ sky130_fd_sc_hd__o22a_1
XFILLER_0_59_673 VGND VGND VPWR VPWR sky130_fd_sc_hd__decap_6
X_6704_ _3280_ _3281_ VGND VGND VPWR VPWR _3292_ sky130_fd_sc_hd__nor2_1
XFILLER_0_74_621 VGND VGND VPWR VPWR sky130_fd_sc_hd__decap_3
XFILLER_0_58_194 VGND VGND VPWR VPWR sky130_fd_sc_hd__fill_2
X_3916_ net937 _1150_ _1116_ VGND VGND VPWR VPWR _1151_ sky130_fd_sc_hd__mux2_1
XFILLER_0_116_211 VGND VGND VPWR VPWR sky130_fd_sc_hd__decap_4
X_4896_ _0977_ VGND VGND VPWR VPWR _1884_ sky130_fd_sc_hd__buf_6
XFILLER_0_80_85 VGND VGND VPWR VPWR sky130_fd_sc_hd__fill_1
X_7684_ clknet_leaf_59_clk _0590_ net74 VGND VGND VPWR VPWR u_pe_array.g_pe_row\[0\].g_pe_col\[3\].u_pe.psum_out\[3\]
+ sky130_fd_sc_hd__dfrtp_1
XFILLER_0_19_559 VGND VGND VPWR VPWR sky130_fd_sc_hd__fill_1
X_6635_ u_pe_array.g_pe_row\[0\].g_pe_col\[0\].u_pe.psum_out\[12\] u_pe_array.g_pe_row\[0\].g_pe_col\[0\].u_pe.move_reg\[12\]
+ _3102_ VGND VGND VPWR VPWR _3242_ sky130_fd_sc_hd__mux2_1
X_3847_ _1094_ _1095_ VGND VGND VPWR VPWR _1096_ sky130_fd_sc_hd__or2_1
XFILLER_0_74_698 VGND VGND VPWR VPWR sky130_fd_sc_hd__fill_2
XFILLER_0_73_164 VGND VGND VPWR VPWR sky130_fd_sc_hd__decap_4
XFILLER_0_116_277 VPWR VGND VPWR VGND sky130_ef_sc_hd__decap_12
X_6566_ _3175_ _3176_ _3190_ _3191_ VGND VGND VPWR VPWR _3192_ sky130_fd_sc_hd__a31o_1
XFILLER_0_89_50 VGND VGND VPWR VPWR sky130_fd_sc_hd__decap_6
X_3778_ _0977_ VGND VGND VPWR VPWR _1033_ sky130_fd_sc_hd__buf_8
XFILLER_0_61_337 VGND VGND VPWR VPWR sky130_fd_sc_hd__decap_4
XFILLER_0_14_220 VGND VGND VPWR VPWR sky130_fd_sc_hd__fill_1
XFILLER_0_14_253 VPWR VGND VPWR VGND sky130_ef_sc_hd__decap_12
X_5517_ u_pe_array.u_fifo2.buffer\[8\]\[5\] _2322_ _2372_ _2376_ _0857_ VGND VGND
+ VPWR VPWR _2377_ sky130_fd_sc_hd__a221o_1
X_6497_ u_pe_array.g_pe_row\[0\].g_pe_col\[1\].u_pe.act_val\[2\] u_pe_array.g_pe_row\[0\].g_pe_col\[1\].u_pe.w_out\[0\]
+ VGND VGND VPWR VPWR _3129_ sky130_fd_sc_hd__nand2_1
X_5448_ net150 _1166_ _2294_ _1476_ VGND VGND VPWR VPWR _0431_ sky130_fd_sc_hd__a22o_1
XFILLER_0_2_681 VPWR VGND VPWR VGND sky130_ef_sc_hd__decap_12
XFILLER_0_10_470 VGND VGND VPWR VPWR sky130_fd_sc_hd__decap_6
X_5379_ u_pe_array.g_pe_row\[1\].g_pe_col\[2\].u_pe.act_val\[0\] VGND VGND VPWR VPWR
+ _2270_ sky130_fd_sc_hd__inv_2
XFILLER_0_100_689 VGND VGND VPWR VPWR sky130_fd_sc_hd__decap_8
X_7118_ clknet_leaf_18_clk _0024_ net943 VGND VGND VPWR VPWR u_pe_array.act_from_down\[11\]\[7\]
+ sky130_fd_sc_hd__dfrtp_1
X_7049_ net617 _3362_ _3514_ VGND VGND VPWR VPWR _3520_ sky130_fd_sc_hd__mux2_1
XTAP_1113 VGND VPWR sky130_fd_sc_hd__tapvpwrvgnd_1
XTAP_1102 VGND VPWR sky130_fd_sc_hd__tapvpwrvgnd_1
XTAP_1146 VGND VPWR sky130_fd_sc_hd__tapvpwrvgnd_1
XTAP_1135 VGND VPWR sky130_fd_sc_hd__tapvpwrvgnd_1
XTAP_1124 VGND VPWR sky130_fd_sc_hd__tapvpwrvgnd_1
XFILLER_0_108_701 VGND VGND VPWR VPWR sky130_fd_sc_hd__decap_4
XTAP_1179 VGND VPWR sky130_fd_sc_hd__tapvpwrvgnd_1
XTAP_1157 VGND VPWR sky130_fd_sc_hd__tapvpwrvgnd_1
XTAP_1168 VGND VPWR sky130_fd_sc_hd__tapvpwrvgnd_1
XFILLER_0_65_654 VGND VGND VPWR VPWR sky130_fd_sc_hd__fill_2
XFILLER_0_37_367 VGND VGND VPWR VPWR sky130_fd_sc_hd__fill_2
XFILLER_0_92_484 VGND VGND VPWR VPWR sky130_fd_sc_hd__decap_6
XFILLER_0_65_698 VGND VGND VPWR VPWR sky130_fd_sc_hd__decap_6
XFILLER_0_18_570 VGND VGND VPWR VPWR sky130_fd_sc_hd__decap_4
XFILLER_0_107_277 VGND VGND VPWR VPWR sky130_fd_sc_hd__decap_3
XFILLER_0_33_540 VGND VGND VPWR VPWR sky130_fd_sc_hd__fill_1
XFILLER_0_60_392 VGND VGND VPWR VPWR sky130_fd_sc_hd__decap_8
XFILLER_0_0_629 VGND VGND VPWR VPWR sky130_fd_sc_hd__decap_8
XFILLER_0_20_223 VGND VGND VPWR VPWR sky130_fd_sc_hd__fill_2
XFILLER_0_20_267 VGND VGND VPWR VPWR sky130_fd_sc_hd__fill_2
XTAP_908 VGND VPWR sky130_fd_sc_hd__tapvpwrvgnd_1
XFILLER_0_20_278 VGND VGND VPWR VPWR sky130_fd_sc_hd__decap_8
XTAP_919 VGND VPWR sky130_fd_sc_hd__tapvpwrvgnd_1
XFILLER_0_109_15 VPWR VGND VPWR VGND sky130_ef_sc_hd__decap_12
XFILLER_0_34_45 VPWR VGND VPWR VGND sky130_ef_sc_hd__decap_12
XFILLER_0_47_109 VGND VGND VPWR VPWR sky130_fd_sc_hd__decap_3
XFILLER_0_118_509 VGND VGND VPWR VPWR sky130_fd_sc_hd__decap_4
XFILLER_0_28_301 VGND VGND VPWR VPWR sky130_fd_sc_hd__decap_6
XTAP_1691 VGND VPWR sky130_fd_sc_hd__tapvpwrvgnd_1
XTAP_1680 VGND VPWR sky130_fd_sc_hd__tapvpwrvgnd_1
XFILLER_0_56_643 VGND VGND VPWR VPWR sky130_fd_sc_hd__fill_1
X_4750_ u_pe_array.g_pe_row\[2\].g_pe_col\[2\].u_pe.psum_out\[3\] _1775_ VGND VGND
+ VPWR VPWR _1776_ sky130_fd_sc_hd__xor2_1
X_3701_ net12 u_pe_array.act_from_left\[15\]\[5\] _0963_ VGND VGND VPWR VPWR _0969_
+ sky130_fd_sc_hd__mux2_1
X_4681_ u_pe_array.g_pe_row\[2\].g_pe_col\[2\].u_pe.psum_out\[0\] u_pe_array.g_pe_row\[2\].g_pe_col\[2\].u_pe.act_val\[0\]
+ _1599_ VGND VGND VPWR VPWR _1736_ sky130_fd_sc_hd__mux2_1
XFILLER_0_55_197 VGND VGND VPWR VPWR sky130_fd_sc_hd__decap_8
X_6420_ _3083_ _3084_ VGND VGND VPWR VPWR _3085_ sky130_fd_sc_hd__and2_1
X_3632_ _0923_ VGND VGND VPWR VPWR _0011_ sky130_fd_sc_hd__clkbuf_1
XFILLER_0_113_225 VGND VGND VPWR VPWR sky130_fd_sc_hd__decap_4
XFILLER_0_71_679 VGND VGND VPWR VPWR sky130_fd_sc_hd__fill_1
X_6351_ _3021_ _2130_ u_pe_array.g_pe_row\[0\].g_pe_col\[2\].u_pe.psum_out\[4\] VGND
+ VGND VPWR VPWR _3022_ sky130_fd_sc_hd__a21oi_1
X_5302_ net569 _1904_ _2202_ _2203_ VGND VGND VPWR VPWR _0401_ sky130_fd_sc_hd__a22o_1
XFILLER_0_11_223 VGND VGND VPWR VPWR sky130_fd_sc_hd__fill_1
X_3563_ u_fsm.ch_cnt\[0\] u_fsm.ch_cnt\[1\] VGND VGND VPWR VPWR _0871_ sky130_fd_sc_hd__nand2_1
XFILLER_0_59_53 VGND VGND VPWR VPWR sky130_fd_sc_hd__decap_3
X_6282_ net493 _2006_ _2009_ _2978_ VGND VGND VPWR VPWR _0606_ sky130_fd_sc_hd__a22o_1
X_5233_ net3 net821 _0963_ VGND VGND VPWR VPWR _2150_ sky130_fd_sc_hd__mux2_1
X_5164_ _2093_ _2096_ _2101_ _1003_ VGND VGND VPWR VPWR _2103_ sky130_fd_sc_hd__a31o_1
X_4115_ net405 _1167_ _1169_ _1297_ VGND VGND VPWR VPWR _0120_ sky130_fd_sc_hd__a22o_1
X_5095_ _2037_ u_pe_array.g_pe_row\[2\].g_pe_col\[0\].u_pe.psum_out\[3\] _1286_ VGND
+ VGND VPWR VPWR _2039_ sky130_fd_sc_hd__and3_1
XFILLER_0_75_85 VGND VGND VPWR VPWR sky130_fd_sc_hd__decap_3
X_4046_ _1238_ _1244_ VGND VGND VPWR VPWR _1245_ sky130_fd_sc_hd__nand2_1
XPHY_207 VGND VGND VPWR VPWR sky130_fd_sc_hd__decap_3
X_7805_ clknet_leaf_56_clk _0710_ net74 VGND VGND VPWR VPWR u_pe_array.g_pe_row\[0\].g_pe_col\[0\].u_pe.psum_out\[0\]
+ sky130_fd_sc_hd__dfrtp_1
XPHY_229 VGND VGND VPWR VPWR sky130_fd_sc_hd__decap_3
XPHY_218 VGND VGND VPWR VPWR sky130_fd_sc_hd__decap_3
X_5997_ _2741_ _2747_ _2750_ VGND VGND VPWR VPWR _2751_ sky130_fd_sc_hd__a21o_1
X_7736_ clknet_leaf_53_clk _0642_ net74 VGND VGND VPWR VPWR u_pe_array.g_pe_row\[0\].g_pe_col\[0\].u_pe.w_out\[1\]
+ sky130_fd_sc_hd__dfrtp_1
X_4948_ _1929_ _1930_ VGND VGND VPWR VPWR _1931_ sky130_fd_sc_hd__xnor2_2
XFILLER_0_93_248 VGND VGND VPWR VPWR sky130_fd_sc_hd__decap_4
X_4879_ u_pe_array.g_pe_row\[2\].g_pe_col\[1\].u_pe.psum_out\[12\] u_pe_array.g_pe_row\[2\].g_pe_col\[1\].u_pe.move_reg\[12\]
+ _1867_ VGND VGND VPWR VPWR _1881_ sky130_fd_sc_hd__mux2_1
X_7667_ clknet_leaf_63_clk _0573_ net74 VGND VGND VPWR VPWR u_pe_array.act_from_right\[2\]\[12\]
+ sky130_fd_sc_hd__dfrtp_1
XFILLER_0_19_389 VGND VGND VPWR VPWR sky130_fd_sc_hd__decap_3
XFILLER_0_46_153 VGND VGND VPWR VPWR sky130_fd_sc_hd__fill_1
X_6618_ net418 _1731_ _1734_ _3233_ VGND VGND VPWR VPWR _0687_ sky130_fd_sc_hd__a22o_1
XFILLER_0_46_197 VGND VGND VPWR VPWR sky130_fd_sc_hd__decap_8
X_7598_ clknet_leaf_44_clk _0504_ net947 VGND VGND VPWR VPWR u_pe_array.g_pe_row\[1\].g_pe_col\[1\].u_pe.psum_out\[12\]
+ sky130_fd_sc_hd__dfrtp_1
X_6549_ _3152_ _3153_ _3162_ _3164_ VGND VGND VPWR VPWR _3177_ sky130_fd_sc_hd__o22a_1
XFILLER_0_104_269 VPWR VGND VPWR VGND sky130_ef_sc_hd__decap_12
XFILLER_0_15_584 VGND VGND VPWR VPWR sky130_fd_sc_hd__fill_1
XFILLER_0_30_598 VPWR VGND VPWR VGND sky130_ef_sc_hd__decap_12
XFILLER_0_100_497 VGND VGND VPWR VPWR sky130_fd_sc_hd__decap_3
XFILLER_0_69_223 VGND VGND VPWR VPWR sky130_fd_sc_hd__fill_1
XFILLER_0_29_109 VGND VGND VPWR VPWR sky130_fd_sc_hd__decap_3
XFILLER_0_57_429 VGND VGND VPWR VPWR sky130_fd_sc_hd__decap_6
XFILLER_0_108_531 VGND VGND VPWR VPWR sky130_fd_sc_hd__fill_1
XFILLER_0_111_27 VPWR VGND VPWR VGND sky130_ef_sc_hd__decap_12
XFILLER_0_80_432 VGND VGND VPWR VPWR sky130_fd_sc_hd__decap_8
XFILLER_0_80_421 VGND VGND VPWR VPWR sky130_fd_sc_hd__decap_6
XFILLER_0_4_209 VPWR VGND VPWR VGND sky130_ef_sc_hd__decap_12
XFILLER_0_25_337 VGND VGND VPWR VPWR sky130_fd_sc_hd__fill_2
XFILLER_0_25_348 VGND VGND VPWR VPWR sky130_fd_sc_hd__fill_1
XFILLER_0_110_239 VPWR VGND VPWR VGND sky130_ef_sc_hd__decap_12
XFILLER_0_110_217 VGND VGND VPWR VPWR sky130_fd_sc_hd__decap_6
XTAP_705 VGND VPWR sky130_fd_sc_hd__tapvpwrvgnd_1
XTAP_716 VGND VPWR sky130_fd_sc_hd__tapvpwrvgnd_1
XTAP_727 VGND VPWR sky130_fd_sc_hd__tapvpwrvgnd_1
XTAP_738 VGND VPWR sky130_fd_sc_hd__tapvpwrvgnd_1
XTAP_749 VGND VPWR sky130_fd_sc_hd__tapvpwrvgnd_1
X_5920_ u_pe_array.u_fifo1.buffer\[5\]\[0\] _2687_ _2688_ u_pe_array.u_fifo1.buffer\[6\]\[0\]
+ _2689_ VGND VGND VPWR VPWR _2690_ sky130_fd_sc_hd__a221o_1
XFILLER_0_61_43 VPWR VGND VPWR VGND sky130_ef_sc_hd__decap_12
X_5851_ net863 _2642_ _2273_ VGND VGND VPWR VPWR _2643_ sky130_fd_sc_hd__mux2_1
XFILLER_0_0_57 VPWR VGND VPWR VGND sky130_ef_sc_hd__decap_12
XFILLER_0_0_46 VGND VGND VPWR VPWR sky130_fd_sc_hd__decap_8
XFILLER_0_118_317 VPWR VGND VPWR VGND sky130_ef_sc_hd__decap_12
X_5782_ _2233_ _2584_ _2585_ _2173_ net814 VGND VGND VPWR VPWR _0499_ sky130_fd_sc_hd__a32o_1
X_4802_ _1819_ _1823_ VGND VGND VPWR VPWR _1824_ sky130_fd_sc_hd__or2_1
XFILLER_0_28_120 VGND VGND VPWR VPWR sky130_fd_sc_hd__decap_6
XFILLER_0_90_229 VGND VGND VPWR VPWR sky130_fd_sc_hd__decap_4
X_7521_ clknet_leaf_39_clk _0427_ net946 VGND VGND VPWR VPWR u_pe_array.act_from_left\[7\]\[2\]
+ sky130_fd_sc_hd__dfrtp_1
X_4733_ _1752_ _1756_ VGND VGND VPWR VPWR _1760_ sky130_fd_sc_hd__nand2_1
X_7452_ clknet_leaf_33_clk _0358_ net951 VGND VGND VPWR VPWR u_pe_array.g_pe_row\[2\].g_pe_col\[0\].u_pe.psum_out\[2\]
+ sky130_fd_sc_hd__dfrtp_1
XFILLER_0_83_281 VGND VGND VPWR VPWR sky130_fd_sc_hd__fill_1
XFILLER_0_9_55 VGND VGND VPWR VPWR sky130_fd_sc_hd__fill_1
X_4664_ u_pe_array.g_pe_row\[2\].g_pe_col\[3\].u_pe.psum_out\[9\] u_pe_array.g_pe_row\[2\].g_pe_col\[3\].u_pe.psum_out\[10\]
+ _1427_ VGND VGND VPWR VPWR _1722_ sky130_fd_sc_hd__o21a_1
X_6403_ _3068_ _3069_ VGND VGND VPWR VPWR _3070_ sky130_fd_sc_hd__nand2_1
X_7383_ clknet_leaf_22_clk _0289_ net942 VGND VGND VPWR VPWR u_pe_array.act_from_right\[8\]\[0\]
+ sky130_fd_sc_hd__dfrtp_1
XFILLER_0_71_487 VPWR VGND VPWR VGND sky130_ef_sc_hd__decap_12
X_3615_ net197 _0909_ _0905_ VGND VGND VPWR VPWR _0910_ sky130_fd_sc_hd__o21bai_1
X_4595_ u_pe_array.g_pe_row\[2\].g_pe_col\[3\].u_pe.act_val\[4\] _1424_ _1651_ VGND
+ VGND VPWR VPWR _1660_ sky130_fd_sc_hd__and3_1
X_3546_ u_fsm.state\[0\] _0853_ VGND VGND VPWR VPWR _0854_ sky130_fd_sc_hd__nand2_8
X_6334_ u_pe_array.g_pe_row\[0\].g_pe_col\[2\].u_pe.act_val\[2\] _2128_ _2998_ VGND
+ VGND VPWR VPWR _3006_ sky130_fd_sc_hd__and3_1
X_6265_ _2954_ _2959_ _2965_ _2968_ _2964_ VGND VGND VPWR VPWR _2969_ sky130_fd_sc_hd__a32o_1
XFILLER_0_12_587 VGND VGND VPWR VPWR sky130_fd_sc_hd__fill_1
X_5216_ u_pe_array.g_pe_row\[1\].g_pe_col\[3\].u_pe.psum_out\[7\] u_pe_array.g_pe_row\[1\].g_pe_col\[3\].u_pe.move_reg\[7\]
+ _2133_ VGND VGND VPWR VPWR _2141_ sky130_fd_sc_hd__mux2_1
X_6196_ u_pe_array.g_pe_row\[0\].g_pe_col\[3\].u_pe.act_val\[4\] u_pe_array.g_pe_row\[0\].g_pe_col\[3\].u_pe.w_out\[0\]
+ _2893_ VGND VGND VPWR VPWR _2907_ sky130_fd_sc_hd__and3_1
X_5147_ _2085_ _2086_ VGND VGND VPWR VPWR _2087_ sky130_fd_sc_hd__and2_1
X_5078_ u_pe_array.g_pe_row\[2\].g_pe_col\[0\].u_pe.act_val\[1\] _1284_ _2021_ _2022_
+ VGND VGND VPWR VPWR _2024_ sky130_fd_sc_hd__a22o_1
X_4029_ _1133_ _0934_ u_pe_array.g_pe_row\[3\].g_pe_col\[2\].u_pe.psum_out\[6\] VGND
+ VGND VPWR VPWR _1229_ sky130_fd_sc_hd__a21o_1
XFILLER_0_94_502 VGND VGND VPWR VPWR sky130_fd_sc_hd__decap_6
X_7719_ clknet_leaf_62_clk net408 net74 VGND VGND VPWR VPWR u_pe_array.g_pe_row\[0\].g_pe_col\[2\].u_pe.move_reg\[10\]
+ sky130_fd_sc_hd__dfrtp_1
XFILLER_0_35_602 VGND VGND VPWR VPWR sky130_fd_sc_hd__decap_3
XFILLER_0_62_432 VPWR VGND VPWR VGND sky130_ef_sc_hd__decap_12
XFILLER_0_62_421 VGND VGND VPWR VPWR sky130_fd_sc_hd__fill_2
XFILLER_0_62_465 VGND VGND VPWR VPWR sky130_fd_sc_hd__decap_8
XFILLER_0_22_307 VGND VGND VPWR VPWR sky130_fd_sc_hd__fill_1
XFILLER_0_50_649 VGND VGND VPWR VPWR sky130_fd_sc_hd__fill_1
XFILLER_0_106_27 VGND VGND VPWR VPWR sky130_fd_sc_hd__fill_1
XFILLER_0_85_579 VPWR VGND VPWR VGND sky130_ef_sc_hd__decap_12
XFILLER_0_85_568 VGND VGND VPWR VPWR sky130_fd_sc_hd__decap_8
XFILLER_0_65_281 VGND VGND VPWR VPWR sky130_fd_sc_hd__fill_1
XFILLER_0_31_57 VGND VGND VPWR VPWR sky130_fd_sc_hd__decap_4
XFILLER_0_38_495 VGND VGND VPWR VPWR sky130_fd_sc_hd__decap_8
XFILLER_0_80_251 VGND VGND VPWR VPWR sky130_fd_sc_hd__fill_1
XFILLER_0_13_307 VGND VGND VPWR VPWR sky130_fd_sc_hd__fill_1
XFILLER_0_25_167 VGND VGND VPWR VPWR sky130_fd_sc_hd__fill_1
Xhold208 _0668_ VGND VGND VPWR VPWR net282 sky130_fd_sc_hd__dlygate4sd3_1
XFILLER_0_41_627 VGND VGND VPWR VPWR sky130_fd_sc_hd__fill_1
Xhold219 u_pe_array.g_pe_row\[2\].g_pe_col\[1\].u_pe.move_reg\[11\] VGND VGND VPWR
+ VPWR net293 sky130_fd_sc_hd__dlygate4sd3_1
X_4380_ _1488_ _1489_ VGND VGND VPWR VPWR _1490_ sky130_fd_sc_hd__xor2_1
XFILLER_0_0_223 VGND VGND VPWR VPWR sky130_fd_sc_hd__fill_1
XTAP_502 VGND VPWR sky130_fd_sc_hd__tapvpwrvgnd_1
XTAP_513 VGND VPWR sky130_fd_sc_hd__tapvpwrvgnd_1
XTAP_524 VGND VPWR sky130_fd_sc_hd__tapvpwrvgnd_1
XTAP_535 VGND VPWR sky130_fd_sc_hd__tapvpwrvgnd_1
XTAP_546 VGND VPWR sky130_fd_sc_hd__tapvpwrvgnd_1
XTAP_557 VGND VPWR sky130_fd_sc_hd__tapvpwrvgnd_1
X_6050_ _2798_ _2799_ VGND VGND VPWR VPWR _2800_ sky130_fd_sc_hd__and2_1
X_5001_ u_pe_array.g_pe_row\[2\].g_pe_col\[1\].u_pe.psum_out\[7\] u_pe_array.g_pe_row\[2\].g_pe_col\[1\].u_pe.psum_out\[8\]
+ _1105_ VGND VGND VPWR VPWR _1979_ sky130_fd_sc_hd__o21a_1
XTAP_568 VGND VPWR sky130_fd_sc_hd__tapvpwrvgnd_1
XTAP_579 VGND VPWR sky130_fd_sc_hd__tapvpwrvgnd_1
XFILLER_0_88_362 VGND VGND VPWR VPWR sky130_fd_sc_hd__fill_2
X_6952_ _3460_ _3461_ VGND VGND VPWR VPWR _0793_ sky130_fd_sc_hd__nor2_1
XFILLER_0_88_373 VGND VGND VPWR VPWR sky130_fd_sc_hd__fill_2
X_6883_ _3421_ VGND VGND VPWR VPWR _0764_ sky130_fd_sc_hd__clkbuf_1
X_5903_ net130 _1159_ _2664_ _0983_ VGND VGND VPWR VPWR _0531_ sky130_fd_sc_hd__a22o_1
XFILLER_0_8_301 VGND VGND VPWR VPWR sky130_fd_sc_hd__decap_6
X_5834_ net36 _2629_ _2273_ VGND VGND VPWR VPWR _2630_ sky130_fd_sc_hd__mux2_1
XFILLER_0_118_125 VPWR VGND VPWR VGND sky130_ef_sc_hd__decap_12
XFILLER_0_118_169 VPWR VGND VPWR VGND sky130_ef_sc_hd__decap_12
X_5765_ _2567_ _2569_ VGND VGND VPWR VPWR _2570_ sky130_fd_sc_hd__xnor2_2
XFILLER_0_106_309 VGND VGND VPWR VPWR sky130_fd_sc_hd__decap_6
XFILLER_0_56_292 VGND VGND VPWR VPWR sky130_fd_sc_hd__decap_6
XFILLER_0_29_495 VGND VGND VPWR VPWR sky130_fd_sc_hd__fill_1
X_7504_ clknet_leaf_26_clk _0410_ net943 VGND VGND VPWR VPWR u_pe_array.g_pe_row\[1\].g_pe_col\[1\].u_pe.w_out\[0\]
+ sky130_fd_sc_hd__dfrtp_4
XFILLER_0_98_3 VPWR VGND VPWR VGND sky130_ef_sc_hd__decap_12
X_5696_ net316 _2016_ _1883_ u_pe_array.g_pe_row\[1\].g_pe_col\[1\].u_pe.move_reg\[9\]
+ VGND VGND VPWR VPWR _0488_ sky130_fd_sc_hd__a22o_1
X_4716_ net346 _1750_ _1483_ net375 VGND VGND VPWR VPWR _0268_ sky130_fd_sc_hd__a22o_1
X_7435_ clknet_leaf_38_clk net448 net951 VGND VGND VPWR VPWR u_pe_array.act_from_up\[12\]\[11\]
+ sky130_fd_sc_hd__dfrtp_1
XFILLER_0_71_262 VGND VGND VPWR VPWR sky130_fd_sc_hd__decap_8
X_4647_ _1487_ _1706_ _1707_ _1356_ net782 VGND VGND VPWR VPWR _0242_ sky130_fd_sc_hd__a32o_1
XFILLER_0_114_386 VGND VGND VPWR VPWR sky130_fd_sc_hd__fill_1
XFILLER_0_102_526 VGND VGND VPWR VPWR sky130_fd_sc_hd__decap_6
Xhold720 u_pe_array.u_fifo1.buffer\[8\]\[3\] VGND VGND VPWR VPWR net794 sky130_fd_sc_hd__dlygate4sd3_1
X_7366_ clknet_leaf_6_clk net315 net945 VGND VGND VPWR VPWR u_pe_array.g_pe_row\[2\].g_pe_col\[2\].u_pe.move_reg\[11\]
+ sky130_fd_sc_hd__dfrtp_1
Xhold742 net59 VGND VGND VPWR VPWR net816 sky130_fd_sc_hd__dlygate4sd3_1
Xhold764 u_pe_array.g_pe_row\[3\].g_pe_col\[0\].u_pe.psum_out\[2\] VGND VGND VPWR
+ VPWR net838 sky130_fd_sc_hd__dlygate4sd3_1
X_4578_ _1640_ _1642_ _1644_ VGND VGND VPWR VPWR _1645_ sky130_fd_sc_hd__o21ai_1
X_6317_ u_pe_array.g_pe_row\[0\].g_pe_col\[2\].u_pe.act_val\[0\] u_pe_array.g_pe_row\[0\].g_pe_col\[2\].u_pe.psum_out\[1\]
+ _2130_ VGND VGND VPWR VPWR _2991_ sky130_fd_sc_hd__and3_1
Xhold753 u_pe_array.act_from_left\[7\]\[3\] VGND VGND VPWR VPWR net827 sky130_fd_sc_hd__dlygate4sd3_1
Xhold731 u_pe_array.g_pe_row\[1\].g_pe_col\[2\].u_pe.psum_out\[11\] VGND VGND VPWR
+ VPWR net805 sky130_fd_sc_hd__dlygate4sd3_1
Xhold775 u_pe_array.g_pe_row\[1\].g_pe_col\[3\].u_pe.act_val\[1\] VGND VGND VPWR VPWR
+ net849 sky130_fd_sc_hd__dlygate4sd3_1
X_7297_ clknet_leaf_95_clk _0203_ net951 VGND VGND VPWR VPWR u_pe_array.g_pe_row\[3\].g_pe_col\[0\].u_pe.psum_out\[11\]
+ sky130_fd_sc_hd__dfrtp_1
Xhold797 u_pe_array.g_pe_row\[1\].g_pe_col\[0\].u_pe.psum_out\[4\] VGND VGND VPWR
+ VPWR net871 sky130_fd_sc_hd__dlygate4sd3_1
Xhold786 u_pe_array.g_pe_row\[1\].g_pe_col\[2\].u_pe.psum_out\[8\] VGND VGND VPWR
+ VPWR net860 sky130_fd_sc_hd__dlygate4sd3_1
X_6248_ _2947_ _2948_ _2953_ _2950_ _2945_ VGND VGND VPWR VPWR _2954_ sky130_fd_sc_hd__a32o_1
X_6179_ net446 _2586_ _2891_ _0978_ VGND VGND VPWR VPWR _0590_ sky130_fd_sc_hd__a22o_1
XFILLER_0_79_384 VGND VGND VPWR VPWR sky130_fd_sc_hd__decap_8
XFILLER_0_67_513 VGND VGND VPWR VPWR sky130_fd_sc_hd__decap_6
XFILLER_0_94_321 VGND VGND VPWR VPWR sky130_fd_sc_hd__decap_6
XFILLER_0_109_147 VGND VGND VPWR VPWR sky130_fd_sc_hd__fill_1
XFILLER_0_35_421 VGND VGND VPWR VPWR sky130_fd_sc_hd__fill_1
XFILLER_0_47_281 VPWR VGND VPWR VGND sky130_ef_sc_hd__decap_12
XFILLER_0_62_262 VGND VGND VPWR VPWR sky130_fd_sc_hd__fill_1
Xhold80 u_pe_array.act_from_down\[3\]\[0\] VGND VGND VPWR VPWR net154 sky130_fd_sc_hd__clkdlybuf4s25_1
Xhold91 u_pe_array.act_from_right\[13\]\[10\] VGND VGND VPWR VPWR net165 sky130_fd_sc_hd__dlygate4sd3_1
XFILLER_0_85_310 VGND VGND VPWR VPWR sky130_fd_sc_hd__decap_3
XFILLER_0_85_321 VGND VGND VPWR VPWR sky130_fd_sc_hd__decap_4
XFILLER_0_73_516 VGND VGND VPWR VPWR sky130_fd_sc_hd__decap_8
XFILLER_0_73_505 VGND VGND VPWR VPWR sky130_fd_sc_hd__decap_3
X_3880_ _1122_ _1112_ VGND VGND VPWR VPWR _1123_ sky130_fd_sc_hd__nand2_1
Xclkbuf_leaf_70_clk clknet_3_4__leaf_clk VGND VGND VPWR VPWR clknet_leaf_70_clk sky130_fd_sc_hd__clkbuf_16
X_5550_ _2278_ u_pe_array.g_pe_row\[1\].g_pe_col\[2\].u_pe.psum_out\[3\] _1597_ VGND
+ VGND VPWR VPWR _2399_ sky130_fd_sc_hd__and3_1
XFILLER_0_53_251 VGND VGND VPWR VPWR sky130_fd_sc_hd__fill_1
XFILLER_0_108_180 VPWR VGND VPWR VGND sky130_ef_sc_hd__decap_12
XFILLER_0_81_593 VGND VGND VPWR VPWR sky130_fd_sc_hd__fill_2
X_5481_ u_pe_array.u_fifo2.buffer\[7\]\[1\] _2327_ _2329_ u_pe_array.u_fifo2.buffer\[1\]\[1\]
+ VGND VGND VPWR VPWR _2345_ sky130_fd_sc_hd__a22o_1
X_4501_ _1597_ _0933_ _0931_ VGND VGND VPWR VPWR _1598_ sky130_fd_sc_hd__mux2_1
X_7220_ clknet_leaf_16_clk _0126_ net943 VGND VGND VPWR VPWR u_pe_array.g_pe_row\[3\].g_pe_col\[1\].u_pe.act_val\[1\]
+ sky130_fd_sc_hd__dfrtp_2
X_4432_ _1445_ _1287_ u_pe_array.g_pe_row\[3\].g_pe_col\[0\].u_pe.psum_out\[6\] VGND
+ VGND VPWR VPWR _1537_ sky130_fd_sc_hd__a21oi_1
X_7151_ clknet_leaf_23_clk _0057_ net943 VGND VGND VPWR VPWR u_pe_array.g_pe_row\[3\].g_pe_col\[1\].u_pe.w_out\[1\]
+ sky130_fd_sc_hd__dfrtp_1
XFILLER_0_67_20 VGND VGND VPWR VPWR sky130_fd_sc_hd__decap_4
X_4363_ net20 net773 _0857_ VGND VGND VPWR VPWR _1482_ sky130_fd_sc_hd__mux2_1
XFILLER_0_21_181 VPWR VGND VPWR VGND sky130_ef_sc_hd__decap_12
XFILLER_0_67_75 VGND VGND VPWR VPWR sky130_fd_sc_hd__decap_8
XTAP_332 VGND VPWR sky130_fd_sc_hd__tapvpwrvgnd_1
XTAP_321 VGND VPWR sky130_fd_sc_hd__tapvpwrvgnd_1
XTAP_310 VGND VPWR sky130_fd_sc_hd__tapvpwrvgnd_1
X_7082_ _3538_ VGND VGND VPWR VPWR _0846_ sky130_fd_sc_hd__clkbuf_1
X_4294_ net815 _1440_ _1116_ VGND VGND VPWR VPWR _1441_ sky130_fd_sc_hd__mux2_1
X_6102_ _0946_ VGND VGND VPWR VPWR _2844_ sky130_fd_sc_hd__clkbuf_16
XTAP_376 VGND VPWR sky130_fd_sc_hd__tapvpwrvgnd_1
XTAP_365 VGND VPWR sky130_fd_sc_hd__tapvpwrvgnd_1
XTAP_354 VGND VPWR sky130_fd_sc_hd__tapvpwrvgnd_1
XTAP_343 VGND VPWR sky130_fd_sc_hd__tapvpwrvgnd_1
X_6033_ _2782_ _2783_ VGND VGND VPWR VPWR _2784_ sky130_fd_sc_hd__or2_1
XTAP_398 VGND VPWR sky130_fd_sc_hd__tapvpwrvgnd_1
XTAP_387 VGND VPWR sky130_fd_sc_hd__tapvpwrvgnd_1
XFILLER_0_89_660 VPWR VGND VPWR VGND sky130_ef_sc_hd__decap_12
XFILLER_0_83_96 VGND VGND VPWR VPWR sky130_fd_sc_hd__fill_1
XFILLER_0_13_3 VPWR VGND VPWR VGND sky130_ef_sc_hd__decap_12
XFILLER_0_107_81 VPWR VGND VPWR VGND sky130_ef_sc_hd__decap_12
XTAP_1509 VGND VPWR sky130_fd_sc_hd__tapvpwrvgnd_1
XPHY_16 VGND VGND VPWR VPWR sky130_fd_sc_hd__decap_3
XPHY_27 VGND VGND VPWR VPWR sky130_fd_sc_hd__decap_3
XPHY_38 VGND VGND VPWR VPWR sky130_fd_sc_hd__decap_3
X_6935_ _0926_ net674 _3446_ VGND VGND VPWR VPWR _3451_ sky130_fd_sc_hd__mux2_1
XPHY_49 VGND VGND VPWR VPWR sky130_fd_sc_hd__decap_3
XFILLER_0_91_302 VGND VGND VPWR VPWR sky130_fd_sc_hd__decap_4
XFILLER_0_76_365 VGND VGND VPWR VPWR sky130_fd_sc_hd__decap_3
Xclkbuf_leaf_61_clk clknet_3_7__leaf_clk VGND VGND VPWR VPWR clknet_leaf_61_clk sky130_fd_sc_hd__clkbuf_16
X_6866_ _3412_ VGND VGND VPWR VPWR _0756_ sky130_fd_sc_hd__clkbuf_1
XFILLER_0_9_621 VGND VGND VPWR VPWR sky130_fd_sc_hd__fill_1
XFILLER_0_107_607 VGND VGND VPWR VPWR sky130_fd_sc_hd__decap_8
X_5817_ _2615_ _2616_ VGND VGND VPWR VPWR _2617_ sky130_fd_sc_hd__or2_1
X_6797_ net688 _3366_ VGND VGND VPWR VPWR _3369_ sky130_fd_sc_hd__nor2_1
XFILLER_0_9_654 VPWR VGND VPWR VGND sky130_ef_sc_hd__decap_12
XFILLER_0_17_421 VGND VGND VPWR VPWR sky130_fd_sc_hd__decap_4
XFILLER_0_29_281 VGND VGND VPWR VPWR sky130_fd_sc_hd__decap_6
X_5748_ _2553_ _2554_ net424 _1007_ VGND VGND VPWR VPWR _0496_ sky130_fd_sc_hd__a2bb2o_1
XFILLER_0_107_629 VPWR VGND VPWR VGND sky130_ef_sc_hd__decap_12
XFILLER_0_91_368 VGND VGND VPWR VPWR sky130_fd_sc_hd__decap_8
XFILLER_0_8_197 VGND VGND VPWR VPWR sky130_fd_sc_hd__decap_3
XFILLER_0_44_240 VGND VGND VPWR VPWR sky130_fd_sc_hd__decap_4
XFILLER_0_115_673 VPWR VGND VPWR VGND sky130_ef_sc_hd__decap_12
X_5679_ u_pe_array.g_pe_row\[1\].g_pe_col\[1\].u_pe.psum_out\[12\] u_pe_array.g_pe_row\[1\].g_pe_col\[1\].u_pe.move_reg\[12\]
+ _2133_ VGND VGND VPWR VPWR _2504_ sky130_fd_sc_hd__mux2_1
XFILLER_0_32_435 VGND VGND VPWR VPWR sky130_fd_sc_hd__fill_1
X_7418_ clknet_leaf_29_clk _0324_ net71 VGND VGND VPWR VPWR u_pe_array.g_pe_row\[2\].g_pe_col\[1\].u_pe.psum_out\[9\]
+ sky130_fd_sc_hd__dfrtp_2
XFILLER_0_102_323 VPWR VGND VPWR VGND sky130_ef_sc_hd__decap_12
XFILLER_0_102_356 VGND VGND VPWR VPWR sky130_fd_sc_hd__fill_1
Xhold572 u_pe_array.g_pe_row\[3\].g_pe_col\[3\].u_pe.psum_out\[11\] VGND VGND VPWR
+ VPWR net646 sky130_fd_sc_hd__dlygate4sd3_1
Xhold561 u_pe_array.g_pe_row\[1\].g_pe_col\[0\].u_pe.psum_out\[12\] VGND VGND VPWR
+ VPWR net635 sky130_fd_sc_hd__dlygate4sd3_1
Xhold550 u_pe_array.u_fifo2.buffer\[3\]\[4\] VGND VGND VPWR VPWR net624 sky130_fd_sc_hd__dlygate4sd3_1
X_7349_ clknet_leaf_0_clk _0255_ net945 VGND VGND VPWR VPWR u_pe_array.act_from_up\[14\]\[7\]
+ sky130_fd_sc_hd__dfrtp_1
Xhold594 u_pe_array.g_pe_row\[1\].g_pe_col\[1\].u_pe.psum_out\[11\] VGND VGND VPWR
+ VPWR net668 sky130_fd_sc_hd__dlygate4sd3_1
XFILLER_0_4_6 VPWR VGND VPWR VGND sky130_ef_sc_hd__decap_12
Xhold583 u_pe_array.u_fifo1.buffer\[1\]\[1\] VGND VGND VPWR VPWR net657 sky130_fd_sc_hd__dlygate4sd3_1
Xclkbuf_leaf_52_clk clknet_3_7__leaf_clk VGND VGND VPWR VPWR clknet_leaf_52_clk sky130_fd_sc_hd__clkbuf_16
XFILLER_0_95_685 VPWR VGND VPWR VGND sky130_ef_sc_hd__decap_12
XFILLER_0_103_39 VPWR VGND VPWR VGND sky130_ef_sc_hd__decap_12
XFILLER_0_55_538 VGND VGND VPWR VPWR sky130_fd_sc_hd__fill_2
XFILLER_0_12_26 VGND VGND VPWR VPWR sky130_fd_sc_hd__fill_2
XFILLER_0_51_700 VGND VGND VPWR VPWR sky130_fd_sc_hd__decap_4
XFILLER_0_112_109 VPWR VGND VPWR VGND sky130_ef_sc_hd__decap_12
XFILLER_0_23_479 VGND VGND VPWR VPWR sky130_fd_sc_hd__fill_1
XFILLER_0_31_490 VGND VGND VPWR VPWR sky130_fd_sc_hd__fill_2
XFILLER_0_37_34 VGND VGND VPWR VPWR sky130_fd_sc_hd__decap_4
X_4981_ _1948_ _1960_ VGND VGND VPWR VPWR _1961_ sky130_fd_sc_hd__and2_1
XFILLER_0_98_490 VGND VGND VPWR VPWR sky130_fd_sc_hd__decap_3
XFILLER_0_86_630 VPWR VGND VPWR VGND sky130_ef_sc_hd__decap_12
X_6720_ _3301_ _3303_ _3299_ VGND VGND VPWR VPWR _3306_ sky130_fd_sc_hd__o21bai_1
Xclkbuf_leaf_43_clk clknet_3_6__leaf_clk VGND VGND VPWR VPWR clknet_leaf_43_clk sky130_fd_sc_hd__clkbuf_16
XFILLER_0_58_365 VGND VGND VPWR VPWR sky130_fd_sc_hd__fill_2
X_3932_ _1124_ net853 _1159_ VGND VGND VPWR VPWR _1162_ sky130_fd_sc_hd__mux2_1
X_6651_ u_pe_array.g_pe_row\[0\].g_pe_col\[0\].u_pe.psum_out\[0\] u_pe_array.g_pe_row\[0\].g_pe_col\[0\].u_pe.act_val\[0\]
+ _2486_ VGND VGND VPWR VPWR _3244_ sky130_fd_sc_hd__and3_1
XFILLER_0_46_549 VPWR VGND VPWR VGND sky130_ef_sc_hd__decap_12
X_3863_ _0946_ VGND VGND VPWR VPWR _1108_ sky130_fd_sc_hd__buf_12
X_6582_ _3198_ _3201_ _3206_ VGND VGND VPWR VPWR _3207_ sky130_fd_sc_hd__o21ai_1
XFILLER_0_73_368 VPWR VGND VPWR VGND sky130_ef_sc_hd__decap_12
X_5602_ _2442_ _2446_ _2431_ VGND VGND VPWR VPWR _2447_ sky130_fd_sc_hd__mux2_1
X_3794_ u_pe_array.g_pe_row\[3\].g_pe_col\[3\].u_pe.psum_out\[5\] _1036_ _1047_ VGND
+ VGND VPWR VPWR _1048_ sky130_fd_sc_hd__a21oi_1
X_5533_ _2380_ _2381_ _2382_ VGND VGND VPWR VPWR _2384_ sky130_fd_sc_hd__or3_1
XFILLER_0_5_167 VGND VGND VPWR VPWR sky130_fd_sc_hd__fill_1
X_5464_ u_pe_array.u_fifo2.rd_ptr\[1\] u_pe_array.u_fifo2.rd_ptr\[0\] _2328_ VGND
+ VGND VPWR VPWR _2329_ sky130_fd_sc_hd__and3b_2
X_4415_ _1520_ _1521_ VGND VGND VPWR VPWR _1522_ sky130_fd_sc_hd__nor2_1
X_7203_ clknet_leaf_97_clk _0109_ net950 VGND VGND VPWR VPWR u_pe_array.g_pe_row\[3\].g_pe_col\[2\].u_pe.psum_out\[12\]
+ sky130_fd_sc_hd__dfrtp_1
X_5395_ _2282_ _1112_ VGND VGND VPWR VPWR _2283_ sky130_fd_sc_hd__nand2_1
X_7134_ clknet_leaf_21_clk _0040_ net943 VGND VGND VPWR VPWR u_pe_array.g_pe_row\[3\].g_pe_col\[3\].u_pe.move_reg\[10\]
+ sky130_fd_sc_hd__dfrtp_1
X_4346_ net159 _1166_ _1450_ _1476_ VGND VGND VPWR VPWR _0172_ sky130_fd_sc_hd__a22o_1
X_4277_ _1426_ _1427_ _0931_ VGND VGND VPWR VPWR _1428_ sky130_fd_sc_hd__mux2_1
X_7065_ _3528_ VGND VGND VPWR VPWR _3529_ sky130_fd_sc_hd__buf_2
X_6016_ _2766_ _2767_ VGND VGND VPWR VPWR _2769_ sky130_fd_sc_hd__and2_1
XFILLER_0_96_416 VGND VGND VPWR VPWR sky130_fd_sc_hd__decap_4
XTAP_1339 VGND VPWR sky130_fd_sc_hd__tapvpwrvgnd_1
XTAP_1317 VGND VPWR sky130_fd_sc_hd__tapvpwrvgnd_1
XTAP_1328 VGND VPWR sky130_fd_sc_hd__tapvpwrvgnd_1
XTAP_1306 VGND VPWR sky130_fd_sc_hd__tapvpwrvgnd_1
XFILLER_0_49_310 VGND VGND VPWR VPWR sky130_fd_sc_hd__fill_2
Xclkbuf_leaf_34_clk clknet_3_3__leaf_clk VGND VGND VPWR VPWR clknet_leaf_34_clk sky130_fd_sc_hd__clkbuf_16
X_6918_ _0922_ net774 _3439_ VGND VGND VPWR VPWR _3442_ sky130_fd_sc_hd__mux2_1
X_7898_ clknet_leaf_76_clk _0803_ VGND VGND VPWR VPWR u_pe_array.u_fifo1.buffer\[0\]\[0\]
+ sky130_fd_sc_hd__dfxtp_1
XFILLER_0_37_505 VGND VGND VPWR VPWR sky130_fd_sc_hd__fill_2
X_6849_ net621 _0922_ _3400_ VGND VGND VPWR VPWR _3403_ sky130_fd_sc_hd__mux2_1
XFILLER_0_91_132 VGND VGND VPWR VPWR sky130_fd_sc_hd__fill_1
XFILLER_0_92_688 VPWR VGND VPWR VGND sky130_ef_sc_hd__decap_12
XFILLER_0_72_390 VPWR VGND VPWR VGND sky130_ef_sc_hd__decap_12
XFILLER_0_115_492 VGND VGND VPWR VPWR sky130_fd_sc_hd__fill_1
XFILLER_0_60_585 VGND VGND VPWR VPWR sky130_fd_sc_hd__decap_3
XFILLER_0_102_175 VGND VGND VPWR VPWR sky130_fd_sc_hd__decap_8
XFILLER_0_102_164 VGND VGND VPWR VPWR sky130_fd_sc_hd__decap_4
Xhold380 u_pe_array.act_from_right\[8\]\[12\] VGND VGND VPWR VPWR net454 sky130_fd_sc_hd__dlygate4sd3_1
XFILLER_0_2_3 VPWR VGND VPWR VGND sky130_ef_sc_hd__decap_12
XFILLER_0_102_197 VPWR VGND VPWR VGND sky130_ef_sc_hd__decap_12
Xhold391 u_pe_array.act_from_right\[8\]\[7\] VGND VGND VPWR VPWR net465 sky130_fd_sc_hd__dlygate4sd3_1
XFILLER_0_99_276 VGND VGND VPWR VPWR sky130_fd_sc_hd__decap_4
XFILLER_0_87_449 VGND VGND VPWR VPWR sky130_fd_sc_hd__decap_8
XFILLER_0_114_27 VGND VGND VPWR VPWR sky130_fd_sc_hd__fill_1
XFILLER_0_95_460 VGND VGND VPWR VPWR sky130_fd_sc_hd__decap_6
XFILLER_0_68_674 VGND VGND VPWR VPWR sky130_fd_sc_hd__fill_1
XFILLER_0_67_162 VGND VGND VPWR VPWR sky130_fd_sc_hd__decap_6
XFILLER_0_55_357 VGND VGND VPWR VPWR sky130_fd_sc_hd__fill_1
XFILLER_0_23_210 VPWR VGND VPWR VGND sky130_ef_sc_hd__decap_12
X_4200_ u_pe_array.g_pe_row\[3\].g_pe_col\[1\].u_pe.psum_out\[5\] _1359_ VGND VGND
+ VPWR VPWR _1360_ sky130_fd_sc_hd__xnor2_1
X_5180_ _2111_ _2115_ VGND VGND VPWR VPWR _2117_ sky130_fd_sc_hd__or2_1
XFILLER_0_48_66 VGND VGND VPWR VPWR sky130_fd_sc_hd__fill_2
X_4131_ u_pe_array.g_pe_row\[3\].g_pe_col\[1\].u_pe.act_val\[2\] _1301_ _1305_ net628
+ VGND VGND VPWR VPWR _0127_ sky130_fd_sc_hd__a22o_1
XFILLER_0_47_9 VGND VGND VPWR VPWR sky130_fd_sc_hd__decap_6
X_4062_ u_pe_array.g_pe_row\[3\].g_pe_col\[2\].u_pe.psum_out\[9\] _0934_ VGND VGND
+ VPWR VPWR _1259_ sky130_fd_sc_hd__nand2_1
XFILLER_0_3_57 VPWR VGND VPWR VGND sky130_ef_sc_hd__decap_12
XFILLER_0_64_65 VGND VGND VPWR VPWR sky130_fd_sc_hd__decap_8
X_7821_ clknet_leaf_72_clk _0726_ VGND VGND VPWR VPWR u_pe_array.u_fifo1.buffer\[8\]\[3\]
+ sky130_fd_sc_hd__dfxtp_1
X_4964_ _1926_ _1935_ VGND VGND VPWR VPWR _1946_ sky130_fd_sc_hd__and2b_1
X_7752_ clknet_leaf_49_clk _0658_ net947 VGND VGND VPWR VPWR u_pe_array.g_pe_row\[0\].g_pe_col\[1\].u_pe.act_val\[2\]
+ sky130_fd_sc_hd__dfrtp_2
Xclkbuf_leaf_16_clk clknet_3_2__leaf_clk VGND VGND VPWR VPWR clknet_leaf_16_clk sky130_fd_sc_hd__clkbuf_16
XFILLER_0_59_652 VGND VGND VPWR VPWR sky130_fd_sc_hd__decap_4
XFILLER_0_19_505 VGND VGND VPWR VPWR sky130_fd_sc_hd__decap_4
X_6703_ _3289_ _3290_ VGND VGND VPWR VPWR _3291_ sky130_fd_sc_hd__or2_1
XFILLER_0_73_110 VGND VGND VPWR VPWR sky130_fd_sc_hd__fill_2
XFILLER_0_19_516 VGND VGND VPWR VPWR sky130_fd_sc_hd__fill_1
X_3915_ u_pe_array.g_pe_row\[3\].g_pe_col\[2\].u_pe.psum_out\[10\] _1112_ _1109_ _1149_
+ VGND VGND VPWR VPWR _1150_ sky130_fd_sc_hd__o211a_1
XFILLER_0_46_313 VGND VGND VPWR VPWR sky130_fd_sc_hd__decap_8
XFILLER_0_116_201 VGND VGND VPWR VPWR sky130_fd_sc_hd__fill_1
X_4895_ u_pe_array.act_from_down\[9\]\[12\] _1750_ _1883_ net273 VGND VGND VPWR VPWR
+ _0314_ sky130_fd_sc_hd__a22o_1
XFILLER_0_73_132 VGND VGND VPWR VPWR sky130_fd_sc_hd__fill_1
X_7683_ clknet_leaf_59_clk _0589_ net74 VGND VGND VPWR VPWR u_pe_array.g_pe_row\[0\].g_pe_col\[3\].u_pe.psum_out\[2\]
+ sky130_fd_sc_hd__dfrtp_1
X_3846_ _0988_ u_pe_array.g_pe_row\[3\].g_pe_col\[3\].u_pe.psum_out\[11\] VGND VGND
+ VPWR VPWR _1095_ sky130_fd_sc_hd__and2b_1
X_6634_ net456 _1731_ _1734_ _3241_ VGND VGND VPWR VPWR _0695_ sky130_fd_sc_hd__a22o_1
XFILLER_0_6_421 VGND VGND VPWR VPWR sky130_fd_sc_hd__decap_6
X_6565_ _3178_ _3190_ VGND VGND VPWR VPWR _3191_ sky130_fd_sc_hd__and2_1
X_3777_ _1031_ _1032_ net566 _1006_ VGND VGND VPWR VPWR _0047_ sky130_fd_sc_hd__a2bb2o_1
XFILLER_0_54_390 VGND VGND VPWR VPWR sky130_fd_sc_hd__decap_3
XFILLER_0_116_289 VGND VGND VPWR VPWR sky130_fd_sc_hd__fill_1
X_6496_ u_pe_array.g_pe_row\[0\].g_pe_col\[1\].u_pe.act_val\[1\] _2268_ VGND VGND
+ VPWR VPWR _3128_ sky130_fd_sc_hd__and2b_1
XFILLER_0_14_265 VGND VGND VPWR VPWR sky130_fd_sc_hd__decap_4
XFILLER_0_14_243 VGND VGND VPWR VPWR sky130_fd_sc_hd__fill_2
X_5516_ u_pe_array.u_fifo2.buffer\[4\]\[5\] net68 _2373_ _2375_ VGND VGND VPWR VPWR
+ _2376_ sky130_fd_sc_hd__a211o_1
XFILLER_0_42_563 VGND VGND VPWR VPWR sky130_fd_sc_hd__decap_4
XFILLER_0_112_451 VGND VGND VPWR VPWR sky130_fd_sc_hd__fill_1
X_5447_ _2319_ VGND VGND VPWR VPWR _0430_ sky130_fd_sc_hd__clkbuf_1
XFILLER_0_2_693 VGND VGND VPWR VPWR sky130_fd_sc_hd__decap_6
X_5378_ _2269_ VGND VGND VPWR VPWR _0411_ sky130_fd_sc_hd__clkbuf_1
XFILLER_0_10_460 VGND VGND VPWR VPWR sky130_fd_sc_hd__fill_2
XFILLER_0_1_181 VPWR VGND VPWR VGND sky130_ef_sc_hd__decap_12
X_7117_ clknet_leaf_4_clk net350 net945 VGND VGND VPWR VPWR u_pe_array.act_from_down\[11\]\[6\]
+ sky130_fd_sc_hd__dfrtp_1
X_4329_ u_pe_array.g_pe_row\[3\].g_pe_col\[0\].u_pe.move_reg\[12\] _1118_ VGND VGND
+ VPWR VPWR _1467_ sky130_fd_sc_hd__or2_1
X_7048_ _3519_ VGND VGND VPWR VPWR _0831_ sky130_fd_sc_hd__clkbuf_1
XFILLER_0_69_449 VGND VGND VPWR VPWR sky130_fd_sc_hd__decap_4
XTAP_1114 VGND VPWR sky130_fd_sc_hd__tapvpwrvgnd_1
XTAP_1103 VGND VPWR sky130_fd_sc_hd__tapvpwrvgnd_1
XFILLER_0_84_419 VGND VGND VPWR VPWR sky130_fd_sc_hd__fill_1
XTAP_1147 VGND VPWR sky130_fd_sc_hd__tapvpwrvgnd_1
XTAP_1136 VGND VPWR sky130_fd_sc_hd__tapvpwrvgnd_1
XTAP_1125 VGND VPWR sky130_fd_sc_hd__tapvpwrvgnd_1
XTAP_1158 VGND VPWR sky130_fd_sc_hd__tapvpwrvgnd_1
XTAP_1169 VGND VPWR sky130_fd_sc_hd__tapvpwrvgnd_1
XFILLER_0_65_644 VGND VGND VPWR VPWR sky130_fd_sc_hd__fill_2
XFILLER_0_107_223 VGND VGND VPWR VPWR sky130_fd_sc_hd__fill_1
XFILLER_0_80_625 VPWR VGND VPWR VGND sky130_ef_sc_hd__decap_12
XFILLER_0_18_560 VGND VGND VPWR VPWR sky130_fd_sc_hd__fill_1
XFILLER_0_80_658 VGND VGND VPWR VPWR sky130_fd_sc_hd__fill_1
XFILLER_0_100_29 VPWR VGND VPWR VGND sky130_ef_sc_hd__decap_12
XFILLER_0_60_382 VGND VGND VPWR VPWR sky130_fd_sc_hd__fill_2
XTAP_909 VGND VPWR sky130_fd_sc_hd__tapvpwrvgnd_1
XFILLER_0_109_27 VPWR VGND VPWR VGND sky130_ef_sc_hd__decap_12
XTAP_1692 VGND VPWR sky130_fd_sc_hd__tapvpwrvgnd_1
XTAP_1681 VGND VPWR sky130_fd_sc_hd__tapvpwrvgnd_1
XTAP_1670 VGND VPWR sky130_fd_sc_hd__tapvpwrvgnd_1
X_3700_ net810 _0949_ _0944_ _0968_ VGND VGND VPWR VPWR _0034_ sky130_fd_sc_hd__a22o_1
XFILLER_0_50_23 VGND VGND VPWR VPWR sky130_fd_sc_hd__decap_4
XFILLER_0_70_102 VGND VGND VPWR VPWR sky130_fd_sc_hd__decap_4
XFILLER_0_55_165 VGND VGND VPWR VPWR sky130_fd_sc_hd__decap_3
X_4680_ _1734_ VGND VGND VPWR VPWR _1735_ sky130_fd_sc_hd__buf_8
X_3631_ _0922_ net630 _0918_ VGND VGND VPWR VPWR _0923_ sky130_fd_sc_hd__mux2_1
XFILLER_0_36_390 VGND VGND VPWR VPWR sky130_fd_sc_hd__decap_3
X_3562_ u_fsm.v_cnt\[0\] u_fsm.v_cnt\[1\] u_fsm.v_cnt\[2\] VGND VGND VPWR VPWR _0870_
+ sky130_fd_sc_hd__and3b_1
XFILLER_0_24_552 VGND VGND VPWR VPWR sky130_fd_sc_hd__fill_1
X_6350_ u_pe_array.g_pe_row\[0\].g_pe_col\[2\].u_pe.act_val\[3\] VGND VGND VPWR VPWR
+ _3021_ sky130_fd_sc_hd__inv_2
X_5301_ _2194_ _2201_ _0977_ VGND VGND VPWR VPWR _2203_ sky130_fd_sc_hd__o21a_1
X_6281_ u_pe_array.g_pe_row\[0\].g_pe_col\[2\].u_pe.psum_out\[4\] u_pe_array.g_pe_row\[0\].g_pe_col\[2\].u_pe.act_val\[4\]
+ _2844_ VGND VGND VPWR VPWR _2978_ sky130_fd_sc_hd__mux2_1
XFILLER_0_51_393 VGND VGND VPWR VPWR sky130_fd_sc_hd__decap_3
X_5232_ net849 _2143_ _2132_ _2149_ VGND VGND VPWR VPWR _0385_ sky130_fd_sc_hd__a22o_1
XFILLER_0_11_279 VGND VGND VPWR VPWR sky130_fd_sc_hd__fill_1
Xclkbuf_leaf_5_clk clknet_3_0__leaf_clk VGND VGND VPWR VPWR clknet_leaf_5_clk sky130_fd_sc_hd__clkbuf_16
X_5163_ _2093_ _2096_ _2101_ VGND VGND VPWR VPWR _2102_ sky130_fd_sc_hd__a21oi_2
X_4114_ u_pe_array.g_pe_row\[3\].g_pe_col\[1\].u_pe.psum_out\[8\] u_pe_array.g_pe_row\[3\].g_pe_col\[1\].u_pe.move_reg\[8\]
+ _0947_ VGND VGND VPWR VPWR _1297_ sky130_fd_sc_hd__mux2_1
X_5094_ _2037_ _1286_ u_pe_array.g_pe_row\[2\].g_pe_col\[0\].u_pe.psum_out\[3\] VGND
+ VGND VPWR VPWR _2038_ sky130_fd_sc_hd__a21oi_1
X_4045_ _1239_ _1243_ _1228_ VGND VGND VPWR VPWR _1244_ sky130_fd_sc_hd__mux2_1
X_7804_ clknet_leaf_43_clk net223 net946 VGND VGND VPWR VPWR u_pe_array.g_pe_row\[0\].g_pe_col\[0\].u_pe.move_reg\[12\]
+ sky130_fd_sc_hd__dfrtp_1
XFILLER_0_115_81 VPWR VGND VPWR VGND sky130_ef_sc_hd__decap_12
XPHY_219 VGND VGND VPWR VPWR sky130_fd_sc_hd__decap_3
XPHY_208 VGND VGND VPWR VPWR sky130_fd_sc_hd__decap_3
XFILLER_0_19_313 VGND VGND VPWR VPWR sky130_fd_sc_hd__fill_2
XFILLER_0_19_324 VGND VGND VPWR VPWR sky130_fd_sc_hd__fill_2
X_5996_ _2742_ _2746_ VGND VGND VPWR VPWR _2750_ sky130_fd_sc_hd__nor2_1
X_7735_ clknet_leaf_54_clk _0641_ net74 VGND VGND VPWR VPWR u_pe_array.g_pe_row\[0\].g_pe_col\[0\].u_pe.w_out\[0\]
+ sky130_fd_sc_hd__dfrtp_1
X_4947_ u_pe_array.g_pe_row\[2\].g_pe_col\[1\].u_pe.act_val\[5\] u_pe_array.g_pe_row\[2\].g_pe_col\[1\].u_pe.w_out\[0\]
+ VGND VGND VPWR VPWR _1930_ sky130_fd_sc_hd__nand2_1
XFILLER_0_59_493 VGND VGND VPWR VPWR sky130_fd_sc_hd__fill_1
XFILLER_0_47_655 VGND VGND VPWR VPWR sky130_fd_sc_hd__fill_2
X_4878_ net401 _1749_ _1873_ _1880_ VGND VGND VPWR VPWR _0300_ sky130_fd_sc_hd__a22o_1
XFILLER_0_74_474 VGND VGND VPWR VPWR sky130_fd_sc_hd__fill_2
X_7666_ clknet_leaf_63_clk _0572_ net74 VGND VGND VPWR VPWR u_pe_array.act_from_right\[2\]\[11\]
+ sky130_fd_sc_hd__dfrtp_1
X_6617_ u_pe_array.g_pe_row\[0\].g_pe_col\[0\].u_pe.psum_out\[3\] u_pe_array.g_pe_row\[0\].g_pe_col\[0\].u_pe.act_val\[3\]
+ _3102_ VGND VGND VPWR VPWR _3233_ sky130_fd_sc_hd__mux2_1
X_3829_ u_pe_array.g_pe_row\[3\].g_pe_col\[3\].u_pe.psum_out\[8\] u_pe_array.g_pe_row\[3\].g_pe_col\[3\].u_pe.psum_out\[9\]
+ _0988_ VGND VGND VPWR VPWR _1080_ sky130_fd_sc_hd__and3_1
XFILLER_0_61_113 VGND VGND VPWR VPWR sky130_fd_sc_hd__decap_4
X_7597_ clknet_leaf_44_clk _0503_ net947 VGND VGND VPWR VPWR u_pe_array.g_pe_row\[1\].g_pe_col\[1\].u_pe.psum_out\[11\]
+ sky130_fd_sc_hd__dfrtp_1
X_6548_ _3156_ _3165_ VGND VGND VPWR VPWR _3176_ sky130_fd_sc_hd__and2b_1
XFILLER_0_104_248 VGND VGND VPWR VPWR sky130_fd_sc_hd__decap_4
XFILLER_0_42_360 VGND VGND VPWR VPWR sky130_fd_sc_hd__decap_4
X_6479_ u_pe_array.act_from_down\[1\]\[10\] _0866_ _0940_ net244 VGND VGND VPWR VPWR
+ _0666_ sky130_fd_sc_hd__a22o_1
XFILLER_0_30_544 VGND VGND VPWR VPWR sky130_fd_sc_hd__decap_6
XFILLER_0_84_249 VGND VGND VPWR VPWR sky130_fd_sc_hd__decap_3
XFILLER_0_37_110 VGND VGND VPWR VPWR sky130_fd_sc_hd__fill_2
XFILLER_0_20_15 VPWR VGND VPWR VGND sky130_ef_sc_hd__decap_12
XFILLER_0_111_39 VPWR VGND VPWR VGND sky130_ef_sc_hd__decap_12
XFILLER_0_80_477 VGND VGND VPWR VPWR sky130_fd_sc_hd__fill_1
XFILLER_0_18_390 VGND VGND VPWR VPWR sky130_fd_sc_hd__decap_8
XFILLER_0_40_319 VGND VGND VPWR VPWR sky130_fd_sc_hd__decap_8
XFILLER_0_0_405 VGND VGND VPWR VPWR sky130_fd_sc_hd__fill_2
XFILLER_0_33_393 VPWR VGND VPWR VGND sky130_ef_sc_hd__decap_12
XFILLER_0_0_449 VGND VGND VPWR VPWR sky130_fd_sc_hd__decap_8
XTAP_706 VGND VPWR sky130_fd_sc_hd__tapvpwrvgnd_1
XFILLER_0_29_68 VGND VGND VPWR VPWR sky130_fd_sc_hd__fill_1
XTAP_717 VGND VPWR sky130_fd_sc_hd__tapvpwrvgnd_1
XTAP_728 VGND VPWR sky130_fd_sc_hd__tapvpwrvgnd_1
XTAP_739 VGND VPWR sky130_fd_sc_hd__tapvpwrvgnd_1
Xmax_cap1 _3258_ VGND VGND VPWR VPWR net940 sky130_fd_sc_hd__clkbuf_1
XFILLER_0_29_611 VGND VGND VPWR VPWR sky130_fd_sc_hd__decap_4
X_5850_ u_pe_array.g_pe_row\[1\].g_pe_col\[0\].u_pe.psum_out\[4\] _1108_ _1110_ _2641_
+ VGND VGND VPWR VPWR _2642_ sky130_fd_sc_hd__o211a_2
XFILLER_0_48_419 VGND VGND VPWR VPWR sky130_fd_sc_hd__fill_1
XFILLER_0_118_329 VGND VGND VPWR VPWR sky130_fd_sc_hd__decap_6
XFILLER_0_118_307 VGND VGND VPWR VPWR sky130_fd_sc_hd__fill_1
X_5781_ _2579_ _2583_ VGND VGND VPWR VPWR _2585_ sky130_fd_sc_hd__nand2_1
XFILLER_0_61_55 VGND VGND VPWR VPWR sky130_fd_sc_hd__fill_1
XFILLER_0_56_441 VPWR VGND VPWR VGND sky130_ef_sc_hd__decap_12
XFILLER_0_0_69 VGND VGND VPWR VPWR sky130_fd_sc_hd__decap_8
X_4801_ _1822_ u_pe_array.g_pe_row\[2\].g_pe_col\[2\].u_pe.psum_out\[7\] _1805_ VGND
+ VGND VPWR VPWR _1823_ sky130_fd_sc_hd__mux2_1
XFILLER_0_71_400 VGND VGND VPWR VPWR sky130_fd_sc_hd__fill_1
X_4732_ _1487_ _1758_ _1759_ _1356_ net702 VGND VGND VPWR VPWR _0275_ sky130_fd_sc_hd__a32o_1
X_7520_ clknet_leaf_71_clk _0426_ net949 VGND VGND VPWR VPWR u_pe_array.act_from_left\[7\]\[1\]
+ sky130_fd_sc_hd__dfrtp_1
XFILLER_0_44_614 VGND VGND VPWR VPWR sky130_fd_sc_hd__fill_2
X_7451_ clknet_leaf_36_clk _0357_ net951 VGND VGND VPWR VPWR u_pe_array.g_pe_row\[2\].g_pe_col\[0\].u_pe.psum_out\[1\]
+ sky130_fd_sc_hd__dfrtp_1
XFILLER_0_43_113 VGND VGND VPWR VPWR sky130_fd_sc_hd__decap_6
XFILLER_0_44_636 VGND VGND VPWR VPWR sky130_fd_sc_hd__decap_8
X_4663_ net665 _1273_ _1721_ _1021_ VGND VGND VPWR VPWR _0244_ sky130_fd_sc_hd__a22o_1
X_3614_ _0905_ _0908_ _0909_ VGND VGND VPWR VPWR _0007_ sky130_fd_sc_hd__nor3_1
X_6402_ u_pe_array.g_pe_row\[0\].g_pe_col\[2\].u_pe.psum_out\[8\] _2130_ VGND VGND
+ VPWR VPWR _3069_ sky130_fd_sc_hd__or2_1
X_7382_ clknet_leaf_37_clk _0288_ net942 VGND VGND VPWR VPWR u_pe_array.g_pe_row\[2\].g_pe_col\[0\].u_pe.w_out\[1\]
+ sky130_fd_sc_hd__dfrtp_1
XFILLER_0_71_499 VGND VGND VPWR VPWR sky130_fd_sc_hd__decap_4
X_4594_ _1487_ _1658_ _1659_ _1356_ net339 VGND VGND VPWR VPWR _0237_ sky130_fd_sc_hd__a32o_1
XFILLER_0_12_533 VGND VGND VPWR VPWR sky130_fd_sc_hd__decap_3
X_3545_ u_fsm.state\[2\] VGND VGND VPWR VPWR _0853_ sky130_fd_sc_hd__buf_6
X_6333_ u_pe_array.g_pe_row\[0\].g_pe_col\[2\].u_pe.act_val\[1\] u_pe_array.g_pe_row\[0\].g_pe_col\[2\].u_pe.psum_out\[2\]
+ _2130_ VGND VGND VPWR VPWR _3005_ sky130_fd_sc_hd__and3b_1
X_6264_ u_pe_array.g_pe_row\[0\].g_pe_col\[3\].u_pe.psum_out\[9\] u_pe_array.g_pe_row\[0\].g_pe_col\[3\].u_pe.psum_out\[10\]
+ _1999_ VGND VGND VPWR VPWR _2968_ sky130_fd_sc_hd__o21a_1
XFILLER_0_86_41 VGND VGND VPWR VPWR sky130_fd_sc_hd__decap_4
X_5215_ net519 _1882_ _2132_ _2140_ VGND VGND VPWR VPWR _0377_ sky130_fd_sc_hd__a22o_1
XFILLER_0_86_96 VGND VGND VPWR VPWR sky130_fd_sc_hd__decap_3
X_6195_ u_pe_array.g_pe_row\[0\].g_pe_col\[3\].u_pe.psum_out\[5\] _2905_ VGND VGND
+ VPWR VPWR _2906_ sky130_fd_sc_hd__xnor2_2
XFILLER_0_43_3 VGND VGND VPWR VPWR sky130_fd_sc_hd__decap_8
X_5146_ u_pe_array.g_pe_row\[2\].g_pe_col\[0\].u_pe.psum_out\[7\] _1286_ VGND VGND
+ VPWR VPWR _2086_ sky130_fd_sc_hd__or2_1
X_5077_ u_pe_array.g_pe_row\[2\].g_pe_col\[0\].u_pe.act_val\[1\] _1284_ _2021_ _2022_
+ VGND VGND VPWR VPWR _2023_ sky130_fd_sc_hd__nand4_1
X_4028_ _1133_ u_pe_array.g_pe_row\[3\].g_pe_col\[2\].u_pe.psum_out\[6\] _0934_ VGND
+ VGND VPWR VPWR _1228_ sky130_fd_sc_hd__nand3_2
X_5979_ u_pe_array.g_pe_row\[1\].g_pe_col\[0\].u_pe.act_val\[0\] _1865_ VGND VGND
+ VPWR VPWR _2735_ sky130_fd_sc_hd__nand2_1
X_7718_ clknet_leaf_62_clk net309 net72 VGND VGND VPWR VPWR u_pe_array.g_pe_row\[0\].g_pe_col\[2\].u_pe.move_reg\[9\]
+ sky130_fd_sc_hd__dfrtp_1
XFILLER_0_35_625 VGND VGND VPWR VPWR sky130_fd_sc_hd__decap_4
XFILLER_0_62_444 VGND VGND VPWR VPWR sky130_fd_sc_hd__decap_6
X_7649_ clknet_leaf_62_clk _0555_ net72 VGND VGND VPWR VPWR u_pe_array.g_pe_row\[1\].g_pe_col\[0\].u_pe.psum_out\[9\]
+ sky130_fd_sc_hd__dfrtp_2
XFILLER_0_30_341 VGND VGND VPWR VPWR sky130_fd_sc_hd__decap_3
XFILLER_0_100_240 VGND VGND VPWR VPWR sky130_fd_sc_hd__fill_1
XFILLER_0_30_396 VGND VGND VPWR VPWR sky130_fd_sc_hd__decap_3
XFILLER_0_15_15 VPWR VGND VPWR VGND sky130_ef_sc_hd__decap_12
XFILLER_0_85_558 VGND VGND VPWR VPWR sky130_fd_sc_hd__fill_2
XFILLER_0_57_238 VGND VGND VPWR VPWR sky130_fd_sc_hd__fill_1
XFILLER_0_65_260 VGND VGND VPWR VPWR sky130_fd_sc_hd__decap_6
XFILLER_0_41_606 VGND VGND VPWR VPWR sky130_fd_sc_hd__decap_8
Xhold209 u_pe_array.act_from_down\[1\]\[5\] VGND VGND VPWR VPWR net283 sky130_fd_sc_hd__dlygate4sd3_1
XFILLER_0_40_149 VGND VGND VPWR VPWR sky130_fd_sc_hd__decap_3
XTAP_503 VGND VPWR sky130_fd_sc_hd__tapvpwrvgnd_1
XTAP_514 VGND VPWR sky130_fd_sc_hd__tapvpwrvgnd_1
XTAP_525 VGND VPWR sky130_fd_sc_hd__tapvpwrvgnd_1
X_5000_ _1884_ _1977_ _1978_ _1803_ net722 VGND VGND VPWR VPWR _0324_ sky130_fd_sc_hd__a32o_1
XTAP_536 VGND VPWR sky130_fd_sc_hd__tapvpwrvgnd_1
XTAP_547 VGND VPWR sky130_fd_sc_hd__tapvpwrvgnd_1
XTAP_558 VGND VPWR sky130_fd_sc_hd__tapvpwrvgnd_1
XTAP_569 VGND VPWR sky130_fd_sc_hd__tapvpwrvgnd_1
XFILLER_0_88_330 VPWR VGND VPWR VGND sky130_ef_sc_hd__decap_12
X_6951_ net622 _3459_ VGND VGND VPWR VPWR _3461_ sky130_fd_sc_hd__nor2_1
X_5902_ net143 _1159_ _2661_ _0983_ VGND VGND VPWR VPWR _0530_ sky130_fd_sc_hd__a22o_1
X_6882_ net655 _0928_ _3415_ VGND VGND VPWR VPWR _3421_ sky130_fd_sc_hd__mux2_1
X_5833_ u_pe_array.g_pe_row\[1\].g_pe_col\[0\].u_pe.psum_out\[0\] _1108_ _1110_ _2628_
+ VGND VGND VPWR VPWR _2629_ sky130_fd_sc_hd__o211a_2
XFILLER_0_118_137 VGND VGND VPWR VPWR sky130_fd_sc_hd__decap_3
XFILLER_0_17_614 VGND VGND VPWR VPWR sky130_fd_sc_hd__fill_2
X_5764_ u_pe_array.g_pe_row\[1\].g_pe_col\[1\].u_pe.psum_out\[5\] _2557_ _2568_ VGND
+ VGND VPWR VPWR _2569_ sky130_fd_sc_hd__a21oi_2
X_7503_ clknet_leaf_42_clk _0409_ net946 VGND VGND VPWR VPWR u_pe_array.g_pe_row\[1\].g_pe_col\[3\].u_pe.psum_out\[12\]
+ sky130_fd_sc_hd__dfrtp_1
XFILLER_0_16_124 VGND VGND VPWR VPWR sky130_fd_sc_hd__decap_4
X_4715_ _0866_ VGND VGND VPWR VPWR _1750_ sky130_fd_sc_hd__clkbuf_8
X_5695_ net81 _2016_ _1883_ u_pe_array.g_pe_row\[1\].g_pe_col\[1\].u_pe.move_reg\[8\]
+ VGND VGND VPWR VPWR _0487_ sky130_fd_sc_hd__a22o_1
XFILLER_0_32_606 VGND VGND VPWR VPWR sky130_fd_sc_hd__decap_8
XFILLER_0_44_444 VGND VGND VPWR VPWR sky130_fd_sc_hd__decap_4
X_7434_ clknet_leaf_13_clk _0340_ net951 VGND VGND VPWR VPWR u_pe_array.act_from_up\[12\]\[10\]
+ sky130_fd_sc_hd__dfrtp_1
X_4646_ _1698_ _1700_ _1705_ VGND VGND VPWR VPWR _1707_ sky130_fd_sc_hd__or3_1
XFILLER_0_44_477 VGND VGND VPWR VPWR sky130_fd_sc_hd__fill_2
Xhold721 u_pe_array.g_pe_row\[2\].g_pe_col\[0\].u_pe.psum_out\[11\] VGND VGND VPWR
+ VPWR net795 sky130_fd_sc_hd__dlygate4sd3_1
Xhold710 u_pe_array.g_pe_row\[0\].g_pe_col\[1\].u_pe.psum_out\[7\] VGND VGND VPWR
+ VPWR net784 sky130_fd_sc_hd__dlygate4sd3_1
X_4577_ _1629_ _1630_ _1643_ VGND VGND VPWR VPWR _1644_ sky130_fd_sc_hd__o21a_1
X_7365_ clknet_leaf_7_clk net290 net945 VGND VGND VPWR VPWR u_pe_array.g_pe_row\[2\].g_pe_col\[2\].u_pe.move_reg\[10\]
+ sky130_fd_sc_hd__dfrtp_1
Xhold743 u_pe_array.g_pe_row\[3\].g_pe_col\[3\].u_pe.psum_out\[8\] VGND VGND VPWR
+ VPWR net817 sky130_fd_sc_hd__dlygate4sd3_1
Xhold754 u_pe_array.act_from_left\[13\]\[1\] VGND VGND VPWR VPWR net828 sky130_fd_sc_hd__dlygate4sd3_1
Xhold732 u_pe_array.g_pe_row\[0\].g_pe_col\[2\].u_pe.psum_out\[7\] VGND VGND VPWR
+ VPWR net806 sky130_fd_sc_hd__dlygate4sd3_1
XFILLER_0_12_352 VGND VGND VPWR VPWR sky130_fd_sc_hd__decap_8
XFILLER_0_12_341 VGND VGND VPWR VPWR sky130_fd_sc_hd__fill_2
X_6316_ u_pe_array.g_pe_row\[0\].g_pe_col\[2\].u_pe.act_val\[0\] _2130_ u_pe_array.g_pe_row\[0\].g_pe_col\[2\].u_pe.psum_out\[1\]
+ VGND VGND VPWR VPWR _2990_ sky130_fd_sc_hd__a21oi_1
XFILLER_0_40_650 VGND VGND VPWR VPWR sky130_fd_sc_hd__decap_4
Xhold776 _0385_ VGND VGND VPWR VPWR net850 sky130_fd_sc_hd__dlygate4sd3_1
XFILLER_0_12_385 VGND VGND VPWR VPWR sky130_fd_sc_hd__decap_3
Xhold787 u_pe_array.act_from_left\[15\]\[4\] VGND VGND VPWR VPWR net861 sky130_fd_sc_hd__dlygate4sd3_1
Xhold765 net52 VGND VGND VPWR VPWR net839 sky130_fd_sc_hd__dlygate4sd3_1
XFILLER_0_40_683 VGND VGND VPWR VPWR sky130_fd_sc_hd__decap_8
XFILLER_0_40_694 VGND VGND VPWR VPWR sky130_fd_sc_hd__fill_2
X_7296_ clknet_leaf_94_clk _0202_ net951 VGND VGND VPWR VPWR u_pe_array.g_pe_row\[3\].g_pe_col\[0\].u_pe.psum_out\[10\]
+ sky130_fd_sc_hd__dfrtp_2
X_6247_ u_pe_array.g_pe_row\[0\].g_pe_col\[3\].u_pe.psum_out\[7\] u_pe_array.g_pe_row\[0\].g_pe_col\[3\].u_pe.psum_out\[8\]
+ _1999_ VGND VGND VPWR VPWR _2953_ sky130_fd_sc_hd__o21a_1
Xhold798 u_pe_array.act_from_right\[13\]\[3\] VGND VGND VPWR VPWR net872 sky130_fd_sc_hd__dlygate4sd3_1
X_6178_ _2880_ _2890_ VGND VGND VPWR VPWR _2891_ sky130_fd_sc_hd__xnor2_1
X_5129_ _2069_ _2070_ VGND VGND VPWR VPWR _2071_ sky130_fd_sc_hd__xnor2_1
XFILLER_0_98_138 VGND VGND VPWR VPWR sky130_fd_sc_hd__fill_2
XFILLER_0_47_293 VGND VGND VPWR VPWR sky130_fd_sc_hd__decap_6
XFILLER_0_23_617 VGND VGND VPWR VPWR sky130_fd_sc_hd__decap_3
XFILLER_0_22_138 VGND VGND VPWR VPWR sky130_fd_sc_hd__fill_2
XFILLER_0_22_149 VGND VGND VPWR VPWR sky130_fd_sc_hd__fill_2
Xhold92 _0135_ VGND VGND VPWR VPWR net166 sky130_fd_sc_hd__dlygate4sd3_1
Xhold70 u_pe_array.act_from_left\[5\]\[8\] VGND VGND VPWR VPWR net144 sky130_fd_sc_hd__dlygate4sd3_1
Xhold81 u_pe_array.act_from_down\[11\]\[5\] VGND VGND VPWR VPWR net155 sky130_fd_sc_hd__dlygate4sd3_1
XFILLER_0_42_57 VGND VGND VPWR VPWR sky130_fd_sc_hd__decap_6
XFILLER_0_5_305 VGND VGND VPWR VPWR sky130_fd_sc_hd__decap_6
XFILLER_0_108_192 VGND VGND VPWR VPWR sky130_fd_sc_hd__decap_4
XFILLER_0_81_561 VGND VGND VPWR VPWR sky130_fd_sc_hd__decap_3
X_5480_ u_pe_array.u_fifo2.buffer\[0\]\[1\] _2324_ VGND VGND VPWR VPWR _2344_ sky130_fd_sc_hd__or2_1
X_4500_ u_pe_array.g_pe_row\[1\].g_pe_col\[2\].u_pe.w_out\[1\] VGND VGND VPWR VPWR
+ _1597_ sky130_fd_sc_hd__buf_6
XFILLER_0_101_3 VPWR VGND VPWR VGND sky130_ef_sc_hd__decap_12
X_4431_ _1445_ u_pe_array.g_pe_row\[3\].g_pe_col\[0\].u_pe.psum_out\[6\] _1287_ VGND
+ VGND VPWR VPWR _1536_ sky130_fd_sc_hd__and3_1
XANTENNA_1 _1468_ VGND VGND VPWR VPWR sky130_fd_sc_hd__diode_2
XFILLER_0_111_313 VPWR VGND VPWR VGND sky130_ef_sc_hd__decap_12
XFILLER_0_111_346 VGND VGND VPWR VPWR sky130_fd_sc_hd__decap_8
X_7150_ clknet_leaf_23_clk _0056_ net943 VGND VGND VPWR VPWR u_pe_array.g_pe_row\[3\].g_pe_col\[1\].u_pe.w_out\[0\]
+ sky130_fd_sc_hd__dfrtp_4
XFILLER_0_22_683 VPWR VGND VPWR VGND sky130_ef_sc_hd__decap_12
X_4362_ net930 _1301_ _1305_ _1481_ VGND VGND VPWR VPWR _0183_ sky130_fd_sc_hd__a22o_1
XFILLER_0_67_65 VGND VGND VPWR VPWR sky130_fd_sc_hd__decap_3
X_4293_ u_pe_array.g_pe_row\[3\].g_pe_col\[0\].u_pe.psum_out\[3\] _1108_ _1110_ _1439_
+ VGND VGND VPWR VPWR _1440_ sky130_fd_sc_hd__o211a_1
XTAP_333 VGND VPWR sky130_fd_sc_hd__tapvpwrvgnd_1
XTAP_322 VGND VPWR sky130_fd_sc_hd__tapvpwrvgnd_1
XTAP_311 VGND VPWR sky130_fd_sc_hd__tapvpwrvgnd_1
XTAP_300 VGND VPWR sky130_fd_sc_hd__tapvpwrvgnd_1
X_7081_ net586 _3354_ _3536_ VGND VGND VPWR VPWR _3538_ sky130_fd_sc_hd__mux2_1
XFILLER_0_21_193 VGND VGND VPWR VPWR sky130_fd_sc_hd__decap_3
X_6101_ _2843_ VGND VGND VPWR VPWR _0560_ sky130_fd_sc_hd__clkbuf_1
XTAP_366 VGND VPWR sky130_fd_sc_hd__tapvpwrvgnd_1
XTAP_355 VGND VPWR sky130_fd_sc_hd__tapvpwrvgnd_1
XTAP_344 VGND VPWR sky130_fd_sc_hd__tapvpwrvgnd_1
X_6032_ _2644_ _1865_ u_pe_array.g_pe_row\[1\].g_pe_col\[0\].u_pe.psum_out\[6\] VGND
+ VGND VPWR VPWR _2783_ sky130_fd_sc_hd__a21oi_1
XTAP_399 VGND VPWR sky130_fd_sc_hd__tapvpwrvgnd_1
XTAP_388 VGND VPWR sky130_fd_sc_hd__tapvpwrvgnd_1
XTAP_377 VGND VPWR sky130_fd_sc_hd__tapvpwrvgnd_1
XFILLER_0_107_93 VPWR VGND VPWR VGND sky130_ef_sc_hd__decap_12
XFILLER_0_95_119 VGND VGND VPWR VPWR sky130_fd_sc_hd__decap_4
XFILLER_0_88_160 VGND VGND VPWR VPWR sky130_fd_sc_hd__decap_6
XPHY_28 VGND VGND VPWR VPWR sky130_fd_sc_hd__decap_3
XPHY_17 VGND VGND VPWR VPWR sky130_fd_sc_hd__decap_3
X_6934_ _3450_ VGND VGND VPWR VPWR _0786_ sky130_fd_sc_hd__clkbuf_1
XPHY_39 VGND VGND VPWR VPWR sky130_fd_sc_hd__decap_3
XFILLER_0_49_536 VGND VGND VPWR VPWR sky130_fd_sc_hd__fill_1
XFILLER_0_49_547 VPWR VGND VPWR VGND sky130_ef_sc_hd__decap_12
X_6865_ net611 _0924_ _3408_ VGND VGND VPWR VPWR _3412_ sky130_fd_sc_hd__mux2_1
XFILLER_0_8_121 VPWR VGND VPWR VGND sky130_ef_sc_hd__decap_12
X_5816_ _1728_ u_pe_array.g_pe_row\[1\].g_pe_col\[1\].u_pe.psum_out\[11\] VGND VGND
+ VPWR VPWR _2616_ sky130_fd_sc_hd__and2b_1
XFILLER_0_91_314 VPWR VGND VPWR VGND sky130_ef_sc_hd__decap_12
XFILLER_0_9_666 VGND VGND VPWR VPWR sky130_fd_sc_hd__decap_6
X_6796_ u_pe_array.u_fifo2.wr_ptr\[2\] _3366_ VGND VGND VPWR VPWR _3368_ sky130_fd_sc_hd__and2_1
X_5747_ _2544_ _2552_ _1003_ VGND VGND VPWR VPWR _2554_ sky130_fd_sc_hd__a21o_1
XFILLER_0_60_701 VGND VGND VPWR VPWR sky130_fd_sc_hd__decap_4
XFILLER_0_17_499 VGND VGND VPWR VPWR sky130_fd_sc_hd__decap_4
XFILLER_0_115_685 VPWR VGND VPWR VGND sky130_ef_sc_hd__decap_12
X_7417_ clknet_leaf_30_clk _0323_ net71 VGND VGND VPWR VPWR u_pe_array.g_pe_row\[2\].g_pe_col\[1\].u_pe.psum_out\[8\]
+ sky130_fd_sc_hd__dfrtp_4
X_5678_ net359 _2499_ _2491_ _2503_ VGND VGND VPWR VPWR _0477_ sky130_fd_sc_hd__a22o_1
XFILLER_0_114_195 VGND VGND VPWR VPWR sky130_fd_sc_hd__fill_1
XFILLER_0_102_335 VGND VGND VPWR VPWR sky130_fd_sc_hd__fill_2
X_4629_ _1656_ _1657_ _1690_ VGND VGND VPWR VPWR _1691_ sky130_fd_sc_hd__or3_1
XFILLER_0_102_368 VGND VGND VPWR VPWR sky130_fd_sc_hd__fill_2
Xhold540 u_pe_array.g_pe_row\[3\].g_pe_col\[3\].u_pe.psum_out\[1\] VGND VGND VPWR
+ VPWR net614 sky130_fd_sc_hd__dlygate4sd3_1
Xhold562 u_pe_array.g_pe_row\[2\].g_pe_col\[2\].u_pe.psum_out\[4\] VGND VGND VPWR
+ VPWR net636 sky130_fd_sc_hd__dlygate4sd3_1
XFILLER_0_12_171 VGND VGND VPWR VPWR sky130_fd_sc_hd__fill_2
Xhold551 u_pe_array.u_fifo1.buffer\[6\]\[3\] VGND VGND VPWR VPWR net625 sky130_fd_sc_hd__dlygate4sd3_1
X_7348_ clknet_leaf_0_clk _0254_ net945 VGND VGND VPWR VPWR u_pe_array.act_from_up\[14\]\[6\]
+ sky130_fd_sc_hd__dfrtp_1
X_7279_ clknet_leaf_12_clk net199 net942 VGND VGND VPWR VPWR u_pe_array.g_pe_row\[3\].g_pe_col\[0\].u_pe.move_reg\[6\]
+ sky130_fd_sc_hd__dfrtp_1
Xhold584 u_pe_array.g_pe_row\[1\].g_pe_col\[0\].u_pe.psum_out\[11\] VGND VGND VPWR
+ VPWR net658 sky130_fd_sc_hd__dlygate4sd3_1
Xhold595 u_pe_array.u_fifo2.buffer\[7\]\[5\] VGND VGND VPWR VPWR net669 sky130_fd_sc_hd__dlygate4sd3_1
Xhold573 u_pe_array.g_pe_row\[1\].g_pe_col\[2\].u_pe.act_val\[2\] VGND VGND VPWR VPWR
+ net647 sky130_fd_sc_hd__dlygate4sd3_1
XFILLER_0_99_469 VPWR VGND VPWR VGND sky130_ef_sc_hd__decap_12
XFILLER_0_79_182 VGND VGND VPWR VPWR sky130_fd_sc_hd__decap_3
XFILLER_0_94_130 VGND VGND VPWR VPWR sky130_fd_sc_hd__decap_8
XFILLER_0_95_697 VGND VGND VPWR VPWR sky130_fd_sc_hd__decap_8
XFILLER_0_82_347 VGND VGND VPWR VPWR sky130_fd_sc_hd__decap_4
XFILLER_0_35_241 VGND VGND VPWR VPWR sky130_fd_sc_hd__decap_3
XFILLER_0_35_252 VGND VGND VPWR VPWR sky130_fd_sc_hd__decap_8
Xoutput60 net60 VGND VGND VPWR VPWR psum_out1[8] sky130_fd_sc_hd__buf_2
XFILLER_0_37_57 VGND VGND VPWR VPWR sky130_fd_sc_hd__decap_4
X_4980_ _1944_ _1957_ VGND VGND VPWR VPWR _1960_ sky130_fd_sc_hd__and2b_1
XFILLER_0_86_642 VGND VGND VPWR VPWR sky130_fd_sc_hd__fill_2
X_3931_ _1161_ VGND VGND VPWR VPWR _0072_ sky130_fd_sc_hd__clkbuf_1
X_3862_ _1107_ VGND VGND VPWR VPWR _0057_ sky130_fd_sc_hd__clkbuf_1
X_6650_ u_pe_array.g_pe_row\[0\].g_pe_col\[0\].u_pe.act_val\[0\] _2486_ u_pe_array.g_pe_row\[0\].g_pe_col\[0\].u_pe.psum_out\[0\]
+ VGND VGND VPWR VPWR _3243_ sky130_fd_sc_hd__a21o_1
XFILLER_0_46_539 VGND VGND VPWR VPWR sky130_fd_sc_hd__fill_1
X_6581_ _3195_ _3203_ _3204_ _3205_ VGND VGND VPWR VPWR _3206_ sky130_fd_sc_hd__a31o_1
X_5601_ _2445_ VGND VGND VPWR VPWR _2446_ sky130_fd_sc_hd__inv_2
X_3793_ u_pe_array.g_pe_row\[3\].g_pe_col\[3\].u_pe.act_val\[5\] u_pe_array.g_pe_row\[3\].g_pe_col\[3\].u_pe.w_out\[0\]
+ _1034_ VGND VGND VPWR VPWR _1047_ sky130_fd_sc_hd__and3_1
XFILLER_0_5_113 VPWR VGND VPWR VGND sky130_ef_sc_hd__decap_12
X_5532_ _2381_ _2382_ _2380_ VGND VGND VPWR VPWR _2383_ sky130_fd_sc_hd__o21ai_1
XFILLER_0_42_701 VGND VGND VPWR VPWR sky130_fd_sc_hd__decap_4
X_5463_ u_pe_array.u_fifo2.rd_ptr\[3\] u_pe_array.u_fifo2.rd_ptr\[2\] VGND VGND VPWR
+ VPWR _2328_ sky130_fd_sc_hd__nor2_1
X_4414_ u_pe_array.g_pe_row\[3\].g_pe_col\[0\].u_pe.psum_out\[3\] _1506_ _1507_ VGND
+ VGND VPWR VPWR _1521_ sky130_fd_sc_hd__a21boi_2
X_7202_ clknet_leaf_95_clk _0108_ net951 VGND VGND VPWR VPWR u_pe_array.g_pe_row\[3\].g_pe_col\[2\].u_pe.psum_out\[11\]
+ sky130_fd_sc_hd__dfrtp_1
X_5394_ u_pe_array.g_pe_row\[1\].g_pe_col\[2\].u_pe.act_val\[3\] VGND VGND VPWR VPWR
+ _2282_ sky130_fd_sc_hd__inv_2
XFILLER_0_112_699 VGND VGND VPWR VPWR sky130_fd_sc_hd__fill_1
X_7133_ clknet_leaf_21_clk _0039_ net943 VGND VGND VPWR VPWR u_pe_array.g_pe_row\[3\].g_pe_col\[3\].u_pe.move_reg\[9\]
+ sky130_fd_sc_hd__dfrtp_1
X_4345_ _0983_ VGND VGND VPWR VPWR _1476_ sky130_fd_sc_hd__buf_6
XFILLER_0_94_41 VPWR VGND VPWR VGND sky130_ef_sc_hd__decap_12
X_4276_ u_pe_array.g_pe_row\[2\].g_pe_col\[3\].u_pe.w_out\[1\] VGND VGND VPWR VPWR
+ _1427_ sky130_fd_sc_hd__buf_6
X_7064_ u_pe_array.u_fifo1.wr_ptr\[0\] u_pe_array.u_fifo1.wr_ptr\[1\] _3513_ VGND
+ VGND VPWR VPWR _3528_ sky130_fd_sc_hd__and3b_1
X_6015_ _2766_ _2767_ VGND VGND VPWR VPWR _2768_ sky130_fd_sc_hd__nor2_1
XFILLER_0_118_70 VPWR VGND VPWR VGND sky130_ef_sc_hd__decap_12
XTAP_1318 VGND VPWR sky130_fd_sc_hd__tapvpwrvgnd_1
XTAP_1329 VGND VPWR sky130_fd_sc_hd__tapvpwrvgnd_1
XTAP_1307 VGND VPWR sky130_fd_sc_hd__tapvpwrvgnd_1
X_6917_ _3441_ VGND VGND VPWR VPWR _0778_ sky130_fd_sc_hd__clkbuf_1
X_7897_ clknet_leaf_83_clk _0802_ net948 VGND VGND VPWR VPWR u_pe_array.u_fifo1.count\[3\]
+ sky130_fd_sc_hd__dfrtp_2
X_6848_ _3402_ VGND VGND VPWR VPWR _0748_ sky130_fd_sc_hd__clkbuf_1
XFILLER_0_17_230 VGND VGND VPWR VPWR sky130_fd_sc_hd__fill_1
X_6779_ _3356_ net834 _3352_ VGND VGND VPWR VPWR _3357_ sky130_fd_sc_hd__mux2_1
XFILLER_0_32_222 VGND VGND VPWR VPWR sky130_fd_sc_hd__decap_3
XFILLER_0_60_553 VGND VGND VPWR VPWR sky130_fd_sc_hd__decap_4
Xhold381 _0301_ VGND VGND VPWR VPWR net455 sky130_fd_sc_hd__dlygate4sd3_1
Xhold370 u_pe_array.g_pe_row\[0\].g_pe_col\[2\].u_pe.move_reg\[8\] VGND VGND VPWR
+ VPWR net444 sky130_fd_sc_hd__dlygate4sd3_1
Xhold392 u_pe_array.g_pe_row\[0\].g_pe_col\[3\].u_pe.psum_out\[0\] VGND VGND VPWR
+ VPWR net466 sky130_fd_sc_hd__dlygate4sd3_1
XFILLER_0_83_601 VGND VGND VPWR VPWR sky130_fd_sc_hd__decap_3
XFILLER_0_68_653 VGND VGND VPWR VPWR sky130_fd_sc_hd__decap_6
XFILLER_0_83_612 VGND VGND VPWR VPWR sky130_fd_sc_hd__fill_1
XFILLER_0_68_686 VGND VGND VPWR VPWR sky130_fd_sc_hd__fill_1
XFILLER_0_24_701 VGND VGND VPWR VPWR sky130_fd_sc_hd__decap_4
XFILLER_0_63_391 VGND VGND VPWR VPWR sky130_fd_sc_hd__fill_1
XFILLER_0_3_617 VPWR VGND VPWR VGND sky130_ef_sc_hd__decap_12
XFILLER_0_23_222 VGND VGND VPWR VPWR sky130_fd_sc_hd__fill_2
XFILLER_0_36_594 VGND VGND VPWR VPWR sky130_fd_sc_hd__fill_1
XFILLER_0_106_471 VGND VGND VPWR VPWR sky130_fd_sc_hd__fill_2
XFILLER_0_23_277 VGND VGND VPWR VPWR sky130_fd_sc_hd__decap_3
X_4130_ u_pe_array.act_from_right\[13\]\[2\] net627 _0963_ VGND VGND VPWR VPWR _1306_
+ sky130_fd_sc_hd__mux2_1
X_4061_ _1257_ _1258_ net914 _1006_ VGND VGND VPWR VPWR _0105_ sky130_fd_sc_hd__a2bb2o_1
XFILLER_0_3_69 VPWR VGND VPWR VGND sky130_ef_sc_hd__decap_12
XFILLER_0_78_417 VGND VGND VPWR VPWR sky130_fd_sc_hd__decap_3
X_7820_ clknet_leaf_83_clk _0725_ VGND VGND VPWR VPWR u_pe_array.u_fifo1.buffer\[8\]\[2\]
+ sky130_fd_sc_hd__dfxtp_1
X_7751_ clknet_leaf_52_clk net176 net74 VGND VGND VPWR VPWR u_pe_array.g_pe_row\[0\].g_pe_col\[1\].u_pe.act_val\[1\]
+ sky130_fd_sc_hd__dfrtp_1
X_4963_ _1906_ _1915_ _1914_ VGND VGND VPWR VPWR _1945_ sky130_fd_sc_hd__a21o_1
XFILLER_0_58_141 VGND VGND VPWR VPWR sky130_fd_sc_hd__fill_1
X_6702_ _3287_ _3288_ _3277_ net64 VGND VGND VPWR VPWR _3290_ sky130_fd_sc_hd__a211oi_1
XFILLER_0_73_100 VGND VGND VPWR VPWR sky130_fd_sc_hd__fill_2
X_7682_ clknet_leaf_60_clk _0588_ net74 VGND VGND VPWR VPWR u_pe_array.g_pe_row\[0\].g_pe_col\[3\].u_pe.psum_out\[1\]
+ sky130_fd_sc_hd__dfrtp_1
X_3914_ u_pe_array.g_pe_row\[3\].g_pe_col\[2\].u_pe.move_reg\[10\] _1118_ VGND VGND
+ VPWR VPWR _1149_ sky130_fd_sc_hd__or2_1
X_6633_ u_pe_array.g_pe_row\[0\].g_pe_col\[0\].u_pe.psum_out\[11\] u_pe_array.g_pe_row\[0\].g_pe_col\[0\].u_pe.move_reg\[11\]
+ _3102_ VGND VGND VPWR VPWR _3241_ sky130_fd_sc_hd__mux2_1
XFILLER_0_74_645 VPWR VGND VPWR VGND sky130_ef_sc_hd__decap_12
X_4894_ u_pe_array.act_from_down\[9\]\[11\] _1750_ _1883_ net293 VGND VGND VPWR VPWR
+ _0313_ sky130_fd_sc_hd__a22o_1
XFILLER_0_116_224 VPWR VGND VPWR VGND sky130_ef_sc_hd__decap_12
XFILLER_0_104_83 VGND VGND VPWR VPWR sky130_fd_sc_hd__fill_1
X_3845_ u_pe_array.g_pe_row\[3\].g_pe_col\[3\].u_pe.psum_out\[11\] _0988_ VGND VGND
+ VPWR VPWR _1094_ sky130_fd_sc_hd__and2b_1
XFILLER_0_73_177 VGND VGND VPWR VPWR sky130_fd_sc_hd__fill_1
X_6564_ _3174_ _3187_ VGND VGND VPWR VPWR _3190_ sky130_fd_sc_hd__and2b_1
XFILLER_0_104_419 VGND VGND VPWR VPWR sky130_fd_sc_hd__fill_1
XFILLER_0_73_188 VGND VGND VPWR VPWR sky130_fd_sc_hd__decap_4
X_3776_ _1022_ _1030_ _1003_ VGND VGND VPWR VPWR _1032_ sky130_fd_sc_hd__a21o_1
XFILLER_0_6_477 VGND VGND VPWR VPWR sky130_fd_sc_hd__decap_4
X_6495_ u_pe_array.g_pe_row\[0\].g_pe_col\[1\].u_pe.act_val\[0\] _3119_ _2268_ VGND
+ VGND VPWR VPWR _3127_ sky130_fd_sc_hd__a21bo_1
X_5515_ u_pe_array.u_fifo2.buffer\[3\]\[5\] _2331_ _2332_ u_pe_array.u_fifo2.buffer\[2\]\[5\]
+ _2374_ VGND VGND VPWR VPWR _2375_ sky130_fd_sc_hd__a221o_1
XFILLER_0_42_542 VGND VGND VPWR VPWR sky130_fd_sc_hd__decap_6
XFILLER_0_73_3 VGND VGND VPWR VPWR sky130_fd_sc_hd__decap_6
XFILLER_0_42_597 VGND VGND VPWR VPWR sky130_fd_sc_hd__fill_1
X_5446_ _2291_ net903 _1158_ VGND VGND VPWR VPWR _2319_ sky130_fd_sc_hd__mux2_1
XFILLER_0_112_485 VGND VGND VPWR VPWR sky130_fd_sc_hd__fill_2
X_5377_ _2268_ _1728_ _0931_ VGND VGND VPWR VPWR _2269_ sky130_fd_sc_hd__mux2_1
XFILLER_0_100_636 VGND VGND VPWR VPWR sky130_fd_sc_hd__decap_4
XFILLER_0_1_193 VPWR VGND VPWR VGND sky130_ef_sc_hd__decap_12
X_7116_ clknet_leaf_4_clk _0022_ net69 VGND VGND VPWR VPWR u_pe_array.act_from_down\[11\]\[5\]
+ sky130_fd_sc_hd__dfrtp_1
X_4328_ _1466_ VGND VGND VPWR VPWR _0164_ sky130_fd_sc_hd__clkbuf_1
X_4259_ u_pe_array.g_pe_row\[3\].g_pe_col\[1\].u_pe.psum_out\[10\] _1399_ _1406_ _1410_
+ VGND VGND VPWR VPWR _1413_ sky130_fd_sc_hd__a2bb2o_1
X_7047_ net685 _3360_ _3514_ VGND VGND VPWR VPWR _3519_ sky130_fd_sc_hd__mux2_1
XTAP_1104 VGND VPWR sky130_fd_sc_hd__tapvpwrvgnd_1
XTAP_1137 VGND VPWR sky130_fd_sc_hd__tapvpwrvgnd_1
XTAP_1126 VGND VPWR sky130_fd_sc_hd__tapvpwrvgnd_1
XTAP_1115 VGND VPWR sky130_fd_sc_hd__tapvpwrvgnd_1
XTAP_1159 VGND VPWR sky130_fd_sc_hd__tapvpwrvgnd_1
XTAP_1148 VGND VPWR sky130_fd_sc_hd__tapvpwrvgnd_1
XFILLER_0_49_163 VGND VGND VPWR VPWR sky130_fd_sc_hd__decap_4
XFILLER_0_37_358 VGND VGND VPWR VPWR sky130_fd_sc_hd__fill_1
XFILLER_0_92_475 VGND VGND VPWR VPWR sky130_fd_sc_hd__fill_1
XFILLER_0_52_306 VGND VGND VPWR VPWR sky130_fd_sc_hd__fill_2
XFILLER_0_80_637 VGND VGND VPWR VPWR sky130_fd_sc_hd__decap_3
XFILLER_0_45_391 VGND VGND VPWR VPWR sky130_fd_sc_hd__fill_1
XFILLER_0_33_564 VGND VGND VPWR VPWR sky130_fd_sc_hd__decap_3
XFILLER_0_60_372 VGND VGND VPWR VPWR sky130_fd_sc_hd__fill_1
XFILLER_0_109_39 VPWR VGND VPWR VGND sky130_ef_sc_hd__decap_12
XFILLER_0_18_15 VPWR VGND VPWR VGND sky130_ef_sc_hd__decap_12
XFILLER_0_87_225 VGND VGND VPWR VPWR sky130_fd_sc_hd__fill_1
XTAP_1660 VGND VPWR sky130_fd_sc_hd__tapvpwrvgnd_1
XTAP_1693 VGND VPWR sky130_fd_sc_hd__tapvpwrvgnd_1
XTAP_1682 VGND VPWR sky130_fd_sc_hd__tapvpwrvgnd_1
XTAP_1671 VGND VPWR sky130_fd_sc_hd__tapvpwrvgnd_1
XFILLER_0_56_645 VPWR VGND VPWR VGND sky130_ef_sc_hd__decap_12
XFILLER_0_7_219 VGND VGND VPWR VPWR sky130_fd_sc_hd__decap_4
XFILLER_0_43_306 VGND VGND VPWR VPWR sky130_fd_sc_hd__fill_1
XFILLER_0_83_497 VGND VGND VPWR VPWR sky130_fd_sc_hd__decap_6
X_3630_ u_pe_array.act_from_up\[14\]\[2\] _0869_ _0854_ VGND VGND VPWR VPWR _0922_
+ sky130_fd_sc_hd__and3_2
XFILLER_0_24_531 VGND VGND VPWR VPWR sky130_fd_sc_hd__fill_1
X_3561_ _0860_ _0855_ VGND VGND VPWR VPWR _0869_ sky130_fd_sc_hd__nand2_4
X_5300_ _2194_ _2201_ VGND VGND VPWR VPWR _2202_ sky130_fd_sc_hd__nand2_1
XFILLER_0_3_447 VGND VGND VPWR VPWR sky130_fd_sc_hd__fill_1
XFILLER_0_59_77 VPWR VGND VPWR VGND sky130_ef_sc_hd__decap_12
XFILLER_0_11_225 VGND VGND VPWR VPWR sky130_fd_sc_hd__decap_6
X_6280_ net330 _2006_ _2009_ _2977_ VGND VGND VPWR VPWR _0605_ sky130_fd_sc_hd__a22o_1
X_5231_ net2 u_pe_array.act_from_left\[7\]\[1\] _0963_ VGND VGND VPWR VPWR _2149_
+ sky130_fd_sc_hd__mux2_1
X_5162_ _2085_ _2099_ _2100_ VGND VGND VPWR VPWR _2101_ sky130_fd_sc_hd__a21o_1
X_5093_ u_pe_array.g_pe_row\[2\].g_pe_col\[0\].u_pe.act_val\[2\] VGND VGND VPWR VPWR
+ _2037_ sky130_fd_sc_hd__inv_2
X_4113_ net75 _1167_ _1169_ _1296_ VGND VGND VPWR VPWR _0119_ sky130_fd_sc_hd__a22o_1
X_4044_ _1242_ VGND VGND VPWR VPWR _1243_ sky130_fd_sc_hd__inv_2
X_7803_ clknet_leaf_43_clk net231 net946 VGND VGND VPWR VPWR u_pe_array.g_pe_row\[0\].g_pe_col\[0\].u_pe.move_reg\[11\]
+ sky130_fd_sc_hd__dfrtp_1
XPHY_209 VGND VGND VPWR VPWR sky130_fd_sc_hd__decap_3
X_7734_ clknet_leaf_73_clk _0640_ net13 VGND VGND VPWR VPWR u_pe_array.g_pe_row\[0\].g_pe_col\[2\].u_pe.psum_out\[12\]
+ sky130_fd_sc_hd__dfrtp_1
X_5995_ _2748_ _2749_ net901 _1007_ VGND VGND VPWR VPWR _0548_ sky130_fd_sc_hd__a2bb2o_1
XFILLER_0_115_93 VPWR VGND VPWR VGND sky130_ef_sc_hd__decap_12
X_4946_ u_pe_array.g_pe_row\[2\].g_pe_col\[1\].u_pe.act_val\[4\] _1105_ VGND VGND
+ VPWR VPWR _1929_ sky130_fd_sc_hd__and2b_1
X_4877_ u_pe_array.g_pe_row\[2\].g_pe_col\[1\].u_pe.psum_out\[11\] u_pe_array.g_pe_row\[2\].g_pe_col\[1\].u_pe.move_reg\[11\]
+ _1867_ VGND VGND VPWR VPWR _1880_ sky130_fd_sc_hd__mux2_1
X_7665_ clknet_leaf_63_clk _0571_ net74 VGND VGND VPWR VPWR u_pe_array.act_from_right\[2\]\[10\]
+ sky130_fd_sc_hd__dfrtp_1
X_7596_ clknet_leaf_45_clk _0502_ net947 VGND VGND VPWR VPWR u_pe_array.g_pe_row\[1\].g_pe_col\[1\].u_pe.psum_out\[10\]
+ sky130_fd_sc_hd__dfrtp_2
X_3828_ u_pe_array.g_pe_row\[3\].g_pe_col\[3\].u_pe.psum_out\[9\] _0988_ VGND VGND
+ VPWR VPWR _1079_ sky130_fd_sc_hd__or2_1
XFILLER_0_46_188 VGND VGND VPWR VPWR sky130_fd_sc_hd__decap_8
X_6616_ net428 _1731_ _1734_ _3232_ VGND VGND VPWR VPWR _0686_ sky130_fd_sc_hd__a22o_1
X_6547_ _3136_ _3145_ _3144_ VGND VGND VPWR VPWR _3175_ sky130_fd_sc_hd__a21o_1
XFILLER_0_70_670 VGND VGND VPWR VPWR sky130_fd_sc_hd__decap_8
X_3759_ u_pe_array.g_pe_row\[3\].g_pe_col\[3\].u_pe.psum_out\[2\] _0999_ _1015_ VGND
+ VGND VPWR VPWR _1016_ sky130_fd_sc_hd__a21oi_1
XFILLER_0_100_400 VGND VGND VPWR VPWR sky130_fd_sc_hd__fill_1
X_6478_ u_pe_array.act_from_down\[1\]\[9\] _0866_ _0940_ net236 VGND VGND VPWR VPWR
+ _0665_ sky130_fd_sc_hd__a22o_1
X_5429_ u_pe_array.g_pe_row\[1\].g_pe_col\[2\].u_pe.psum_out\[11\] _1112_ _1109_ _2308_
+ VGND VGND VPWR VPWR _2309_ sky130_fd_sc_hd__o211a_1
XFILLER_0_69_225 VGND VGND VPWR VPWR sky130_fd_sc_hd__decap_6
XFILLER_0_84_217 VGND VGND VPWR VPWR sky130_fd_sc_hd__fill_2
XFILLER_0_38_623 VGND VGND VPWR VPWR sky130_fd_sc_hd__fill_1
XFILLER_0_84_239 VGND VGND VPWR VPWR sky130_fd_sc_hd__fill_2
XFILLER_0_65_453 VGND VGND VPWR VPWR sky130_fd_sc_hd__fill_1
XFILLER_0_38_667 VPWR VGND VPWR VGND sky130_ef_sc_hd__decap_12
XFILLER_0_20_27 VGND VGND VPWR VPWR sky130_fd_sc_hd__fill_1
XFILLER_0_20_49 VGND VGND VPWR VPWR sky130_fd_sc_hd__fill_1
XFILLER_0_40_309 VGND VGND VPWR VPWR sky130_fd_sc_hd__fill_2
XFILLER_0_103_260 VGND VGND VPWR VPWR sky130_fd_sc_hd__decap_6
XFILLER_0_60_191 VGND VGND VPWR VPWR sky130_fd_sc_hd__fill_1
XTAP_707 VGND VPWR sky130_fd_sc_hd__tapvpwrvgnd_1
XTAP_718 VGND VPWR sky130_fd_sc_hd__tapvpwrvgnd_1
XTAP_729 VGND VPWR sky130_fd_sc_hd__tapvpwrvgnd_1
Xmax_cap2 _2177_ VGND VGND VPWR VPWR net941 sky130_fd_sc_hd__buf_1
X_4800_ _1820_ _1821_ VGND VGND VPWR VPWR _1822_ sky130_fd_sc_hd__and2_1
X_5780_ _2579_ _2583_ VGND VGND VPWR VPWR _2584_ sky130_fd_sc_hd__or2_1
XTAP_1490 VGND VPWR sky130_fd_sc_hd__tapvpwrvgnd_1
XFILLER_0_56_475 VGND VGND VPWR VPWR sky130_fd_sc_hd__fill_1
XFILLER_0_56_453 VGND VGND VPWR VPWR sky130_fd_sc_hd__decap_8
X_4731_ u_pe_array.g_pe_row\[2\].g_pe_col\[2\].u_pe.psum_out\[1\] _1757_ VGND VGND
+ VPWR VPWR _1759_ sky130_fd_sc_hd__nand2_1
XFILLER_0_29_667 VGND VGND VPWR VPWR sky130_fd_sc_hd__decap_4
XFILLER_0_83_272 VGND VGND VPWR VPWR sky130_fd_sc_hd__fill_1
X_7450_ clknet_leaf_36_clk _0356_ net951 VGND VGND VPWR VPWR u_pe_array.g_pe_row\[2\].g_pe_col\[0\].u_pe.psum_out\[0\]
+ sky130_fd_sc_hd__dfrtp_1
XFILLER_0_4_701 VGND VGND VPWR VPWR sky130_fd_sc_hd__decap_4
X_4662_ _1716_ _1720_ VGND VGND VPWR VPWR _1721_ sky130_fd_sc_hd__xor2_1
XFILLER_0_9_57 VPWR VGND VPWR VGND sky130_ef_sc_hd__decap_12
X_3613_ _0907_ _0906_ VGND VGND VPWR VPWR _0909_ sky130_fd_sc_hd__nor2_1
X_6401_ u_pe_array.g_pe_row\[0\].g_pe_col\[2\].u_pe.psum_out\[8\] _2130_ VGND VGND
+ VPWR VPWR _3068_ sky130_fd_sc_hd__nand2_1
XFILLER_0_114_569 VGND VGND VPWR VPWR sky130_fd_sc_hd__decap_8
XFILLER_0_114_547 VPWR VGND VPWR VGND sky130_ef_sc_hd__decap_12
XFILLER_0_101_51 VGND VGND VPWR VPWR sky130_fd_sc_hd__decap_4
X_7381_ clknet_leaf_38_clk _0287_ net942 VGND VGND VPWR VPWR u_pe_array.g_pe_row\[2\].g_pe_col\[0\].u_pe.w_out\[0\]
+ sky130_fd_sc_hd__dfrtp_1
XFILLER_0_24_361 VGND VGND VPWR VPWR sky130_fd_sc_hd__decap_3
X_4593_ _1656_ _1657_ VGND VGND VPWR VPWR _1659_ sky130_fd_sc_hd__nand2_1
XFILLER_0_43_169 VGND VGND VPWR VPWR sky130_fd_sc_hd__decap_6
XFILLER_0_3_255 VGND VGND VPWR VPWR sky130_fd_sc_hd__fill_1
X_3544_ u_fsm.cnt\[2\] u_fsm.cnt\[3\] _0851_ VGND VGND VPWR VPWR _0852_ sky130_fd_sc_hd__or3_2
X_6332_ net770 _2586_ _3004_ _0978_ VGND VGND VPWR VPWR _0630_ sky130_fd_sc_hd__a22o_1
X_6263_ _2795_ _2966_ _2967_ _2621_ net590 VGND VGND VPWR VPWR _0598_ sky130_fd_sc_hd__a32o_1
XFILLER_0_12_589 VGND VGND VPWR VPWR sky130_fd_sc_hd__decap_4
X_5214_ u_pe_array.g_pe_row\[1\].g_pe_col\[3\].u_pe.psum_out\[6\] u_pe_array.g_pe_row\[1\].g_pe_col\[3\].u_pe.move_reg\[6\]
+ _2133_ VGND VGND VPWR VPWR _2140_ sky130_fd_sc_hd__mux2_1
X_6194_ _2903_ _2904_ VGND VGND VPWR VPWR _2905_ sky130_fd_sc_hd__xnor2_2
X_5145_ u_pe_array.g_pe_row\[2\].g_pe_col\[0\].u_pe.psum_out\[7\] _1286_ VGND VGND
+ VPWR VPWR _2085_ sky130_fd_sc_hd__nand2_1
XFILLER_0_98_309 VGND VGND VPWR VPWR sky130_fd_sc_hd__decap_6
X_5076_ _2018_ _2019_ _2020_ VGND VGND VPWR VPWR _2022_ sky130_fd_sc_hd__or3_1
X_4027_ net921 _1007_ _1227_ _1021_ VGND VGND VPWR VPWR _0102_ sky130_fd_sc_hd__a22o_1
XFILLER_0_19_111 VGND VGND VPWR VPWR sky130_fd_sc_hd__fill_1
X_5978_ u_pe_array.g_pe_row\[1\].g_pe_col\[0\].u_pe.act_val\[1\] u_pe_array.g_pe_row\[1\].g_pe_col\[0\].u_pe.w_out\[0\]
+ VGND VGND VPWR VPWR _2734_ sky130_fd_sc_hd__nand2_1
X_4929_ _1911_ _1913_ VGND VGND VPWR VPWR _1914_ sky130_fd_sc_hd__nor2_1
XFILLER_0_81_209 VGND VGND VPWR VPWR sky130_fd_sc_hd__fill_2
X_7717_ clknet_leaf_61_clk _0623_ net74 VGND VGND VPWR VPWR u_pe_array.g_pe_row\[0\].g_pe_col\[2\].u_pe.move_reg\[8\]
+ sky130_fd_sc_hd__dfrtp_1
XFILLER_0_35_637 VPWR VGND VPWR VGND sky130_ef_sc_hd__decap_12
X_7648_ clknet_leaf_73_clk _0554_ net72 VGND VGND VPWR VPWR u_pe_array.g_pe_row\[1\].g_pe_col\[0\].u_pe.psum_out\[8\]
+ sky130_fd_sc_hd__dfrtp_2
XFILLER_0_105_503 VGND VGND VPWR VPWR sky130_fd_sc_hd__fill_1
XFILLER_0_7_561 VPWR VGND VPWR VGND sky130_ef_sc_hd__decap_12
XFILLER_0_117_396 VGND VGND VPWR VPWR sky130_fd_sc_hd__decap_4
X_7579_ clknet_leaf_67_clk net84 net947 VGND VGND VPWR VPWR u_pe_array.g_pe_row\[1\].g_pe_col\[1\].u_pe.move_reg\[6\]
+ sky130_fd_sc_hd__dfrtp_1
XFILLER_0_43_692 VPWR VGND VPWR VGND sky130_ef_sc_hd__decap_12
XFILLER_0_100_296 VGND VGND VPWR VPWR sky130_fd_sc_hd__decap_6
XFILLER_0_106_29 VPWR VGND VPWR VGND sky130_ef_sc_hd__decap_12
XFILLER_0_15_27 VPWR VGND VPWR VGND sky130_ef_sc_hd__decap_12
XFILLER_0_108_341 VGND VGND VPWR VPWR sky130_fd_sc_hd__fill_1
XFILLER_0_65_272 VGND VGND VPWR VPWR sky130_fd_sc_hd__fill_1
XFILLER_0_53_434 VGND VGND VPWR VPWR sky130_fd_sc_hd__fill_1
XFILLER_0_108_385 VGND VGND VPWR VPWR sky130_fd_sc_hd__fill_1
XFILLER_0_108_363 VGND VGND VPWR VPWR sky130_fd_sc_hd__fill_1
XFILLER_0_65_294 VGND VGND VPWR VPWR sky130_fd_sc_hd__fill_1
XFILLER_0_25_169 VGND VGND VPWR VPWR sky130_fd_sc_hd__decap_3
XFILLER_0_111_528 VPWR VGND VPWR VGND sky130_ef_sc_hd__decap_12
XFILLER_0_21_331 VGND VGND VPWR VPWR sky130_fd_sc_hd__decap_4
XFILLER_0_33_191 VGND VGND VPWR VPWR sky130_fd_sc_hd__decap_4
XFILLER_0_0_225 VPWR VGND VPWR VGND sky130_ef_sc_hd__decap_12
XTAP_504 VGND VPWR sky130_fd_sc_hd__tapvpwrvgnd_1
XTAP_515 VGND VPWR sky130_fd_sc_hd__tapvpwrvgnd_1
XTAP_526 VGND VPWR sky130_fd_sc_hd__tapvpwrvgnd_1
XTAP_537 VGND VPWR sky130_fd_sc_hd__tapvpwrvgnd_1
XTAP_548 VGND VPWR sky130_fd_sc_hd__tapvpwrvgnd_1
XTAP_559 VGND VPWR sky130_fd_sc_hd__tapvpwrvgnd_1
X_6950_ u_pe_array.u_fifo1.wr_ptr\[2\] _3459_ VGND VGND VPWR VPWR _3460_ sky130_fd_sc_hd__and2_1
XFILLER_0_88_342 VPWR VGND VPWR VGND sky130_ef_sc_hd__decap_12
XFILLER_0_72_11 VGND VGND VPWR VPWR sky130_fd_sc_hd__fill_2
X_5901_ net157 _1159_ _2658_ _1476_ VGND VGND VPWR VPWR _0529_ sky130_fd_sc_hd__a22o_1
X_6881_ _3420_ VGND VGND VPWR VPWR _0763_ sky130_fd_sc_hd__clkbuf_1
XFILLER_0_76_548 VGND VGND VPWR VPWR sky130_fd_sc_hd__fill_1
X_5832_ u_pe_array.g_pe_row\[1\].g_pe_col\[0\].u_pe.act_val\[0\] _1118_ VGND VGND
+ VPWR VPWR _2628_ sky130_fd_sc_hd__or2_1
XFILLER_0_118_105 VGND VGND VPWR VPWR sky130_fd_sc_hd__decap_3
X_5763_ u_pe_array.g_pe_row\[1\].g_pe_col\[1\].u_pe.act_val\[5\] u_pe_array.g_pe_row\[1\].g_pe_col\[1\].u_pe.w_out\[0\]
+ _2555_ VGND VGND VPWR VPWR _2568_ sky130_fd_sc_hd__and3_1
X_7502_ clknet_leaf_41_clk _0408_ net946 VGND VGND VPWR VPWR u_pe_array.g_pe_row\[1\].g_pe_col\[3\].u_pe.psum_out\[11\]
+ sky130_fd_sc_hd__dfrtp_1
X_4714_ net371 _1310_ _1483_ net374 VGND VGND VPWR VPWR _0267_ sky130_fd_sc_hd__a22o_1
X_5694_ net269 _2016_ _1883_ u_pe_array.g_pe_row\[1\].g_pe_col\[1\].u_pe.move_reg\[7\]
+ VGND VGND VPWR VPWR _0486_ sky130_fd_sc_hd__a22o_1
XFILLER_0_112_83 VGND VGND VPWR VPWR sky130_fd_sc_hd__fill_1
X_7433_ clknet_leaf_38_clk net505 net951 VGND VGND VPWR VPWR u_pe_array.act_from_up\[12\]\[9\]
+ sky130_fd_sc_hd__dfrtp_1
XFILLER_0_25_670 VGND VGND VPWR VPWR sky130_fd_sc_hd__fill_2
X_4645_ _1698_ _1700_ _1705_ VGND VGND VPWR VPWR _1706_ sky130_fd_sc_hd__o21ai_1
XFILLER_0_114_377 VGND VGND VPWR VPWR sky130_fd_sc_hd__fill_2
XFILLER_0_97_30 VPWR VGND VPWR VGND sky130_ef_sc_hd__decap_12
Xhold711 u_pe_array.g_pe_row\[1\].g_pe_col\[3\].u_pe.move_reg\[6\] VGND VGND VPWR
+ VPWR net785 sky130_fd_sc_hd__dlygate4sd3_1
Xhold700 u_pe_array.u_fifo2.buffer\[6\]\[2\] VGND VGND VPWR VPWR net774 sky130_fd_sc_hd__dlygate4sd3_1
XFILLER_0_21_92 VGND VGND VPWR VPWR sky130_fd_sc_hd__decap_4
X_4576_ _1626_ _1628_ VGND VGND VPWR VPWR _1643_ sky130_fd_sc_hd__nand2_1
X_7364_ clknet_leaf_7_clk net433 net945 VGND VGND VPWR VPWR u_pe_array.g_pe_row\[2\].g_pe_col\[2\].u_pe.move_reg\[9\]
+ sky130_fd_sc_hd__dfrtp_1
Xhold722 u_pe_array.g_pe_row\[0\].g_pe_col\[3\].u_pe.psum_out\[9\] VGND VGND VPWR
+ VPWR net796 sky130_fd_sc_hd__dlygate4sd3_1
Xhold744 u_pe_array.g_pe_row\[3\].g_pe_col\[3\].u_pe.move_reg\[11\] VGND VGND VPWR
+ VPWR net818 sky130_fd_sc_hd__dlygate4sd3_1
Xhold755 u_pe_array.u_fifo2.count\[2\] VGND VGND VPWR VPWR net829 sky130_fd_sc_hd__dlygate4sd3_1
X_6315_ _2795_ _2988_ _2989_ _2621_ net542 VGND VGND VPWR VPWR _0628_ sky130_fd_sc_hd__a32o_1
Xhold733 u_pe_array.g_pe_row\[1\].g_pe_col\[2\].u_pe.psum_out\[7\] VGND VGND VPWR
+ VPWR net807 sky130_fd_sc_hd__dlygate4sd3_1
Xhold766 u_pe_array.act_from_left\[5\]\[3\] VGND VGND VPWR VPWR net840 sky130_fd_sc_hd__dlygate4sd3_1
Xhold777 u_pe_array.act_from_left\[7\]\[1\] VGND VGND VPWR VPWR net851 sky130_fd_sc_hd__dlygate4sd3_1
X_7295_ clknet_leaf_11_clk _0201_ net950 VGND VGND VPWR VPWR u_pe_array.g_pe_row\[3\].g_pe_col\[0\].u_pe.psum_out\[9\]
+ sky130_fd_sc_hd__dfrtp_2
Xhold788 u_pe_array.act_from_left\[5\]\[1\] VGND VGND VPWR VPWR net862 sky130_fd_sc_hd__dlygate4sd3_1
XFILLER_0_110_561 VPWR VGND VPWR VGND sky130_ef_sc_hd__decap_12
X_6246_ _2795_ _2951_ _2952_ _2621_ net796 VGND VGND VPWR VPWR _0596_ sky130_fd_sc_hd__a32o_1
Xhold799 u_pe_array.g_pe_row\[1\].g_pe_col\[0\].u_pe.psum_out\[3\] VGND VGND VPWR
+ VPWR net873 sky130_fd_sc_hd__dlygate4sd3_1
X_6177_ _2888_ _2889_ VGND VGND VPWR VPWR _2890_ sky130_fd_sc_hd__or2b_1
X_5128_ _2058_ _2059_ _2056_ VGND VGND VPWR VPWR _2070_ sky130_fd_sc_hd__o21ba_1
X_5059_ u_pe_array.g_pe_row\[2\].g_pe_col\[0\].u_pe.act_val\[3\] _1882_ _1873_ net484
+ VGND VGND VPWR VPWR _0346_ sky130_fd_sc_hd__a22o_1
XFILLER_0_109_105 VGND VGND VPWR VPWR sky130_fd_sc_hd__decap_6
XFILLER_0_35_401 VGND VGND VPWR VPWR sky130_fd_sc_hd__decap_8
XFILLER_0_105_300 VGND VGND VPWR VPWR sky130_fd_sc_hd__decap_6
XFILLER_0_105_344 VGND VGND VPWR VPWR sky130_fd_sc_hd__fill_2
XFILLER_0_7_380 VPWR VGND VPWR VGND sky130_ef_sc_hd__decap_12
XFILLER_0_35_478 VPWR VGND VPWR VGND sky130_ef_sc_hd__decap_12
XFILLER_0_22_117 VGND VGND VPWR VPWR sky130_fd_sc_hd__decap_8
XFILLER_0_31_673 VPWR VGND VPWR VGND sky130_ef_sc_hd__decap_12
XFILLER_0_30_194 VGND VGND VPWR VPWR sky130_fd_sc_hd__fill_2
XFILLER_0_26_37 VGND VGND VPWR VPWR sky130_fd_sc_hd__decap_8
Xhold71 u_pe_array.act_from_left\[13\]\[11\] VGND VGND VPWR VPWR net145 sky130_fd_sc_hd__dlygate4sd3_1
Xhold60 u_pe_array.act_from_left\[15\]\[11\] VGND VGND VPWR VPWR net134 sky130_fd_sc_hd__dlygate4sd3_1
Xhold82 _0225_ VGND VGND VPWR VPWR net156 sky130_fd_sc_hd__dlygate4sd3_1
Xhold93 u_pe_array.act_from_left\[5\]\[12\] VGND VGND VPWR VPWR net167 sky130_fd_sc_hd__dlygate4sd3_1
XFILLER_0_97_161 VGND VGND VPWR VPWR sky130_fd_sc_hd__decap_6
XFILLER_0_58_515 VGND VGND VPWR VPWR sky130_fd_sc_hd__decap_4
XFILLER_0_85_334 VGND VGND VPWR VPWR sky130_fd_sc_hd__fill_2
XFILLER_0_116_609 VGND VGND VPWR VPWR sky130_fd_sc_hd__decap_4
XFILLER_0_38_261 VGND VGND VPWR VPWR sky130_fd_sc_hd__decap_4
XFILLER_0_109_661 VGND VGND VPWR VPWR sky130_fd_sc_hd__decap_8
XFILLER_0_38_294 VGND VGND VPWR VPWR sky130_fd_sc_hd__decap_4
XFILLER_0_81_573 VGND VGND VPWR VPWR sky130_fd_sc_hd__decap_4
XFILLER_0_13_106 VGND VGND VPWR VPWR sky130_fd_sc_hd__decap_6
XFILLER_0_14_629 VGND VGND VPWR VPWR sky130_fd_sc_hd__fill_2
XANTENNA_2 _1468_ VGND VGND VPWR VPWR sky130_fd_sc_hd__diode_2
X_4430_ _1487_ _1534_ _1535_ _1356_ net742 VGND VGND VPWR VPWR _0197_ sky130_fd_sc_hd__a32o_1
XFILLER_0_111_325 VGND VGND VPWR VPWR sky130_fd_sc_hd__decap_8
XFILLER_0_67_11 VGND VGND VPWR VPWR sky130_fd_sc_hd__fill_2
XFILLER_0_21_161 VGND VGND VPWR VPWR sky130_fd_sc_hd__decap_6
XFILLER_0_22_695 VGND VGND VPWR VPWR sky130_fd_sc_hd__decap_4
X_4361_ net19 u_pe_array.act_from_up\[12\]\[4\] _0857_ VGND VGND VPWR VPWR _1481_
+ sky130_fd_sc_hd__mux2_1
X_6100_ net32 _2130_ _0931_ VGND VGND VPWR VPWR _2843_ sky130_fd_sc_hd__mux2_1
X_4292_ u_pe_array.g_pe_row\[3\].g_pe_col\[0\].u_pe.act_val\[3\] net62 VGND VGND VPWR
+ VPWR _1439_ sky130_fd_sc_hd__or2_1
XTAP_323 VGND VPWR sky130_fd_sc_hd__tapvpwrvgnd_1
XTAP_312 VGND VPWR sky130_fd_sc_hd__tapvpwrvgnd_1
XTAP_301 VGND VPWR sky130_fd_sc_hd__tapvpwrvgnd_1
X_7080_ _3537_ VGND VGND VPWR VPWR _0845_ sky130_fd_sc_hd__clkbuf_1
X_6031_ _2644_ u_pe_array.g_pe_row\[1\].g_pe_col\[0\].u_pe.psum_out\[6\] _1865_ VGND
+ VGND VPWR VPWR _2782_ sky130_fd_sc_hd__and3_1
XTAP_367 VGND VPWR sky130_fd_sc_hd__tapvpwrvgnd_1
XTAP_356 VGND VPWR sky130_fd_sc_hd__tapvpwrvgnd_1
XTAP_334 VGND VPWR sky130_fd_sc_hd__tapvpwrvgnd_1
XTAP_345 VGND VPWR sky130_fd_sc_hd__tapvpwrvgnd_1
XTAP_389 VGND VPWR sky130_fd_sc_hd__tapvpwrvgnd_1
XTAP_378 VGND VPWR sky130_fd_sc_hd__tapvpwrvgnd_1
XFILLER_0_89_673 VPWR VGND VPWR VGND sky130_ef_sc_hd__decap_12
XPHY_18 VGND VGND VPWR VPWR sky130_fd_sc_hd__decap_3
XPHY_29 VGND VGND VPWR VPWR sky130_fd_sc_hd__decap_3
X_6933_ _0924_ net692 _3446_ VGND VGND VPWR VPWR _3450_ sky130_fd_sc_hd__mux2_1
X_6864_ _3411_ VGND VGND VPWR VPWR _0755_ sky130_fd_sc_hd__clkbuf_1
XFILLER_0_49_559 VGND VGND VPWR VPWR sky130_fd_sc_hd__fill_1
X_5815_ u_pe_array.g_pe_row\[1\].g_pe_col\[1\].u_pe.psum_out\[11\] _1728_ VGND VGND
+ VPWR VPWR _2615_ sky130_fd_sc_hd__and2b_1
XFILLER_0_64_507 VGND VGND VPWR VPWR sky130_fd_sc_hd__decap_3
XFILLER_0_91_337 VGND VGND VPWR VPWR sky130_fd_sc_hd__decap_8
XFILLER_0_91_326 VGND VGND VPWR VPWR sky130_fd_sc_hd__decap_8
XFILLER_0_76_389 VGND VGND VPWR VPWR sky130_fd_sc_hd__decap_4
XFILLER_0_57_581 VGND VGND VPWR VPWR sky130_fd_sc_hd__decap_3
X_6795_ _3366_ _3367_ VGND VGND VPWR VPWR _0730_ sky130_fd_sc_hd__nor2_1
XFILLER_0_8_133 VGND VGND VPWR VPWR sky130_fd_sc_hd__decap_6
X_5746_ _2544_ _2552_ VGND VGND VPWR VPWR _2553_ sky130_fd_sc_hd__nor2_1
XFILLER_0_32_91 VGND VGND VPWR VPWR sky130_fd_sc_hd__fill_1
X_5677_ u_pe_array.g_pe_row\[1\].g_pe_col\[1\].u_pe.psum_out\[11\] u_pe_array.g_pe_row\[1\].g_pe_col\[1\].u_pe.move_reg\[11\]
+ _2133_ VGND VGND VPWR VPWR _2503_ sky130_fd_sc_hd__mux2_1
X_7416_ clknet_leaf_30_clk _0322_ net71 VGND VGND VPWR VPWR u_pe_array.g_pe_row\[2\].g_pe_col\[1\].u_pe.psum_out\[7\]
+ sky130_fd_sc_hd__dfrtp_4
XFILLER_0_114_141 VPWR VGND VPWR VGND sky130_ef_sc_hd__decap_12
X_4628_ _1665_ _1666_ _1677_ _1687_ VGND VGND VPWR VPWR _1690_ sky130_fd_sc_hd__or4_1
XFILLER_0_115_697 VGND VGND VPWR VPWR sky130_fd_sc_hd__decap_8
Xhold530 u_pe_array.g_pe_row\[0\].g_pe_col\[1\].u_pe.psum_out\[11\] VGND VGND VPWR
+ VPWR net604 sky130_fd_sc_hd__dlygate4sd3_1
Xhold563 u_pe_array.act_from_up\[14\]\[3\] VGND VGND VPWR VPWR net637 sky130_fd_sc_hd__dlygate4sd3_1
XFILLER_0_12_161 VGND VGND VPWR VPWR sky130_fd_sc_hd__fill_1
X_7347_ clknet_leaf_103_clk _0253_ net950 VGND VGND VPWR VPWR u_pe_array.act_from_up\[14\]\[5\]
+ sky130_fd_sc_hd__dfrtp_1
Xhold552 u_pe_array.u_fifo2.buffer\[5\]\[5\] VGND VGND VPWR VPWR net626 sky130_fd_sc_hd__dlygate4sd3_1
XFILLER_0_13_673 VPWR VGND VPWR VGND sky130_ef_sc_hd__decap_12
X_4559_ u_pe_array.g_pe_row\[2\].g_pe_col\[3\].u_pe.act_val\[0\] VGND VGND VPWR VPWR
+ _1627_ sky130_fd_sc_hd__inv_2
Xhold541 u_pe_array.u_fifo1.buffer\[3\]\[5\] VGND VGND VPWR VPWR net615 sky130_fd_sc_hd__dlygate4sd3_1
XFILLER_0_40_481 VGND VGND VPWR VPWR sky130_fd_sc_hd__fill_1
X_7278_ clknet_leaf_12_clk _0184_ net942 VGND VGND VPWR VPWR u_pe_array.g_pe_row\[3\].g_pe_col\[0\].u_pe.act_val\[5\]
+ sky130_fd_sc_hd__dfrtp_1
Xhold574 u_pe_array.act_from_up\[6\]\[9\] VGND VGND VPWR VPWR net648 sky130_fd_sc_hd__dlygate4sd3_1
Xhold596 u_pe_array.u_fifo2.buffer\[7\]\[0\] VGND VGND VPWR VPWR net670 sky130_fd_sc_hd__dlygate4sd3_1
Xhold585 u_pe_array.u_fifo1.buffer\[3\]\[3\] VGND VGND VPWR VPWR net659 sky130_fd_sc_hd__dlygate4sd3_1
X_6229_ u_pe_array.g_pe_row\[0\].g_pe_col\[3\].u_pe.psum_out\[7\] VGND VGND VPWR VPWR
+ _2937_ sky130_fd_sc_hd__inv_2
XTAP_890 VGND VPWR sky130_fd_sc_hd__tapvpwrvgnd_1
XFILLER_0_95_610 VGND VGND VPWR VPWR sky130_fd_sc_hd__decap_6
XFILLER_0_82_326 VGND VGND VPWR VPWR sky130_fd_sc_hd__fill_1
XFILLER_0_94_197 VGND VGND VPWR VPWR sky130_fd_sc_hd__fill_2
XFILLER_0_35_275 VGND VGND VPWR VPWR sky130_fd_sc_hd__decap_4
XFILLER_0_35_297 VPWR VGND VPWR VGND sky130_ef_sc_hd__decap_12
XFILLER_0_10_109 VGND VGND VPWR VPWR sky130_fd_sc_hd__decap_4
XFILLER_0_31_481 VGND VGND VPWR VPWR sky130_fd_sc_hd__fill_2
Xoutput61 net61 VGND VGND VPWR VPWR psum_out1[9] sky130_fd_sc_hd__clkbuf_4
Xoutput50 net50 VGND VGND VPWR VPWR psum_out1[10] sky130_fd_sc_hd__buf_2
XFILLER_0_37_69 VGND VGND VPWR VPWR sky130_fd_sc_hd__decap_4
XFILLER_0_77_109 VGND VGND VPWR VPWR sky130_fd_sc_hd__decap_3
X_3930_ _1120_ net757 _1159_ VGND VGND VPWR VPWR _1161_ sky130_fd_sc_hd__mux2_1
XFILLER_0_53_57 VPWR VGND VPWR VGND sky130_ef_sc_hd__decap_12
X_3861_ _1105_ _1106_ _0931_ VGND VGND VPWR VPWR _1107_ sky130_fd_sc_hd__mux2_1
X_6580_ u_pe_array.g_pe_row\[0\].g_pe_col\[1\].u_pe.psum_out\[8\] u_pe_array.g_pe_row\[0\].g_pe_col\[1\].u_pe.psum_out\[9\]
+ _2268_ VGND VGND VPWR VPWR _3205_ sky130_fd_sc_hd__and3_1
X_3792_ _1044_ _1045_ VGND VGND VPWR VPWR _1046_ sky130_fd_sc_hd__or2_1
X_5600_ _2443_ _2444_ VGND VGND VPWR VPWR _2445_ sky130_fd_sc_hd__and2_1
XFILLER_0_54_551 VGND VGND VPWR VPWR sky130_fd_sc_hd__decap_8
XFILLER_0_5_125 VPWR VGND VPWR VGND sky130_ef_sc_hd__decap_12
X_5531_ u_pe_array.g_pe_row\[1\].g_pe_col\[2\].u_pe.act_val\[0\] u_pe_array.g_pe_row\[1\].g_pe_col\[2\].u_pe.psum_out\[1\]
+ _1597_ VGND VGND VPWR VPWR _2382_ sky130_fd_sc_hd__and3_1
XFILLER_0_5_169 VPWR VGND VPWR VGND sky130_ef_sc_hd__decap_12
XFILLER_0_41_223 VGND VGND VPWR VPWR sky130_fd_sc_hd__fill_1
XFILLER_0_111_111 VGND VGND VPWR VPWR sky130_fd_sc_hd__fill_1
X_5462_ u_pe_array.u_fifo2.rd_ptr\[3\] u_pe_array.u_fifo2.rd_ptr\[2\] u_pe_array.u_fifo2.rd_ptr\[1\]
+ u_pe_array.u_fifo2.rd_ptr\[0\] VGND VGND VPWR VPWR _2327_ sky130_fd_sc_hd__and4b_2
X_7201_ clknet_leaf_95_clk _0107_ net950 VGND VGND VPWR VPWR u_pe_array.g_pe_row\[3\].g_pe_col\[2\].u_pe.psum_out\[10\]
+ sky130_fd_sc_hd__dfrtp_4
XFILLER_0_41_234 VGND VGND VPWR VPWR sky130_fd_sc_hd__decap_3
XFILLER_0_112_645 VPWR VGND VPWR VGND sky130_ef_sc_hd__decap_12
X_5393_ _2281_ VGND VGND VPWR VPWR _0414_ sky130_fd_sc_hd__clkbuf_1
X_4413_ u_pe_array.g_pe_row\[3\].g_pe_col\[0\].u_pe.psum_out\[4\] _1519_ VGND VGND
+ VPWR VPWR _1520_ sky130_fd_sc_hd__xnor2_1
XFILLER_0_10_610 VGND VGND VPWR VPWR sky130_fd_sc_hd__decap_3
XFILLER_0_1_331 VGND VGND VPWR VPWR sky130_fd_sc_hd__fill_2
XFILLER_0_41_289 VGND VGND VPWR VPWR sky130_fd_sc_hd__decap_4
X_7132_ clknet_leaf_21_clk _0038_ net943 VGND VGND VPWR VPWR u_pe_array.g_pe_row\[3\].g_pe_col\[3\].u_pe.move_reg\[8\]
+ sky130_fd_sc_hd__dfrtp_1
X_4344_ _1475_ VGND VGND VPWR VPWR _0171_ sky130_fd_sc_hd__clkbuf_1
XFILLER_0_111_199 VGND VGND VPWR VPWR sky130_fd_sc_hd__decap_4
X_7063_ _3527_ VGND VGND VPWR VPWR _0838_ sky130_fd_sc_hd__clkbuf_1
XFILLER_0_94_53 VPWR VGND VPWR VGND sky130_ef_sc_hd__decap_12
X_4275_ u_pe_array.g_pe_row\[1\].g_pe_col\[3\].u_pe.w_out\[1\] VGND VGND VPWR VPWR
+ _1426_ sky130_fd_sc_hd__clkbuf_8
X_6014_ u_pe_array.g_pe_row\[1\].g_pe_col\[0\].u_pe.psum_out\[3\] _2752_ _2753_ VGND
+ VGND VPWR VPWR _2767_ sky130_fd_sc_hd__a21boi_1
XFILLER_0_118_82 VGND VGND VPWR VPWR sky130_fd_sc_hd__fill_2
XFILLER_0_96_429 VGND VGND VPWR VPWR sky130_fd_sc_hd__fill_2
XFILLER_0_89_481 VGND VGND VPWR VPWR sky130_fd_sc_hd__fill_1
XTAP_1319 VGND VPWR sky130_fd_sc_hd__tapvpwrvgnd_1
XTAP_1308 VGND VPWR sky130_fd_sc_hd__tapvpwrvgnd_1
XFILLER_0_77_654 VPWR VGND VPWR VGND sky130_ef_sc_hd__decap_12
X_7896_ clknet_leaf_83_clk _0801_ net948 VGND VGND VPWR VPWR u_pe_array.u_fifo1.count\[2\]
+ sky130_fd_sc_hd__dfrtp_4
X_6916_ _0920_ net750 _3439_ VGND VGND VPWR VPWR _3441_ sky130_fd_sc_hd__mux2_1
XFILLER_0_76_153 VGND VGND VPWR VPWR sky130_fd_sc_hd__decap_6
X_6847_ net653 _0920_ _3400_ VGND VGND VPWR VPWR _3402_ sky130_fd_sc_hd__mux2_1
XFILLER_0_43_90 VGND VGND VPWR VPWR sky130_fd_sc_hd__decap_4
X_6778_ u_pe_array.act_from_up\[12\]\[2\] _0869_ _0854_ VGND VGND VPWR VPWR _3356_
+ sky130_fd_sc_hd__and3_4
XFILLER_0_17_220 VGND VGND VPWR VPWR sky130_fd_sc_hd__decap_4
X_5729_ u_pe_array.g_pe_row\[1\].g_pe_col\[1\].u_pe.psum_out\[3\] _2536_ VGND VGND
+ VPWR VPWR _2537_ sky130_fd_sc_hd__xor2_1
XFILLER_0_115_483 VGND VGND VPWR VPWR sky130_fd_sc_hd__fill_2
XFILLER_0_32_245 VGND VGND VPWR VPWR sky130_fd_sc_hd__decap_6
XFILLER_0_20_429 VGND VGND VPWR VPWR sky130_fd_sc_hd__fill_2
Xhold360 u_pe_array.act_from_down\[9\]\[11\] VGND VGND VPWR VPWR net434 sky130_fd_sc_hd__dlygate4sd3_1
Xhold371 u_pe_array.g_pe_row\[2\].g_pe_col\[3\].u_pe.psum_out\[0\] VGND VGND VPWR
+ VPWR net445 sky130_fd_sc_hd__dlygate4sd3_1
Xhold382 u_pe_array.act_from_up\[4\]\[11\] VGND VGND VPWR VPWR net456 sky130_fd_sc_hd__dlygate4sd3_1
Xhold393 u_pe_array.act_from_down\[11\]\[9\] VGND VGND VPWR VPWR net467 sky130_fd_sc_hd__dlygate4sd3_1
XFILLER_0_99_234 VGND VGND VPWR VPWR sky130_fd_sc_hd__decap_8
XFILLER_0_99_223 VGND VGND VPWR VPWR sky130_fd_sc_hd__fill_1
XFILLER_0_114_29 VPWR VGND VPWR VGND sky130_ef_sc_hd__decap_12
XFILLER_0_68_643 VGND VGND VPWR VPWR sky130_fd_sc_hd__fill_1
XFILLER_0_67_142 VGND VGND VPWR VPWR sky130_fd_sc_hd__fill_1
XFILLER_0_28_529 VGND VGND VPWR VPWR sky130_fd_sc_hd__decap_3
XFILLER_0_83_668 VGND VGND VPWR VPWR sky130_fd_sc_hd__decap_4
XFILLER_0_55_337 VGND VGND VPWR VPWR sky130_fd_sc_hd__decap_6
XFILLER_0_82_189 VGND VGND VPWR VPWR sky130_fd_sc_hd__decap_6
XFILLER_0_36_584 VGND VGND VPWR VPWR sky130_fd_sc_hd__decap_4
Xclkbuf_leaf_102_clk clknet_3_1__leaf_clk VGND VGND VPWR VPWR clknet_leaf_102_clk
+ sky130_fd_sc_hd__clkbuf_16
XFILLER_0_3_629 VPWR VGND VPWR VGND sky130_ef_sc_hd__decap_12
XFILLER_0_2_139 VGND VGND VPWR VPWR sky130_fd_sc_hd__fill_1
XFILLER_0_3_15 VPWR VGND VPWR VGND sky130_ef_sc_hd__decap_12
X_4060_ _1248_ _1251_ _1256_ _1003_ VGND VGND VPWR VPWR _1258_ sky130_fd_sc_hd__a31o_1
X_4962_ _1941_ _1943_ VGND VGND VPWR VPWR _1944_ sky130_fd_sc_hd__xnor2_1
X_7750_ clknet_leaf_51_clk net470 net74 VGND VGND VPWR VPWR u_pe_array.g_pe_row\[0\].g_pe_col\[1\].u_pe.act_val\[0\]
+ sky130_fd_sc_hd__dfrtp_2
X_6701_ _3277_ net64 _3287_ _3288_ VGND VGND VPWR VPWR _3289_ sky130_fd_sc_hd__o211a_1
XFILLER_0_80_44 VPWR VGND VPWR VGND sky130_ef_sc_hd__decap_12
X_4893_ _0939_ VGND VGND VPWR VPWR _1883_ sky130_fd_sc_hd__buf_6
X_7681_ clknet_leaf_61_clk _0587_ net74 VGND VGND VPWR VPWR u_pe_array.g_pe_row\[0\].g_pe_col\[3\].u_pe.psum_out\[0\]
+ sky130_fd_sc_hd__dfrtp_1
X_3913_ _1148_ VGND VGND VPWR VPWR _0067_ sky130_fd_sc_hd__clkbuf_1
XFILLER_0_46_304 VGND VGND VPWR VPWR sky130_fd_sc_hd__decap_4
X_3844_ _1091_ _1093_ net857 _1006_ VGND VGND VPWR VPWR _0053_ sky130_fd_sc_hd__a2bb2o_1
XFILLER_0_74_657 VPWR VGND VPWR VGND sky130_ef_sc_hd__decap_12
X_6632_ net479 _1731_ _1734_ _3240_ VGND VGND VPWR VPWR _0694_ sky130_fd_sc_hd__a22o_1
XFILLER_0_58_197 VGND VGND VPWR VPWR sky130_fd_sc_hd__decap_6
XFILLER_0_116_236 VPWR VGND VPWR VGND sky130_ef_sc_hd__decap_12
XFILLER_0_6_412 VGND VGND VPWR VPWR sky130_fd_sc_hd__decap_8
XFILLER_0_27_540 VGND VGND VPWR VPWR sky130_fd_sc_hd__decap_4
X_6563_ _1092_ _3188_ _3189_ _1005_ net784 VGND VGND VPWR VPWR _0676_ sky130_fd_sc_hd__a32o_1
X_3775_ _1022_ _1030_ VGND VGND VPWR VPWR _1031_ sky130_fd_sc_hd__nor2_1
X_6494_ u_pe_array.g_pe_row\[0\].g_pe_col\[1\].u_pe.psum_out\[1\] _3122_ _3125_ VGND
+ VGND VPWR VPWR _3126_ sky130_fd_sc_hd__a21bo_1
X_5514_ u_pe_array.u_fifo2.buffer\[5\]\[5\] _2333_ _2334_ u_pe_array.u_fifo2.buffer\[6\]\[5\]
+ _2335_ VGND VGND VPWR VPWR _2374_ sky130_fd_sc_hd__a221o_1
X_5445_ _2318_ VGND VGND VPWR VPWR _0429_ sky130_fd_sc_hd__clkbuf_1
XFILLER_0_112_475 VGND VGND VPWR VPWR sky130_fd_sc_hd__fill_1
XFILLER_0_1_161 VGND VGND VPWR VPWR sky130_fd_sc_hd__decap_6
X_5376_ u_pe_array.g_pe_row\[0\].g_pe_col\[1\].u_pe.w_out\[1\] VGND VGND VPWR VPWR
+ _2268_ sky130_fd_sc_hd__buf_6
X_7115_ clknet_leaf_19_clk _0021_ net70 VGND VGND VPWR VPWR u_pe_array.act_from_down\[11\]\[4\]
+ sky130_fd_sc_hd__dfrtp_1
X_4327_ net51 _1465_ _1116_ VGND VGND VPWR VPWR _1466_ sky130_fd_sc_hd__mux2_1
X_4258_ _1033_ _1411_ _1412_ _1356_ net897 VGND VGND VPWR VPWR _0148_ sky130_fd_sc_hd__a32o_1
X_7046_ _3518_ VGND VGND VPWR VPWR _0830_ sky130_fd_sc_hd__clkbuf_1
X_4189_ _1348_ _1349_ VGND VGND VPWR VPWR _1350_ sky130_fd_sc_hd__and2_1
XTAP_1105 VGND VPWR sky130_fd_sc_hd__tapvpwrvgnd_1
XTAP_1138 VGND VPWR sky130_fd_sc_hd__tapvpwrvgnd_1
XTAP_1127 VGND VPWR sky130_fd_sc_hd__tapvpwrvgnd_1
XTAP_1116 VGND VPWR sky130_fd_sc_hd__tapvpwrvgnd_1
XTAP_1149 VGND VPWR sky130_fd_sc_hd__tapvpwrvgnd_1
XFILLER_0_64_101 VPWR VGND VPWR VGND sky130_ef_sc_hd__decap_12
XFILLER_0_107_203 VPWR VGND VPWR VGND sky130_ef_sc_hd__decap_12
X_7879_ clknet_leaf_99_clk _0784_ VGND VGND VPWR VPWR u_pe_array.u_fifo2.buffer\[7\]\[1\]
+ sky130_fd_sc_hd__dfxtp_1
XFILLER_0_107_236 VGND VGND VPWR VPWR sky130_fd_sc_hd__decap_4
XFILLER_0_107_225 VGND VGND VPWR VPWR sky130_fd_sc_hd__decap_3
XFILLER_0_20_248 VGND VGND VPWR VPWR sky130_fd_sc_hd__decap_4
Xhold190 _0355_ VGND VGND VPWR VPWR net264 sky130_fd_sc_hd__dlygate4sd3_1
XFILLER_0_18_27 VGND VGND VPWR VPWR sky130_fd_sc_hd__fill_1
XFILLER_0_34_15 VGND VGND VPWR VPWR sky130_fd_sc_hd__decap_3
XTAP_1650 VGND VPWR sky130_fd_sc_hd__tapvpwrvgnd_1
XTAP_1694 VGND VPWR sky130_fd_sc_hd__tapvpwrvgnd_1
XTAP_1683 VGND VPWR sky130_fd_sc_hd__tapvpwrvgnd_1
XTAP_1661 VGND VPWR sky130_fd_sc_hd__tapvpwrvgnd_1
XTAP_1672 VGND VPWR sky130_fd_sc_hd__tapvpwrvgnd_1
XFILLER_0_95_281 VGND VGND VPWR VPWR sky130_fd_sc_hd__fill_1
XFILLER_0_56_657 VGND VGND VPWR VPWR sky130_fd_sc_hd__decap_3
XFILLER_0_7_209 VGND VGND VPWR VPWR sky130_fd_sc_hd__fill_1
XFILLER_0_55_145 VGND VGND VPWR VPWR sky130_fd_sc_hd__decap_3
X_3560_ _0860_ _0852_ _0862_ _0867_ VGND VGND VPWR VPWR _0868_ sky130_fd_sc_hd__a31o_1
XFILLER_0_51_340 VPWR VGND VPWR VGND sky130_ef_sc_hd__decap_12
XFILLER_0_106_291 VGND VGND VPWR VPWR sky130_fd_sc_hd__decap_6
XFILLER_0_24_598 VGND VGND VPWR VPWR sky130_fd_sc_hd__fill_2
X_5230_ net790 _2143_ _2132_ _2148_ VGND VGND VPWR VPWR _0384_ sky130_fd_sc_hd__a22o_1
XFILLER_0_59_45 VGND VGND VPWR VPWR sky130_fd_sc_hd__decap_8
XFILLER_0_59_89 VGND VGND VPWR VPWR sky130_fd_sc_hd__fill_2
X_5161_ u_pe_array.g_pe_row\[2\].g_pe_col\[0\].u_pe.psum_out\[8\] _2085_ VGND VGND
+ VPWR VPWR _2100_ sky130_fd_sc_hd__nor2_1
X_5092_ u_pe_array.g_pe_row\[2\].g_pe_col\[0\].u_pe.act_val\[3\] _1284_ VGND VGND
+ VPWR VPWR _2036_ sky130_fd_sc_hd__nand2_1
X_4112_ u_pe_array.g_pe_row\[3\].g_pe_col\[1\].u_pe.psum_out\[7\] u_pe_array.g_pe_row\[3\].g_pe_col\[1\].u_pe.move_reg\[7\]
+ _0947_ VGND VGND VPWR VPWR _1296_ sky130_fd_sc_hd__mux2_1
X_4043_ _1240_ _1241_ VGND VGND VPWR VPWR _1242_ sky130_fd_sc_hd__and2_1
X_7802_ clknet_leaf_51_clk net118 net74 VGND VGND VPWR VPWR u_pe_array.g_pe_row\[0\].g_pe_col\[0\].u_pe.move_reg\[10\]
+ sky130_fd_sc_hd__dfrtp_1
XFILLER_0_91_65 VGND VGND VPWR VPWR sky130_fd_sc_hd__fill_1
X_5994_ _2741_ _2747_ _1003_ VGND VGND VPWR VPWR _2749_ sky130_fd_sc_hd__a21o_1
X_4945_ _1927_ _1928_ net886 _1006_ VGND VGND VPWR VPWR _0319_ sky130_fd_sc_hd__a2bb2o_1
XFILLER_0_91_87 VGND VGND VPWR VPWR sky130_fd_sc_hd__decap_4
X_7733_ clknet_leaf_73_clk _0639_ net13 VGND VGND VPWR VPWR u_pe_array.g_pe_row\[0\].g_pe_col\[2\].u_pe.psum_out\[11\]
+ sky130_fd_sc_hd__dfrtp_1
XFILLER_0_86_270 VGND VGND VPWR VPWR sky130_fd_sc_hd__fill_1
XFILLER_0_74_432 VGND VGND VPWR VPWR sky130_fd_sc_hd__fill_2
XFILLER_0_19_337 VGND VGND VPWR VPWR sky130_fd_sc_hd__decap_4
XFILLER_0_24_81 VGND VGND VPWR VPWR sky130_fd_sc_hd__decap_3
X_4876_ net353 _1749_ _1873_ _1879_ VGND VGND VPWR VPWR _0299_ sky130_fd_sc_hd__a22o_1
XFILLER_0_74_454 VPWR VGND VPWR VGND sky130_ef_sc_hd__decap_12
X_7664_ clknet_leaf_62_clk _0570_ net74 VGND VGND VPWR VPWR u_pe_array.act_from_right\[2\]\[9\]
+ sky130_fd_sc_hd__dfrtp_1
X_7595_ clknet_leaf_45_clk _0501_ net947 VGND VGND VPWR VPWR u_pe_array.g_pe_row\[1\].g_pe_col\[1\].u_pe.psum_out\[9\]
+ sky130_fd_sc_hd__dfrtp_1
X_6615_ u_pe_array.g_pe_row\[0\].g_pe_col\[0\].u_pe.psum_out\[2\] u_pe_array.g_pe_row\[0\].g_pe_col\[0\].u_pe.act_val\[2\]
+ _3102_ VGND VGND VPWR VPWR _3232_ sky130_fd_sc_hd__mux2_1
X_3827_ u_pe_array.g_pe_row\[3\].g_pe_col\[3\].u_pe.psum_out\[9\] _0988_ VGND VGND
+ VPWR VPWR _1078_ sky130_fd_sc_hd__nand2_1
XFILLER_0_6_253 VGND VGND VPWR VPWR sky130_fd_sc_hd__decap_4
X_6546_ _3171_ _3173_ VGND VGND VPWR VPWR _3174_ sky130_fd_sc_hd__xnor2_1
X_3758_ u_pe_array.g_pe_row\[3\].g_pe_col\[3\].u_pe.act_val\[2\] u_pe_array.g_pe_row\[3\].g_pe_col\[3\].u_pe.w_out\[0\]
+ _0997_ VGND VGND VPWR VPWR _1015_ sky130_fd_sc_hd__and3_1
XFILLER_0_112_261 VGND VGND VPWR VPWR sky130_fd_sc_hd__fill_1
X_6477_ net366 _0866_ _0940_ u_pe_array.g_pe_row\[0\].g_pe_col\[1\].u_pe.move_reg\[8\]
+ VGND VGND VPWR VPWR _0664_ sky130_fd_sc_hd__a22o_1
X_3689_ _0869_ _0854_ VGND VGND VPWR VPWR _0962_ sky130_fd_sc_hd__and2_1
XFILLER_0_30_524 VGND VGND VPWR VPWR sky130_fd_sc_hd__fill_1
X_5428_ u_pe_array.g_pe_row\[1\].g_pe_col\[2\].u_pe.move_reg\[11\] net62 VGND VGND
+ VPWR VPWR _2308_ sky130_fd_sc_hd__or2_1
X_5359_ _2250_ _2254_ VGND VGND VPWR VPWR _2255_ sky130_fd_sc_hd__nand2_1
XFILLER_0_100_489 VGND VGND VPWR VPWR sky130_fd_sc_hd__decap_8
X_7029_ net588 _3356_ _3506_ VGND VGND VPWR VPWR _3509_ sky130_fd_sc_hd__mux2_1
XFILLER_0_97_502 VGND VGND VPWR VPWR sky130_fd_sc_hd__fill_2
XFILLER_0_77_281 VGND VGND VPWR VPWR sky130_fd_sc_hd__decap_3
XFILLER_0_37_167 VGND VGND VPWR VPWR sky130_fd_sc_hd__fill_1
XFILLER_0_92_295 VGND VGND VPWR VPWR sky130_fd_sc_hd__decap_4
XFILLER_0_92_262 VGND VGND VPWR VPWR sky130_fd_sc_hd__decap_4
XFILLER_0_80_457 VGND VGND VPWR VPWR sky130_fd_sc_hd__fill_1
XFILLER_0_33_362 VPWR VGND VPWR VGND sky130_ef_sc_hd__decap_12
XFILLER_0_110_209 VGND VGND VPWR VPWR sky130_fd_sc_hd__decap_3
XTAP_708 VGND VPWR sky130_fd_sc_hd__tapvpwrvgnd_1
XTAP_719 VGND VPWR sky130_fd_sc_hd__tapvpwrvgnd_1
XFILLER_0_88_513 VGND VGND VPWR VPWR sky130_fd_sc_hd__decap_6
XFILLER_0_0_27 VGND VGND VPWR VPWR sky130_fd_sc_hd__fill_1
XFILLER_0_29_602 VGND VGND VPWR VPWR sky130_fd_sc_hd__decap_6
XFILLER_0_61_57 VGND VGND VPWR VPWR sky130_fd_sc_hd__fill_1
XTAP_1491 VGND VPWR sky130_fd_sc_hd__tapvpwrvgnd_1
XTAP_1480 VGND VPWR sky130_fd_sc_hd__tapvpwrvgnd_1
XFILLER_0_8_529 VGND VGND VPWR VPWR sky130_fd_sc_hd__decap_3
X_4730_ u_pe_array.g_pe_row\[2\].g_pe_col\[2\].u_pe.psum_out\[1\] _1757_ VGND VGND
+ VPWR VPWR _1758_ sky130_fd_sc_hd__or2_1
X_4661_ u_pe_array.g_pe_row\[2\].g_pe_col\[3\].u_pe.psum_out\[11\] _1719_ _1710_ VGND
+ VGND VPWR VPWR _1720_ sky130_fd_sc_hd__mux2_1
XFILLER_0_9_69 VPWR VGND VPWR VGND sky130_ef_sc_hd__decap_12
X_3612_ _0907_ _0906_ VGND VGND VPWR VPWR _0908_ sky130_fd_sc_hd__and2_1
X_7380_ clknet_leaf_7_clk _0286_ net945 VGND VGND VPWR VPWR u_pe_array.g_pe_row\[2\].g_pe_col\[2\].u_pe.psum_out\[12\]
+ sky130_fd_sc_hd__dfrtp_1
XFILLER_0_43_159 VGND VGND VPWR VPWR sky130_fd_sc_hd__fill_1
X_6400_ _3050_ _3060_ _3065_ _3066_ VGND VGND VPWR VPWR _3067_ sky130_fd_sc_hd__o31a_1
XFILLER_0_114_559 VGND VGND VPWR VPWR sky130_fd_sc_hd__fill_2
XFILLER_0_3_223 VGND VGND VPWR VPWR sky130_fd_sc_hd__fill_1
X_4592_ _1656_ _1657_ VGND VGND VPWR VPWR _1658_ sky130_fd_sc_hd__or2_1
X_6331_ _3002_ _3003_ VGND VGND VPWR VPWR _3004_ sky130_fd_sc_hd__xor2_1
XFILLER_0_101_85 VGND VGND VPWR VPWR sky130_fd_sc_hd__fill_1
X_3543_ u_fsm.cnt\[0\] u_fsm.cnt\[1\] VGND VGND VPWR VPWR _0851_ sky130_fd_sc_hd__nand2_1
X_6262_ _2958_ _2960_ _2965_ VGND VGND VPWR VPWR _2967_ sky130_fd_sc_hd__or3_1
XFILLER_0_10_83 VGND VGND VPWR VPWR sky130_fd_sc_hd__fill_1
X_6193_ u_pe_array.g_pe_row\[0\].g_pe_col\[3\].u_pe.act_val\[5\] u_pe_array.g_pe_row\[0\].g_pe_col\[3\].u_pe.w_out\[0\]
+ VGND VGND VPWR VPWR _2904_ sky130_fd_sc_hd__nand2_1
X_5213_ net526 _1882_ _2132_ _2139_ VGND VGND VPWR VPWR _0376_ sky130_fd_sc_hd__a22o_1
X_5144_ u_pe_array.g_pe_row\[2\].g_pe_col\[0\].u_pe.psum_out\[7\] VGND VGND VPWR VPWR
+ _2084_ sky130_fd_sc_hd__inv_2
X_5075_ _2019_ _2020_ _2018_ VGND VGND VPWR VPWR _2021_ sky130_fd_sc_hd__o21ai_1
X_4026_ _1225_ _1226_ VGND VGND VPWR VPWR _1227_ sky130_fd_sc_hd__xnor2_1
Xclkbuf_leaf_91_clk clknet_3_4__leaf_clk VGND VGND VPWR VPWR clknet_leaf_91_clk sky130_fd_sc_hd__clkbuf_16
XFILLER_0_59_270 VGND VGND VPWR VPWR sky130_fd_sc_hd__fill_1
X_5977_ _2233_ _2731_ _2733_ _2621_ net532 VGND VGND VPWR VPWR _0546_ sky130_fd_sc_hd__a32o_1
X_4928_ u_pe_array.g_pe_row\[2\].g_pe_col\[1\].u_pe.psum_out\[2\] _1899_ _1912_ VGND
+ VGND VPWR VPWR _1913_ sky130_fd_sc_hd__a21oi_1
X_7716_ clknet_leaf_61_clk net292 net72 VGND VGND VPWR VPWR u_pe_array.g_pe_row\[0\].g_pe_col\[2\].u_pe.move_reg\[7\]
+ sky130_fd_sc_hd__dfrtp_1
XFILLER_0_19_189 VGND VGND VPWR VPWR sky130_fd_sc_hd__fill_1
XFILLER_0_35_649 VGND VGND VPWR VPWR sky130_fd_sc_hd__decap_3
XFILLER_0_47_498 VGND VGND VPWR VPWR sky130_fd_sc_hd__decap_6
X_7647_ clknet_leaf_70_clk _0553_ net72 VGND VGND VPWR VPWR u_pe_array.g_pe_row\[1\].g_pe_col\[0\].u_pe.psum_out\[7\]
+ sky130_fd_sc_hd__dfrtp_4
X_4859_ net181 _1749_ _1611_ _1870_ VGND VGND VPWR VPWR _0291_ sky130_fd_sc_hd__a22o_1
X_7578_ clknet_leaf_45_clk _0484_ net947 VGND VGND VPWR VPWR u_pe_array.g_pe_row\[1\].g_pe_col\[1\].u_pe.act_val\[5\]
+ sky130_fd_sc_hd__dfrtp_2
Xclkbuf_3_0__f_clk clknet_0_clk VGND VGND VPWR VPWR clknet_3_0__leaf_clk sky130_fd_sc_hd__clkbuf_16
XFILLER_0_43_671 VGND VGND VPWR VPWR sky130_fd_sc_hd__fill_1
X_6529_ _3157_ _3158_ net488 _1007_ VGND VGND VPWR VPWR _0673_ sky130_fd_sc_hd__a2bb2o_1
XFILLER_0_113_581 VGND VGND VPWR VPWR sky130_fd_sc_hd__decap_8
XFILLER_0_30_365 VGND VGND VPWR VPWR sky130_fd_sc_hd__fill_2
XFILLER_0_97_321 VGND VGND VPWR VPWR sky130_fd_sc_hd__decap_3
XFILLER_0_15_39 VPWR VGND VPWR VGND sky130_ef_sc_hd__decap_12
XFILLER_0_97_387 VGND VGND VPWR VPWR sky130_fd_sc_hd__decap_4
XFILLER_0_85_505 VGND VGND VPWR VPWR sky130_fd_sc_hd__decap_4
Xclkbuf_leaf_82_clk clknet_3_5__leaf_clk VGND VGND VPWR VPWR clknet_leaf_82_clk sky130_fd_sc_hd__clkbuf_16
XFILLER_0_26_616 VGND VGND VPWR VPWR sky130_fd_sc_hd__decap_3
XFILLER_0_31_38 VGND VGND VPWR VPWR sky130_fd_sc_hd__fill_2
XFILLER_0_31_49 VGND VGND VPWR VPWR sky130_fd_sc_hd__decap_6
XFILLER_0_25_159 VGND VGND VPWR VPWR sky130_fd_sc_hd__decap_8
XFILLER_0_61_490 VGND VGND VPWR VPWR sky130_fd_sc_hd__decap_4
XFILLER_0_0_237 VPWR VGND VPWR VGND sky130_ef_sc_hd__decap_12
XFILLER_0_21_365 VGND VGND VPWR VPWR sky130_fd_sc_hd__fill_2
XTAP_505 VGND VPWR sky130_fd_sc_hd__tapvpwrvgnd_1
XTAP_516 VGND VPWR sky130_fd_sc_hd__tapvpwrvgnd_1
XFILLER_0_21_376 VPWR VGND VPWR VGND sky130_ef_sc_hd__decap_12
XTAP_527 VGND VPWR sky130_fd_sc_hd__tapvpwrvgnd_1
XTAP_538 VGND VPWR sky130_fd_sc_hd__tapvpwrvgnd_1
XTAP_549 VGND VPWR sky130_fd_sc_hd__tapvpwrvgnd_1
X_5900_ net144 _1159_ _2655_ _1476_ VGND VGND VPWR VPWR _0528_ sky130_fd_sc_hd__a22o_1
XFILLER_0_88_365 VGND VGND VPWR VPWR sky130_fd_sc_hd__decap_8
XFILLER_0_88_354 VGND VGND VPWR VPWR sky130_fd_sc_hd__decap_8
X_6880_ net624 _0926_ _3415_ VGND VGND VPWR VPWR _3420_ sky130_fd_sc_hd__mux2_1
Xclkbuf_leaf_73_clk clknet_3_5__leaf_clk VGND VGND VPWR VPWR clknet_leaf_73_clk sky130_fd_sc_hd__clkbuf_16
X_5831_ _2627_ VGND VGND VPWR VPWR _0506_ sky130_fd_sc_hd__clkbuf_1
X_5762_ _2565_ _2566_ VGND VGND VPWR VPWR _2567_ sky130_fd_sc_hd__or2_1
X_7501_ clknet_leaf_44_clk _0407_ net947 VGND VGND VPWR VPWR u_pe_array.g_pe_row\[1\].g_pe_col\[3\].u_pe.psum_out\[10\]
+ sky130_fd_sc_hd__dfrtp_2
XFILLER_0_56_251 VGND VGND VPWR VPWR sky130_fd_sc_hd__fill_1
XFILLER_0_8_348 VGND VGND VPWR VPWR sky130_fd_sc_hd__decap_6
XFILLER_0_29_487 VGND VGND VPWR VPWR sky130_fd_sc_hd__fill_1
X_4713_ u_pe_array.g_pe_row\[2\].g_pe_col\[2\].u_pe.act_val\[5\] _1749_ _1611_ net123
+ VGND VGND VPWR VPWR _0266_ sky130_fd_sc_hd__a22o_1
X_5693_ net83 _2016_ _1883_ u_pe_array.g_pe_row\[1\].g_pe_col\[1\].u_pe.move_reg\[6\]
+ VGND VGND VPWR VPWR _0485_ sky130_fd_sc_hd__a22o_1
XFILLER_0_17_649 VGND VGND VPWR VPWR sky130_fd_sc_hd__decap_4
X_7432_ clknet_leaf_38_clk _0338_ net951 VGND VGND VPWR VPWR u_pe_array.act_from_up\[12\]\[8\]
+ sky130_fd_sc_hd__dfrtp_1
X_4644_ _1695_ _1702_ _1703_ _1704_ VGND VGND VPWR VPWR _1705_ sky130_fd_sc_hd__a31o_1
XFILLER_0_114_356 VGND VGND VPWR VPWR sky130_fd_sc_hd__decap_8
Xhold712 u_pe_array.u_fifo2.buffer\[6\]\[5\] VGND VGND VPWR VPWR net786 sky130_fd_sc_hd__dlygate4sd3_1
XFILLER_0_25_682 VGND VGND VPWR VPWR sky130_fd_sc_hd__fill_2
Xhold701 u_pe_array.u_fifo1.buffer\[8\]\[1\] VGND VGND VPWR VPWR net775 sky130_fd_sc_hd__dlygate4sd3_1
X_4575_ _1641_ VGND VGND VPWR VPWR _1642_ sky130_fd_sc_hd__inv_2
X_7363_ clknet_leaf_7_clk _0269_ net944 VGND VGND VPWR VPWR u_pe_array.g_pe_row\[2\].g_pe_col\[2\].u_pe.move_reg\[8\]
+ sky130_fd_sc_hd__dfrtp_1
XFILLER_0_97_42 VPWR VGND VPWR VGND sky130_ef_sc_hd__decap_12
Xhold723 u_pe_array.g_pe_row\[3\].g_pe_col\[1\].u_pe.psum_out\[9\] VGND VGND VPWR
+ VPWR net797 sky130_fd_sc_hd__dlygate4sd3_1
X_7294_ clknet_leaf_11_clk _0200_ net951 VGND VGND VPWR VPWR u_pe_array.g_pe_row\[3\].g_pe_col\[0\].u_pe.psum_out\[8\]
+ sky130_fd_sc_hd__dfrtp_2
Xhold745 u_pe_array.g_pe_row\[3\].g_pe_col\[3\].u_pe.act_val\[2\] VGND VGND VPWR VPWR
+ net819 sky130_fd_sc_hd__dlygate4sd3_1
Xhold734 u_pe_array.g_pe_row\[3\].g_pe_col\[2\].u_pe.psum_out\[12\] VGND VGND VPWR
+ VPWR net808 sky130_fd_sc_hd__dlygate4sd3_1
X_6314_ u_pe_array.g_pe_row\[0\].g_pe_col\[2\].u_pe.psum_out\[0\] u_pe_array.g_pe_row\[0\].g_pe_col\[2\].u_pe.act_val\[0\]
+ _2128_ VGND VGND VPWR VPWR _2989_ sky130_fd_sc_hd__nand3_1
X_6245_ _2942_ _2945_ _2950_ VGND VGND VPWR VPWR _2952_ sky130_fd_sc_hd__or3_1
Xhold767 net44 VGND VGND VPWR VPWR net841 sky130_fd_sc_hd__dlygate4sd3_1
Xhold778 u_pe_array.g_pe_row\[2\].g_pe_col\[2\].u_pe.psum_out\[8\] VGND VGND VPWR
+ VPWR net852 sky130_fd_sc_hd__dlygate4sd3_1
Xhold756 u_pe_array.g_pe_row\[3\].g_pe_col\[0\].u_pe.psum_out\[3\] VGND VGND VPWR
+ VPWR net830 sky130_fd_sc_hd__dlygate4sd3_1
XFILLER_0_110_573 VGND VGND VPWR VPWR sky130_fd_sc_hd__decap_8
Xhold789 net43 VGND VGND VPWR VPWR net863 sky130_fd_sc_hd__dlygate4sd3_1
X_6176_ _2885_ _2887_ VGND VGND VPWR VPWR _2889_ sky130_fd_sc_hd__nand2_1
X_5127_ _2067_ _2068_ VGND VGND VPWR VPWR _2069_ sky130_fd_sc_hd__nor2_1
X_5058_ u_pe_array.g_pe_row\[2\].g_pe_col\[0\].u_pe.act_val\[2\] _1882_ _1873_ net181
+ VGND VGND VPWR VPWR _0345_ sky130_fd_sc_hd__a22o_1
X_4009_ u_pe_array.g_pe_row\[3\].g_pe_col\[2\].u_pe.act_val\[3\] u_pe_array.g_pe_row\[3\].g_pe_col\[2\].u_pe.w_out\[0\]
+ _1197_ _1196_ VGND VGND VPWR VPWR _1211_ sky130_fd_sc_hd__a31o_1
Xclkbuf_leaf_64_clk clknet_3_7__leaf_clk VGND VGND VPWR VPWR clknet_leaf_64_clk sky130_fd_sc_hd__clkbuf_16
XFILLER_0_1_81 VPWR VGND VPWR VGND sky130_ef_sc_hd__decap_12
XFILLER_0_118_673 VGND VGND VPWR VPWR sky130_fd_sc_hd__fill_2
XFILLER_0_62_210 VGND VGND VPWR VPWR sky130_fd_sc_hd__fill_1
XFILLER_0_105_334 VGND VGND VPWR VPWR sky130_fd_sc_hd__fill_2
XFILLER_0_90_563 VGND VGND VPWR VPWR sky130_fd_sc_hd__fill_2
XFILLER_0_7_370 VGND VGND VPWR VPWR sky130_fd_sc_hd__fill_2
XFILLER_0_105_356 VGND VGND VPWR VPWR sky130_fd_sc_hd__decap_6
XFILLER_0_50_427 VGND VGND VPWR VPWR sky130_fd_sc_hd__fill_1
XFILLER_0_105_389 VGND VGND VPWR VPWR sky130_fd_sc_hd__decap_3
XFILLER_0_31_685 VPWR VGND VPWR VGND sky130_ef_sc_hd__decap_12
Xhold50 _0266_ VGND VGND VPWR VPWR net124 sky130_fd_sc_hd__dlygate4sd3_1
XFILLER_0_89_129 VPWR VGND VPWR VGND sky130_ef_sc_hd__decap_12
Xhold83 u_pe_array.act_from_left\[5\]\[9\] VGND VGND VPWR VPWR net157 sky130_fd_sc_hd__dlygate4sd3_1
Xhold72 u_pe_array.act_from_left\[13\]\[10\] VGND VGND VPWR VPWR net146 sky130_fd_sc_hd__dlygate4sd3_1
Xhold61 u_pe_array.act_from_left\[15\]\[9\] VGND VGND VPWR VPWR net135 sky130_fd_sc_hd__dlygate4sd3_1
XFILLER_0_98_652 VPWR VGND VPWR VGND sky130_ef_sc_hd__decap_12
Xhold94 u_pe_array.act_from_up\[4\]\[7\] VGND VGND VPWR VPWR net168 sky130_fd_sc_hd__dlygate4sd3_1
XFILLER_0_97_151 VGND VGND VPWR VPWR sky130_fd_sc_hd__fill_1
Xclkbuf_leaf_55_clk clknet_3_7__leaf_clk VGND VGND VPWR VPWR clknet_leaf_55_clk sky130_fd_sc_hd__clkbuf_16
XFILLER_0_42_26 VGND VGND VPWR VPWR sky130_fd_sc_hd__fill_2
XFILLER_0_109_673 VPWR VGND VPWR VGND sky130_ef_sc_hd__decap_12
XFILLER_0_81_585 VGND VGND VPWR VPWR sky130_fd_sc_hd__decap_8
XFILLER_0_14_608 VGND VGND VPWR VPWR sky130_fd_sc_hd__decap_6
XANTENNA_3 _2636_ VGND VGND VPWR VPWR sky130_fd_sc_hd__diode_2
XFILLER_0_41_427 VGND VGND VPWR VPWR sky130_fd_sc_hd__fill_1
XFILLER_0_41_449 VGND VGND VPWR VPWR sky130_fd_sc_hd__fill_2
X_4360_ net803 _1301_ _1305_ _1480_ VGND VGND VPWR VPWR _0182_ sky130_fd_sc_hd__a22o_1
XFILLER_0_6_15 VPWR VGND VPWR VGND sky130_ef_sc_hd__decap_12
X_4291_ _1438_ VGND VGND VPWR VPWR _0155_ sky130_fd_sc_hd__clkbuf_1
XTAP_324 VGND VPWR sky130_fd_sc_hd__tapvpwrvgnd_1
XTAP_313 VGND VPWR sky130_fd_sc_hd__tapvpwrvgnd_1
XTAP_302 VGND VPWR sky130_fd_sc_hd__tapvpwrvgnd_1
XTAP_357 VGND VPWR sky130_fd_sc_hd__tapvpwrvgnd_1
XTAP_335 VGND VPWR sky130_fd_sc_hd__tapvpwrvgnd_1
XTAP_346 VGND VPWR sky130_fd_sc_hd__tapvpwrvgnd_1
X_6030_ _2233_ _2780_ _2781_ _2621_ net684 VGND VGND VPWR VPWR _0551_ sky130_fd_sc_hd__a32o_1
XTAP_379 VGND VPWR sky130_fd_sc_hd__tapvpwrvgnd_1
XTAP_368 VGND VPWR sky130_fd_sc_hd__tapvpwrvgnd_1
XFILLER_0_83_44 VPWR VGND VPWR VGND sky130_ef_sc_hd__decap_12
XFILLER_0_107_51 VGND VGND VPWR VPWR sky130_fd_sc_hd__decap_4
Xclkbuf_leaf_46_clk clknet_3_6__leaf_clk VGND VGND VPWR VPWR clknet_leaf_46_clk sky130_fd_sc_hd__clkbuf_16
XFILLER_0_89_685 VPWR VGND VPWR VGND sky130_ef_sc_hd__decap_12
X_6932_ _3449_ VGND VGND VPWR VPWR _0785_ sky130_fd_sc_hd__clkbuf_1
XPHY_19 VGND VGND VPWR VPWR sky130_fd_sc_hd__decap_3
XFILLER_0_9_602 VGND VGND VPWR VPWR sky130_fd_sc_hd__fill_2
X_6863_ net699 _0922_ _3408_ VGND VGND VPWR VPWR _3411_ sky130_fd_sc_hd__mux2_1
X_5814_ _2613_ _2614_ net932 _1007_ VGND VGND VPWR VPWR _0502_ sky130_fd_sc_hd__a2bb2o_1
XFILLER_0_9_613 VGND VGND VPWR VPWR sky130_fd_sc_hd__decap_3
X_6794_ u_pe_array.u_fifo2.wr_ptr\[0\] _0914_ net867 VGND VGND VPWR VPWR _3367_ sky130_fd_sc_hd__a21oi_1
XFILLER_0_45_700 VGND VGND VPWR VPWR sky130_fd_sc_hd__decap_4
X_5745_ _2550_ _2551_ VGND VGND VPWR VPWR _2552_ sky130_fd_sc_hd__or2_1
XFILLER_0_106_109 VPWR VGND VPWR VGND sky130_ef_sc_hd__decap_12
XFILLER_0_8_167 VGND VGND VPWR VPWR sky130_fd_sc_hd__decap_4
XFILLER_0_115_643 VPWR VGND VPWR VGND sky130_ef_sc_hd__decap_12
X_5676_ net400 _2499_ _2491_ _2502_ VGND VGND VPWR VPWR _0476_ sky130_fd_sc_hd__a22o_1
XFILLER_0_72_563 VGND VGND VPWR VPWR sky130_fd_sc_hd__fill_2
XFILLER_0_114_153 VPWR VGND VPWR VGND sky130_ef_sc_hd__decap_12
X_7415_ clknet_leaf_26_clk _0321_ net71 VGND VGND VPWR VPWR u_pe_array.g_pe_row\[2\].g_pe_col\[1\].u_pe.psum_out\[6\]
+ sky130_fd_sc_hd__dfrtp_1
X_4627_ _1487_ _1688_ _1689_ _1356_ net783 VGND VGND VPWR VPWR _0240_ sky130_fd_sc_hd__a32o_1
XFILLER_0_44_287 VGND VGND VPWR VPWR sky130_fd_sc_hd__fill_1
Xhold520 u_pe_array.g_pe_row\[3\].g_pe_col\[1\].u_pe.psum_out\[6\] VGND VGND VPWR
+ VPWR net594 sky130_fd_sc_hd__dlygate4sd3_1
XFILLER_0_114_197 VGND VGND VPWR VPWR sky130_fd_sc_hd__decap_4
Xhold553 u_pe_array.act_from_left\[13\]\[2\] VGND VGND VPWR VPWR net627 sky130_fd_sc_hd__dlygate4sd3_1
X_7346_ clknet_leaf_105_clk _0252_ net944 VGND VGND VPWR VPWR u_pe_array.act_from_up\[14\]\[4\]
+ sky130_fd_sc_hd__dfrtp_1
Xhold531 u_pe_array.u_fifo2.buffer\[5\]\[1\] VGND VGND VPWR VPWR net605 sky130_fd_sc_hd__dlygate4sd3_1
XFILLER_0_13_685 VPWR VGND VPWR VGND sky130_ef_sc_hd__decap_12
Xhold542 u_pe_array.u_fifo2.buffer\[8\]\[1\] VGND VGND VPWR VPWR net616 sky130_fd_sc_hd__dlygate4sd3_1
X_4558_ _1623_ _1625_ VGND VGND VPWR VPWR _1626_ sky130_fd_sc_hd__xnor2_1
Xhold564 u_pe_array.g_pe_row\[2\].g_pe_col\[1\].u_pe.psum_out\[11\] VGND VGND VPWR
+ VPWR net638 sky130_fd_sc_hd__dlygate4sd3_1
Xhold575 _0611_ VGND VGND VPWR VPWR net649 sky130_fd_sc_hd__dlygate4sd3_1
Xhold586 u_pe_array.u_fifo2.buffer\[5\]\[4\] VGND VGND VPWR VPWR net660 sky130_fd_sc_hd__dlygate4sd3_1
Xhold597 u_pe_array.u_fifo2.buffer\[1\]\[5\] VGND VGND VPWR VPWR net671 sky130_fd_sc_hd__dlygate4sd3_1
X_7277_ clknet_leaf_96_clk _0183_ net950 VGND VGND VPWR VPWR u_pe_array.g_pe_row\[3\].g_pe_col\[0\].u_pe.act_val\[4\]
+ sky130_fd_sc_hd__dfrtp_2
X_4489_ _1581_ _1583_ _1588_ VGND VGND VPWR VPWR _1589_ sky130_fd_sc_hd__o21ai_1
X_6228_ _2919_ _2920_ _2934_ _2935_ VGND VGND VPWR VPWR _2936_ sky130_fd_sc_hd__a31o_1
X_6159_ u_pe_array.g_pe_row\[0\].g_pe_col\[3\].u_pe.act_val\[2\] u_pe_array.g_pe_row\[0\].g_pe_col\[3\].u_pe.w_out\[0\]
+ VGND VGND VPWR VPWR _2873_ sky130_fd_sc_hd__nand2_1
XTAP_880 VGND VPWR sky130_fd_sc_hd__tapvpwrvgnd_1
XTAP_891 VGND VPWR sky130_fd_sc_hd__tapvpwrvgnd_1
Xclkbuf_leaf_37_clk clknet_3_3__leaf_clk VGND VGND VPWR VPWR clknet_leaf_37_clk sky130_fd_sc_hd__clkbuf_16
XFILLER_0_67_335 VGND VGND VPWR VPWR sky130_fd_sc_hd__fill_1
XFILLER_0_95_655 VPWR VGND VPWR VGND sky130_ef_sc_hd__decap_12
XFILLER_0_12_18 VGND VGND VPWR VPWR sky130_fd_sc_hd__decap_8
XFILLER_0_75_390 VGND VGND VPWR VPWR sky130_fd_sc_hd__fill_2
XFILLER_0_12_29 VPWR VGND VPWR VGND sky130_ef_sc_hd__decap_12
XFILLER_0_106_632 VPWR VGND VPWR VGND sky130_ef_sc_hd__decap_12
XFILLER_0_50_213 VPWR VGND VPWR VGND sky130_ef_sc_hd__decap_12
XFILLER_0_23_449 VPWR VGND VPWR VGND sky130_ef_sc_hd__decap_12
Xoutput40 net40 VGND VGND VPWR VPWR psum_out0[1] sky130_fd_sc_hd__buf_2
Xoutput51 net51 VGND VGND VPWR VPWR psum_out1[11] sky130_fd_sc_hd__clkbuf_4
Xclkbuf_leaf_28_clk clknet_3_3__leaf_clk VGND VGND VPWR VPWR clknet_leaf_28_clk sky130_fd_sc_hd__clkbuf_16
XFILLER_0_85_110 VGND VGND VPWR VPWR sky130_fd_sc_hd__fill_2
XFILLER_0_58_335 VGND VGND VPWR VPWR sky130_fd_sc_hd__decap_4
X_3860_ u_pe_array.g_pe_row\[3\].g_pe_col\[1\].u_pe.w_out\[1\] VGND VGND VPWR VPWR
+ _1106_ sky130_fd_sc_hd__buf_6
XFILLER_0_86_688 VPWR VGND VPWR VGND sky130_ef_sc_hd__decap_12
XFILLER_0_116_418 VGND VGND VPWR VPWR sky130_fd_sc_hd__fill_2
X_3791_ _1043_ _0988_ u_pe_array.g_pe_row\[3\].g_pe_col\[3\].u_pe.psum_out\[6\] VGND
+ VGND VPWR VPWR _1045_ sky130_fd_sc_hd__a21oi_1
XFILLER_0_116_429 VGND VGND VPWR VPWR sky130_fd_sc_hd__fill_2
XPHY_190 VGND VGND VPWR VPWR sky130_fd_sc_hd__decap_3
XFILLER_0_5_137 VPWR VGND VPWR VGND sky130_ef_sc_hd__decap_12
XFILLER_0_26_265 VGND VGND VPWR VPWR sky130_fd_sc_hd__fill_1
X_5530_ u_pe_array.g_pe_row\[1\].g_pe_col\[2\].u_pe.act_val\[0\] _1597_ u_pe_array.g_pe_row\[1\].g_pe_col\[2\].u_pe.psum_out\[1\]
+ VGND VGND VPWR VPWR _2381_ sky130_fd_sc_hd__a21oi_1
XFILLER_0_81_371 VGND VGND VPWR VPWR sky130_fd_sc_hd__fill_1
XFILLER_0_54_585 VGND VGND VPWR VPWR sky130_fd_sc_hd__decap_3
X_5461_ _2321_ u_pe_array.u_fifo2.rd_ptr\[3\] u_pe_array.u_fifo2.rd_ptr\[2\] VGND
+ VGND VPWR VPWR _2326_ sky130_fd_sc_hd__nor3b_1
XFILLER_0_78_11 VGND VGND VPWR VPWR sky130_fd_sc_hd__decap_3
X_4412_ _1517_ _1518_ VGND VGND VPWR VPWR _1519_ sky130_fd_sc_hd__xnor2_2
X_7200_ clknet_leaf_97_clk _0106_ net950 VGND VGND VPWR VPWR u_pe_array.g_pe_row\[3\].g_pe_col\[2\].u_pe.psum_out\[9\]
+ sky130_fd_sc_hd__dfrtp_2
XFILLER_0_41_257 VGND VGND VPWR VPWR sky130_fd_sc_hd__fill_2
XFILLER_0_112_657 VPWR VGND VPWR VGND sky130_ef_sc_hd__decap_12
X_5392_ net776 _2280_ _2273_ VGND VGND VPWR VPWR _2281_ sky130_fd_sc_hd__mux2_1
XFILLER_0_41_279 VGND VGND VPWR VPWR sky130_fd_sc_hd__fill_1
X_7131_ clknet_leaf_20_clk _0037_ net943 VGND VGND VPWR VPWR u_pe_array.g_pe_row\[3\].g_pe_col\[3\].u_pe.move_reg\[7\]
+ sky130_fd_sc_hd__dfrtp_1
X_4343_ _1447_ net747 _1158_ VGND VGND VPWR VPWR _1475_ sky130_fd_sc_hd__mux2_1
XFILLER_0_1_376 VPWR VGND VPWR VGND sky130_ef_sc_hd__decap_12
X_4274_ _1425_ VGND VGND VPWR VPWR _0151_ sky130_fd_sc_hd__clkbuf_1
X_7062_ net664 _3362_ _3521_ VGND VGND VPWR VPWR _3527_ sky130_fd_sc_hd__mux2_1
XFILLER_0_10_699 VGND VGND VPWR VPWR sky130_fd_sc_hd__fill_1
X_6013_ u_pe_array.g_pe_row\[1\].g_pe_col\[0\].u_pe.psum_out\[4\] _2765_ VGND VGND
+ VPWR VPWR _2766_ sky130_fd_sc_hd__xnor2_1
XFILLER_0_94_65 VPWR VGND VPWR VGND sky130_ef_sc_hd__decap_12
Xclkbuf_leaf_19_clk clknet_3_2__leaf_clk VGND VGND VPWR VPWR clknet_leaf_19_clk sky130_fd_sc_hd__clkbuf_16
XTAP_1309 VGND VPWR sky130_fd_sc_hd__tapvpwrvgnd_1
XFILLER_0_77_611 VGND VGND VPWR VPWR sky130_fd_sc_hd__decap_4
XFILLER_0_11_3 VPWR VGND VPWR VGND sky130_ef_sc_hd__decap_12
X_6915_ _3440_ VGND VGND VPWR VPWR _0777_ sky130_fd_sc_hd__clkbuf_1
XFILLER_0_49_302 VGND VGND VPWR VPWR sky130_fd_sc_hd__decap_8
XFILLER_0_77_666 VGND VGND VPWR VPWR sky130_fd_sc_hd__decap_6
X_7895_ clknet_leaf_83_clk _0800_ net948 VGND VGND VPWR VPWR u_pe_array.u_fifo1.count\[1\]
+ sky130_fd_sc_hd__dfrtp_1
XFILLER_0_49_357 VGND VGND VPWR VPWR sky130_fd_sc_hd__decap_4
X_6846_ _3401_ VGND VGND VPWR VPWR _0747_ sky130_fd_sc_hd__clkbuf_1
X_6777_ _3355_ VGND VGND VPWR VPWR _0724_ sky130_fd_sc_hd__clkbuf_1
X_5728_ _2534_ _2535_ VGND VGND VPWR VPWR _2536_ sky130_fd_sc_hd__nand2_1
X_3989_ u_pe_array.g_pe_row\[3\].g_pe_col\[2\].u_pe.act_val\[1\] u_pe_array.g_pe_row\[3\].g_pe_col\[2\].u_pe.psum_out\[2\]
+ _0934_ VGND VGND VPWR VPWR _1192_ sky130_fd_sc_hd__and3b_1
XFILLER_0_60_533 VGND VGND VPWR VPWR sky130_fd_sc_hd__fill_2
X_5659_ net496 _2143_ _2491_ _2493_ VGND VGND VPWR VPWR _0468_ sky130_fd_sc_hd__a22o_1
XFILLER_0_5_671 VGND VGND VPWR VPWR sky130_fd_sc_hd__fill_1
Xhold350 u_pe_array.g_pe_row\[1\].g_pe_col\[1\].u_pe.psum_out\[4\] VGND VGND VPWR
+ VPWR net424 sky130_fd_sc_hd__dlygate4sd3_1
Xhold361 u_pe_array.g_pe_row\[2\].g_pe_col\[1\].u_pe.psum_out\[5\] VGND VGND VPWR
+ VPWR net435 sky130_fd_sc_hd__dlygate4sd3_1
XFILLER_0_13_482 VGND VGND VPWR VPWR sky130_fd_sc_hd__fill_1
X_7329_ clknet_leaf_107_clk _0235_ net944 VGND VGND VPWR VPWR u_pe_array.g_pe_row\[2\].g_pe_col\[3\].u_pe.psum_out\[2\]
+ sky130_fd_sc_hd__dfrtp_1
Xhold372 u_pe_array.g_pe_row\[0\].g_pe_col\[3\].u_pe.psum_out\[3\] VGND VGND VPWR
+ VPWR net446 sky130_fd_sc_hd__dlygate4sd3_1
Xhold394 _0026_ VGND VGND VPWR VPWR net468 sky130_fd_sc_hd__dlygate4sd3_1
Xhold383 u_pe_array.act_from_right\[10\]\[11\] VGND VGND VPWR VPWR net457 sky130_fd_sc_hd__dlygate4sd3_1
XFILLER_0_67_121 VGND VGND VPWR VPWR sky130_fd_sc_hd__fill_1
XFILLER_0_68_699 VGND VGND VPWR VPWR sky130_fd_sc_hd__fill_1
XFILLER_0_106_484 VGND VGND VPWR VPWR sky130_fd_sc_hd__fill_2
XFILLER_0_3_27 VPWR VGND VPWR VGND sky130_ef_sc_hd__decap_12
X_4961_ u_pe_array.g_pe_row\[2\].g_pe_col\[1\].u_pe.psum_out\[5\] _1931_ _1942_ VGND
+ VGND VPWR VPWR _1943_ sky130_fd_sc_hd__a21oi_1
XFILLER_0_59_644 VGND VGND VPWR VPWR sky130_fd_sc_hd__fill_1
X_6700_ u_pe_array.g_pe_row\[0\].g_pe_col\[0\].u_pe.act_val\[4\] _3246_ _3285_ _3286_
+ VGND VGND VPWR VPWR _3288_ sky130_fd_sc_hd__o22ai_2
X_4892_ u_pe_array.act_from_down\[9\]\[10\] _1750_ _1483_ net385 VGND VGND VPWR VPWR
+ _0312_ sky130_fd_sc_hd__a22o_1
XFILLER_0_80_56 VGND VGND VPWR VPWR sky130_fd_sc_hd__fill_1
X_7680_ clknet_leaf_64_clk net148 net946 VGND VGND VPWR VPWR u_pe_array.g_pe_row\[0\].g_pe_col\[3\].u_pe.move_reg\[12\]
+ sky130_fd_sc_hd__dfrtp_1
X_3912_ net255 _1147_ _1116_ VGND VGND VPWR VPWR _1148_ sky130_fd_sc_hd__mux2_1
XFILLER_0_104_41 VPWR VGND VPWR VGND sky130_ef_sc_hd__decap_12
X_6631_ u_pe_array.g_pe_row\[0\].g_pe_col\[0\].u_pe.psum_out\[10\] u_pe_array.g_pe_row\[0\].g_pe_col\[0\].u_pe.move_reg\[10\]
+ _3102_ VGND VGND VPWR VPWR _3240_ sky130_fd_sc_hd__mux2_1
X_3843_ _1085_ _1090_ _1092_ VGND VGND VPWR VPWR _1093_ sky130_fd_sc_hd__o21ai_1
XFILLER_0_104_85 VPWR VGND VPWR VGND sky130_ef_sc_hd__decap_12
XFILLER_0_74_669 VGND VGND VPWR VPWR sky130_fd_sc_hd__decap_6
XFILLER_0_116_248 VGND VGND VPWR VPWR sky130_fd_sc_hd__decap_4
X_6562_ _3183_ _3187_ VGND VGND VPWR VPWR _3189_ sky130_fd_sc_hd__nand2_1
X_3774_ _1028_ _1029_ VGND VGND VPWR VPWR _1030_ sky130_fd_sc_hd__or2_1
XFILLER_0_14_202 VPWR VGND VPWR VGND sky130_ef_sc_hd__decap_12
XFILLER_0_13_94 VGND VGND VPWR VPWR sky130_fd_sc_hd__decap_3
XFILLER_0_27_585 VGND VGND VPWR VPWR sky130_fd_sc_hd__fill_1
X_6493_ _3117_ _3121_ VGND VGND VPWR VPWR _3125_ sky130_fd_sc_hd__nand2_1
XFILLER_0_80_6 VPWR VGND VPWR VGND sky130_ef_sc_hd__decap_12
X_5513_ u_pe_array.u_fifo2.buffer\[7\]\[5\] _2327_ _2329_ u_pe_array.u_fifo2.buffer\[1\]\[5\]
+ VGND VGND VPWR VPWR _2373_ sky130_fd_sc_hd__a22o_1
XFILLER_0_112_421 VPWR VGND VPWR VGND sky130_ef_sc_hd__decap_12
XFILLER_0_14_279 VGND VGND VPWR VPWR sky130_fd_sc_hd__fill_2
X_5444_ _2287_ net889 _1158_ VGND VGND VPWR VPWR _2318_ sky130_fd_sc_hd__mux2_1
Xclkbuf_leaf_8_clk clknet_3_1__leaf_clk VGND VGND VPWR VPWR clknet_leaf_8_clk sky130_fd_sc_hd__clkbuf_16
X_5375_ _2267_ VGND VGND VPWR VPWR _0410_ sky130_fd_sc_hd__clkbuf_1
XFILLER_0_59_3 VGND VGND VPWR VPWR sky130_fd_sc_hd__decap_4
X_7114_ clknet_leaf_3_clk _0020_ net69 VGND VGND VPWR VPWR u_pe_array.act_from_down\[11\]\[3\]
+ sky130_fd_sc_hd__dfrtp_1
XFILLER_0_10_485 VGND VGND VPWR VPWR sky130_fd_sc_hd__fill_2
X_4326_ u_pe_array.g_pe_row\[3\].g_pe_col\[0\].u_pe.psum_out\[11\] _1108_ _1110_ _1464_
+ VGND VGND VPWR VPWR _1465_ sky130_fd_sc_hd__o211a_1
X_4257_ _1406_ _1410_ VGND VGND VPWR VPWR _1412_ sky130_fd_sc_hd__or2_1
X_7045_ net634 _3358_ _3514_ VGND VGND VPWR VPWR _3518_ sky130_fd_sc_hd__mux2_1
X_4188_ u_pe_array.g_pe_row\[3\].g_pe_col\[1\].u_pe.act_val\[3\] u_pe_array.g_pe_row\[3\].g_pe_col\[1\].u_pe.w_out\[0\]
+ _1334_ _1333_ VGND VGND VPWR VPWR _1349_ sky130_fd_sc_hd__a31o_1
XTAP_1128 VGND VPWR sky130_fd_sc_hd__tapvpwrvgnd_1
XTAP_1117 VGND VPWR sky130_fd_sc_hd__tapvpwrvgnd_1
XTAP_1106 VGND VPWR sky130_fd_sc_hd__tapvpwrvgnd_1
XTAP_1139 VGND VPWR sky130_fd_sc_hd__tapvpwrvgnd_1
X_7878_ clknet_leaf_99_clk _0783_ VGND VGND VPWR VPWR u_pe_array.u_fifo2.buffer\[7\]\[0\]
+ sky130_fd_sc_hd__dfxtp_1
XFILLER_0_77_496 VGND VGND VPWR VPWR sky130_fd_sc_hd__fill_1
XFILLER_0_64_113 VGND VGND VPWR VPWR sky130_fd_sc_hd__decap_3
X_6829_ u_pe_array.u_fifo2.wr_ptr\[3\] u_pe_array.u_fifo2.wr_ptr\[2\] net948 _0914_
+ VGND VGND VPWR VPWR _3391_ sky130_fd_sc_hd__and4bb_1
XFILLER_0_107_215 VGND VGND VPWR VPWR sky130_fd_sc_hd__fill_2
XFILLER_0_107_248 VGND VGND VPWR VPWR sky130_fd_sc_hd__decap_8
XFILLER_0_64_179 VPWR VGND VPWR VGND sky130_ef_sc_hd__decap_12
XFILLER_0_18_574 VGND VGND VPWR VPWR sky130_fd_sc_hd__fill_1
XFILLER_0_33_522 VPWR VGND VPWR VGND sky130_ef_sc_hd__decap_12
XFILLER_0_33_544 VGND VGND VPWR VPWR sky130_fd_sc_hd__decap_6
XFILLER_0_45_393 VGND VGND VPWR VPWR sky130_fd_sc_hd__fill_2
XFILLER_0_115_281 VPWR VGND VPWR VGND sky130_ef_sc_hd__decap_12
XFILLER_0_103_465 VGND VGND VPWR VPWR sky130_fd_sc_hd__fill_2
Xhold180 _0660_ VGND VGND VPWR VPWR net254 sky130_fd_sc_hd__dlygate4sd3_1
Xhold191 u_pe_array.g_pe_row\[0\].g_pe_col\[1\].u_pe.move_reg\[11\] VGND VGND VPWR
+ VPWR net265 sky130_fd_sc_hd__dlygate4sd3_1
XTAP_1651 VGND VPWR sky130_fd_sc_hd__tapvpwrvgnd_1
XTAP_1640 VGND VPWR sky130_fd_sc_hd__tapvpwrvgnd_1
XTAP_1684 VGND VPWR sky130_fd_sc_hd__tapvpwrvgnd_1
XTAP_1662 VGND VPWR sky130_fd_sc_hd__tapvpwrvgnd_1
XTAP_1673 VGND VPWR sky130_fd_sc_hd__tapvpwrvgnd_1
XFILLER_0_55_113 VPWR VGND VPWR VGND sky130_ef_sc_hd__decap_12
XTAP_1695 VGND VPWR sky130_fd_sc_hd__tapvpwrvgnd_1
XFILLER_0_71_617 VPWR VGND VPWR VGND sky130_ef_sc_hd__decap_12
XFILLER_0_70_127 VGND VGND VPWR VPWR sky130_fd_sc_hd__decap_6
XFILLER_0_43_319 VPWR VGND VPWR VGND sky130_ef_sc_hd__decap_12
XFILLER_0_113_229 VGND VGND VPWR VPWR sky130_fd_sc_hd__fill_1
XFILLER_0_3_405 VPWR VGND VPWR VGND sky130_ef_sc_hd__decap_12
XFILLER_0_3_449 VPWR VGND VPWR VGND sky130_ef_sc_hd__decap_12
X_5160_ _2097_ _2098_ VGND VGND VPWR VPWR _2099_ sky130_fd_sc_hd__nand2_1
X_5091_ u_pe_array.g_pe_row\[2\].g_pe_col\[0\].u_pe.act_val\[2\] _1284_ _2027_ VGND
+ VGND VPWR VPWR _2035_ sky130_fd_sc_hd__and3_1
X_4111_ net354 _1167_ _1169_ _1295_ VGND VGND VPWR VPWR _0118_ sky130_fd_sc_hd__a22o_1
X_4042_ u_pe_array.g_pe_row\[3\].g_pe_col\[2\].u_pe.psum_out\[7\] _0934_ VGND VGND
+ VPWR VPWR _1241_ sky130_fd_sc_hd__or2_1
X_7801_ clknet_leaf_51_clk net138 net74 VGND VGND VPWR VPWR u_pe_array.g_pe_row\[0\].g_pe_col\[0\].u_pe.move_reg\[9\]
+ sky130_fd_sc_hd__dfrtp_1
XFILLER_0_91_55 VGND VGND VPWR VPWR sky130_fd_sc_hd__fill_1
X_5993_ _2741_ _2747_ VGND VGND VPWR VPWR _2748_ sky130_fd_sc_hd__nor2_1
X_4944_ _1918_ _1926_ _1003_ VGND VGND VPWR VPWR _1928_ sky130_fd_sc_hd__a21o_1
X_7732_ clknet_leaf_73_clk _0638_ net13 VGND VGND VPWR VPWR u_pe_array.g_pe_row\[0\].g_pe_col\[2\].u_pe.psum_out\[10\]
+ sky130_fd_sc_hd__dfrtp_2
X_4875_ u_pe_array.g_pe_row\[2\].g_pe_col\[1\].u_pe.psum_out\[10\] u_pe_array.g_pe_row\[2\].g_pe_col\[1\].u_pe.move_reg\[10\]
+ _1867_ VGND VGND VPWR VPWR _1879_ sky130_fd_sc_hd__mux2_1
XFILLER_0_74_466 VGND VGND VPWR VPWR sky130_fd_sc_hd__decap_8
X_7663_ clknet_leaf_61_clk _0569_ net74 VGND VGND VPWR VPWR u_pe_array.act_from_right\[2\]\[8\]
+ sky130_fd_sc_hd__dfrtp_1
XFILLER_0_46_135 VGND VGND VPWR VPWR sky130_fd_sc_hd__decap_4
X_7594_ clknet_leaf_46_clk _0500_ net947 VGND VGND VPWR VPWR u_pe_array.g_pe_row\[1\].g_pe_col\[1\].u_pe.psum_out\[8\]
+ sky130_fd_sc_hd__dfrtp_2
X_3826_ net817 _1007_ _1075_ _1077_ VGND VGND VPWR VPWR _0051_ sky130_fd_sc_hd__a22o_1
XFILLER_0_74_499 VGND VGND VPWR VPWR sky130_fd_sc_hd__fill_2
XFILLER_0_74_477 VPWR VGND VPWR VGND sky130_ef_sc_hd__decap_12
XFILLER_0_6_221 VGND VGND VPWR VPWR sky130_fd_sc_hd__decap_8
X_6614_ net506 _1731_ _1734_ _3231_ VGND VGND VPWR VPWR _0685_ sky130_fd_sc_hd__a22o_1
X_6545_ u_pe_array.g_pe_row\[0\].g_pe_col\[1\].u_pe.psum_out\[5\] _3161_ _3172_ VGND
+ VGND VPWR VPWR _3173_ sky130_fd_sc_hd__a21oi_1
X_3757_ u_pe_array.g_pe_row\[3\].g_pe_col\[3\].u_pe.psum_out\[3\] _1013_ VGND VGND
+ VPWR VPWR _1014_ sky130_fd_sc_hd__xor2_1
XFILLER_0_6_276 VGND VGND VPWR VPWR sky130_fd_sc_hd__decap_6
XFILLER_0_15_533 VGND VGND VPWR VPWR sky130_fd_sc_hd__decap_6
X_6476_ net106 _0866_ _0940_ u_pe_array.g_pe_row\[0\].g_pe_col\[1\].u_pe.move_reg\[7\]
+ VGND VGND VPWR VPWR _0663_ sky130_fd_sc_hd__a22o_1
X_3688_ net310 _0949_ _0944_ _0961_ VGND VGND VPWR VPWR _0029_ sky130_fd_sc_hd__a22o_1
X_5427_ _2307_ VGND VGND VPWR VPWR _0422_ sky130_fd_sc_hd__clkbuf_1
XFILLER_0_30_558 VPWR VGND VPWR VGND sky130_ef_sc_hd__decap_12
X_5358_ u_pe_array.g_pe_row\[1\].g_pe_col\[3\].u_pe.psum_out\[10\] _2253_ _2244_ VGND
+ VGND VPWR VPWR _2254_ sky130_fd_sc_hd__mux2_1
XFILLER_0_49_90 VGND VGND VPWR VPWR sky130_fd_sc_hd__decap_8
X_4309_ u_pe_array.g_pe_row\[3\].g_pe_col\[0\].u_pe.move_reg\[7\] net62 VGND VGND
+ VPWR VPWR _1452_ sky130_fd_sc_hd__or2_1
X_5289_ _2183_ _2182_ _2190_ _1003_ VGND VGND VPWR VPWR _2192_ sky130_fd_sc_hd__a31o_1
X_7028_ _3508_ VGND VGND VPWR VPWR _0822_ sky130_fd_sc_hd__clkbuf_1
XFILLER_0_97_558 VGND VGND VPWR VPWR sky130_fd_sc_hd__fill_2
XFILLER_0_37_113 VPWR VGND VPWR VGND sky130_ef_sc_hd__decap_12
XFILLER_0_108_513 VPWR VGND VPWR VGND sky130_ef_sc_hd__decap_12
XFILLER_0_53_617 VPWR VGND VPWR VGND sky130_ef_sc_hd__decap_12
XFILLER_0_20_29 VPWR VGND VPWR VGND sky130_ef_sc_hd__decap_12
XFILLER_0_33_352 VGND VGND VPWR VPWR sky130_fd_sc_hd__fill_1
XFILLER_0_0_419 VGND VGND VPWR VPWR sky130_fd_sc_hd__fill_1
XFILLER_0_33_374 VGND VGND VPWR VPWR sky130_fd_sc_hd__fill_1
XFILLER_0_21_558 VGND VGND VPWR VPWR sky130_fd_sc_hd__fill_2
XTAP_709 VGND VPWR sky130_fd_sc_hd__tapvpwrvgnd_1
XFILLER_0_88_569 VGND VGND VPWR VPWR sky130_fd_sc_hd__decap_3
XFILLER_0_75_208 VGND VGND VPWR VPWR sky130_fd_sc_hd__decap_4
XFILLER_0_61_25 VPWR VGND VPWR VGND sky130_ef_sc_hd__decap_12
XTAP_1492 VGND VPWR sky130_fd_sc_hd__tapvpwrvgnd_1
XTAP_1481 VGND VPWR sky130_fd_sc_hd__tapvpwrvgnd_1
XTAP_1470 VGND VPWR sky130_fd_sc_hd__tapvpwrvgnd_1
XFILLER_0_9_15 VPWR VGND VPWR VGND sky130_ef_sc_hd__decap_12
X_4660_ _1717_ _1718_ VGND VGND VPWR VPWR _1719_ sky130_fd_sc_hd__or2_1
XFILLER_0_71_447 VGND VGND VPWR VPWR sky130_fd_sc_hd__fill_1
X_3611_ u_fsm.v_cnt\[1\] VGND VGND VPWR VPWR _0907_ sky130_fd_sc_hd__inv_2
X_4591_ _1644_ _1641_ _1640_ VGND VGND VPWR VPWR _1657_ sky130_fd_sc_hd__a21o_1
X_6330_ _2993_ _2994_ VGND VGND VPWR VPWR _3003_ sky130_fd_sc_hd__and2_1
X_6261_ _2958_ _2960_ _2965_ VGND VGND VPWR VPWR _2966_ sky130_fd_sc_hd__o21ai_1
X_6192_ u_pe_array.g_pe_row\[0\].g_pe_col\[3\].u_pe.act_val\[4\] _1999_ VGND VGND
+ VPWR VPWR _2903_ sky130_fd_sc_hd__and2b_1
X_5212_ u_pe_array.g_pe_row\[1\].g_pe_col\[3\].u_pe.psum_out\[5\] u_pe_array.g_pe_row\[1\].g_pe_col\[3\].u_pe.act_val\[5\]
+ _2133_ VGND VGND VPWR VPWR _2139_ sky130_fd_sc_hd__mux2_1
X_5143_ _2078_ _2081_ _2077_ VGND VGND VPWR VPWR _2083_ sky130_fd_sc_hd__a21oi_1
XFILLER_0_86_88 VGND VGND VPWR VPWR sky130_fd_sc_hd__decap_8
X_5074_ u_pe_array.g_pe_row\[2\].g_pe_col\[0\].u_pe.act_val\[0\] u_pe_array.g_pe_row\[2\].g_pe_col\[0\].u_pe.psum_out\[1\]
+ _1286_ VGND VGND VPWR VPWR _2020_ sky130_fd_sc_hd__and3_1
XFILLER_0_79_503 VGND VGND VPWR VPWR sky130_fd_sc_hd__fill_1
X_4025_ _1214_ _1215_ _1212_ VGND VGND VPWR VPWR _1226_ sky130_fd_sc_hd__o21ba_1
XFILLER_0_94_528 VGND VGND VPWR VPWR sky130_fd_sc_hd__decap_4
XFILLER_0_59_260 VGND VGND VPWR VPWR sky130_fd_sc_hd__decap_3
XFILLER_0_19_113 VGND VGND VPWR VPWR sky130_fd_sc_hd__decap_4
X_5976_ _2732_ VGND VGND VPWR VPWR _2733_ sky130_fd_sc_hd__inv_2
X_4927_ u_pe_array.g_pe_row\[2\].g_pe_col\[1\].u_pe.act_val\[2\] u_pe_array.g_pe_row\[2\].g_pe_col\[1\].u_pe.w_out\[0\]
+ _1897_ VGND VGND VPWR VPWR _1912_ sky130_fd_sc_hd__and3_1
X_7715_ clknet_leaf_61_clk net325 net74 VGND VGND VPWR VPWR u_pe_array.g_pe_row\[0\].g_pe_col\[2\].u_pe.move_reg\[6\]
+ sky130_fd_sc_hd__dfrtp_1
X_4858_ u_pe_array.g_pe_row\[2\].g_pe_col\[1\].u_pe.psum_out\[2\] u_pe_array.g_pe_row\[2\].g_pe_col\[1\].u_pe.act_val\[2\]
+ _1867_ VGND VGND VPWR VPWR _1870_ sky130_fd_sc_hd__mux2_1
XFILLER_0_90_701 VGND VGND VPWR VPWR sky130_fd_sc_hd__decap_4
X_7646_ clknet_leaf_70_clk _0552_ net72 VGND VGND VPWR VPWR u_pe_array.g_pe_row\[1\].g_pe_col\[0\].u_pe.psum_out\[6\]
+ sky130_fd_sc_hd__dfrtp_1
X_3809_ _1061_ u_pe_array.g_pe_row\[3\].g_pe_col\[3\].u_pe.psum_out\[7\] _1044_ VGND
+ VGND VPWR VPWR _1062_ sky130_fd_sc_hd__mux2_1
XFILLER_0_28_680 VPWR VGND VPWR VGND sky130_ef_sc_hd__decap_12
X_7577_ clknet_leaf_45_clk _0483_ net947 VGND VGND VPWR VPWR u_pe_array.g_pe_row\[1\].g_pe_col\[1\].u_pe.act_val\[4\]
+ sky130_fd_sc_hd__dfrtp_2
XFILLER_0_7_596 VGND VGND VPWR VPWR sky130_fd_sc_hd__decap_3
XFILLER_0_15_363 VGND VGND VPWR VPWR sky130_fd_sc_hd__decap_4
X_4789_ _1791_ _1800_ VGND VGND VPWR VPWR _1812_ sky130_fd_sc_hd__and2b_1
X_6528_ _3148_ _3156_ _1003_ VGND VGND VPWR VPWR _3158_ sky130_fd_sc_hd__a21o_1
X_6459_ u_pe_array.g_pe_row\[0\].g_pe_col\[1\].u_pe.psum_out\[8\] u_pe_array.g_pe_row\[0\].g_pe_col\[1\].u_pe.move_reg\[8\]
+ _3102_ VGND VGND VPWR VPWR _3111_ sky130_fd_sc_hd__mux2_1
XFILLER_0_78_580 VGND VGND VPWR VPWR sky130_fd_sc_hd__fill_1
XFILLER_0_108_321 VPWR VGND VPWR VGND sky130_ef_sc_hd__decap_12
XFILLER_0_25_116 VGND VGND VPWR VPWR sky130_fd_sc_hd__fill_1
XFILLER_0_108_365 VGND VGND VPWR VPWR sky130_fd_sc_hd__decap_6
XFILLER_0_25_127 VGND VGND VPWR VPWR sky130_fd_sc_hd__decap_3
XFILLER_0_111_508 VGND VGND VPWR VPWR sky130_fd_sc_hd__fill_1
XFILLER_0_33_182 VGND VGND VPWR VPWR sky130_fd_sc_hd__fill_1
XFILLER_0_0_249 VGND VGND VPWR VPWR sky130_fd_sc_hd__decap_3
XTAP_506 VGND VPWR sky130_fd_sc_hd__tapvpwrvgnd_1
XFILLER_0_21_388 VGND VGND VPWR VPWR sky130_fd_sc_hd__decap_4
XTAP_517 VGND VPWR sky130_fd_sc_hd__tapvpwrvgnd_1
XFILLER_0_21_399 VGND VGND VPWR VPWR sky130_fd_sc_hd__fill_1
XTAP_528 VGND VPWR sky130_fd_sc_hd__tapvpwrvgnd_1
XTAP_539 VGND VPWR sky130_fd_sc_hd__tapvpwrvgnd_1
X_5830_ net34 _1999_ _0931_ VGND VGND VPWR VPWR _2627_ sky130_fd_sc_hd__mux2_1
X_5761_ _2564_ _1728_ u_pe_array.g_pe_row\[1\].g_pe_col\[1\].u_pe.psum_out\[6\] VGND
+ VGND VPWR VPWR _2566_ sky130_fd_sc_hd__a21oi_1
X_7500_ clknet_leaf_41_clk _0406_ net947 VGND VGND VPWR VPWR u_pe_array.g_pe_row\[1\].g_pe_col\[3\].u_pe.psum_out\[9\]
+ sky130_fd_sc_hd__dfrtp_2
XFILLER_0_72_701 VGND VGND VPWR VPWR sky130_fd_sc_hd__decap_4
X_4712_ u_pe_array.g_pe_row\[2\].g_pe_col\[2\].u_pe.act_val\[4\] _1749_ _1611_ net250
+ VGND VGND VPWR VPWR _0265_ sky130_fd_sc_hd__a22o_1
XFILLER_0_112_41 VPWR VGND VPWR VGND sky130_ef_sc_hd__decap_12
X_5692_ net364 _2499_ _2491_ _2510_ VGND VGND VPWR VPWR _0484_ sky130_fd_sc_hd__a22o_1
X_7431_ clknet_leaf_14_clk _0337_ net951 VGND VGND VPWR VPWR u_pe_array.act_from_up\[12\]\[7\]
+ sky130_fd_sc_hd__dfrtp_1
XFILLER_0_71_222 VGND VGND VPWR VPWR sky130_fd_sc_hd__fill_2
XFILLER_0_4_500 VPWR VGND VPWR VGND sky130_ef_sc_hd__decap_12
XFILLER_0_112_85 VPWR VGND VPWR VGND sky130_ef_sc_hd__decap_12
XFILLER_0_4_533 VPWR VGND VPWR VGND sky130_ef_sc_hd__decap_12
XFILLER_0_31_108 VGND VGND VPWR VPWR sky130_fd_sc_hd__decap_4
X_4643_ u_pe_array.g_pe_row\[2\].g_pe_col\[3\].u_pe.psum_out\[8\] u_pe_array.g_pe_row\[2\].g_pe_col\[3\].u_pe.psum_out\[9\]
+ _1427_ VGND VGND VPWR VPWR _1704_ sky130_fd_sc_hd__and3_1
Xhold702 u_pe_array.act_from_right\[5\]\[2\] VGND VGND VPWR VPWR net776 sky130_fd_sc_hd__dlygate4sd3_1
XFILLER_0_4_577 VGND VGND VPWR VPWR sky130_fd_sc_hd__fill_2
XFILLER_0_25_694 VGND VGND VPWR VPWR sky130_fd_sc_hd__decap_8
X_4574_ _1632_ _1633_ _1639_ VGND VGND VPWR VPWR _1641_ sky130_fd_sc_hd__o21ai_1
X_7362_ clknet_leaf_1_clk _0268_ net944 VGND VGND VPWR VPWR u_pe_array.g_pe_row\[2\].g_pe_col\[2\].u_pe.move_reg\[7\]
+ sky130_fd_sc_hd__dfrtp_1
Xhold735 net48 VGND VGND VPWR VPWR net809 sky130_fd_sc_hd__dlygate4sd3_1
Xhold724 net41 VGND VGND VPWR VPWR net798 sky130_fd_sc_hd__dlygate4sd3_1
XFILLER_0_97_54 VGND VGND VPWR VPWR sky130_fd_sc_hd__fill_2
Xhold713 u_pe_array.g_pe_row\[3\].g_pe_col\[3\].u_pe.move_reg\[6\] VGND VGND VPWR
+ VPWR net787 sky130_fd_sc_hd__dlygate4sd3_1
X_7293_ clknet_leaf_11_clk _0199_ net951 VGND VGND VPWR VPWR u_pe_array.g_pe_row\[3\].g_pe_col\[0\].u_pe.psum_out\[7\]
+ sky130_fd_sc_hd__dfrtp_4
Xhold746 u_pe_array.g_pe_row\[3\].g_pe_col\[0\].u_pe.act_val\[2\] VGND VGND VPWR VPWR
+ net820 sky130_fd_sc_hd__dlygate4sd3_1
X_6313_ u_pe_array.g_pe_row\[0\].g_pe_col\[2\].u_pe.act_val\[0\] _2128_ u_pe_array.g_pe_row\[0\].g_pe_col\[2\].u_pe.psum_out\[0\]
+ VGND VGND VPWR VPWR _2988_ sky130_fd_sc_hd__a21o_1
X_6244_ _2942_ _2945_ _2950_ VGND VGND VPWR VPWR _2951_ sky130_fd_sc_hd__o21ai_1
Xhold768 net54 VGND VGND VPWR VPWR net842 sky130_fd_sc_hd__dlygate4sd3_1
Xhold779 u_pe_array.act_from_left\[15\]\[2\] VGND VGND VPWR VPWR net853 sky130_fd_sc_hd__dlygate4sd3_1
Xhold757 u_pe_array.act_from_right\[5\]\[5\] VGND VGND VPWR VPWR net831 sky130_fd_sc_hd__dlygate4sd3_1
X_6175_ _2885_ _2887_ VGND VGND VPWR VPWR _2888_ sky130_fd_sc_hd__nor2_1
XFILLER_0_41_3 VGND VGND VPWR VPWR sky130_fd_sc_hd__fill_2
X_5126_ _2052_ _2062_ _2066_ VGND VGND VPWR VPWR _2068_ sky130_fd_sc_hd__nor3_1
XFILLER_0_98_119 VGND VGND VPWR VPWR sky130_fd_sc_hd__decap_8
X_5057_ u_pe_array.g_pe_row\[2\].g_pe_col\[0\].u_pe.act_val\[1\] _1882_ _1873_ net79
+ VGND VGND VPWR VPWR _0344_ sky130_fd_sc_hd__a22o_1
X_4008_ _1206_ _1209_ VGND VGND VPWR VPWR _1210_ sky130_fd_sc_hd__xnor2_1
XFILLER_0_67_539 VGND VGND VPWR VPWR sky130_fd_sc_hd__fill_1
XFILLER_0_94_358 VGND VGND VPWR VPWR sky130_fd_sc_hd__decap_6
XFILLER_0_94_347 VGND VGND VPWR VPWR sky130_fd_sc_hd__decap_3
XFILLER_0_1_93 VPWR VGND VPWR VGND sky130_ef_sc_hd__decap_12
X_5959_ u_pe_array.u_fifo1.buffer\[7\]\[5\] _2681_ _2683_ u_pe_array.u_fifo1.buffer\[1\]\[5\]
+ VGND VGND VPWR VPWR _2724_ sky130_fd_sc_hd__a22o_1
XFILLER_0_118_641 VGND VGND VPWR VPWR sky130_fd_sc_hd__decap_3
XFILLER_0_75_572 VGND VGND VPWR VPWR sky130_fd_sc_hd__decap_4
XFILLER_0_90_531 VGND VGND VPWR VPWR sky130_fd_sc_hd__fill_1
XFILLER_0_90_553 VGND VGND VPWR VPWR sky130_fd_sc_hd__fill_2
X_7629_ clknet_leaf_76_clk _0535_ net949 VGND VGND VPWR VPWR u_pe_array.g_pe_row\[1\].g_pe_col\[0\].u_pe.act_val\[2\]
+ sky130_fd_sc_hd__dfrtp_1
XFILLER_0_31_642 VPWR VGND VPWR VGND sky130_ef_sc_hd__decap_12
XFILLER_0_31_697 VGND VGND VPWR VPWR sky130_fd_sc_hd__decap_8
XFILLER_0_101_596 VGND VGND VPWR VPWR sky130_fd_sc_hd__decap_3
Xhold40 u_pe_array.act_from_up\[6\]\[8\] VGND VGND VPWR VPWR net114 sky130_fd_sc_hd__buf_1
Xhold73 u_pe_array.act_from_down\[3\]\[12\] VGND VGND VPWR VPWR net147 sky130_fd_sc_hd__dlygate4sd3_1
Xhold62 u_pe_array.act_from_left\[7\]\[8\] VGND VGND VPWR VPWR net136 sky130_fd_sc_hd__dlygate4sd3_1
Xhold51 u_pe_array.act_from_down\[11\]\[1\] VGND VGND VPWR VPWR net125 sky130_fd_sc_hd__dlygate4sd3_1
XFILLER_0_98_642 VGND VGND VPWR VPWR sky130_fd_sc_hd__fill_2
Xhold95 _0540_ VGND VGND VPWR VPWR net169 sky130_fd_sc_hd__dlygate4sd3_1
Xhold84 u_pe_array.act_from_left\[7\]\[7\] VGND VGND VPWR VPWR net158 sky130_fd_sc_hd__dlygate4sd3_1
XFILLER_0_98_664 VPWR VGND VPWR VGND sky130_ef_sc_hd__decap_12
XFILLER_0_54_701 VGND VGND VPWR VPWR sky130_fd_sc_hd__decap_4
XFILLER_0_81_542 VPWR VGND VPWR VGND sky130_ef_sc_hd__decap_12
XFILLER_0_109_685 VPWR VGND VPWR VGND sky130_ef_sc_hd__decap_12
XFILLER_0_53_266 VGND VGND VPWR VPWR sky130_fd_sc_hd__decap_4
XFILLER_0_53_288 VGND VGND VPWR VPWR sky130_fd_sc_hd__decap_6
XANTENNA_4 _2652_ VGND VGND VPWR VPWR sky130_fd_sc_hd__diode_2
XFILLER_0_1_503 VGND VGND VPWR VPWR sky130_fd_sc_hd__fill_1
XFILLER_0_22_653 VGND VGND VPWR VPWR sky130_fd_sc_hd__decap_3
XFILLER_0_6_27 VGND VGND VPWR VPWR sky130_fd_sc_hd__fill_1
XFILLER_0_67_57 VGND VGND VPWR VPWR sky130_fd_sc_hd__fill_2
XFILLER_0_67_24 VGND VGND VPWR VPWR sky130_fd_sc_hd__fill_1
X_4290_ net842 _1437_ _1116_ VGND VGND VPWR VPWR _1438_ sky130_fd_sc_hd__mux2_1
XTAP_314 VGND VPWR sky130_fd_sc_hd__tapvpwrvgnd_1
XTAP_303 VGND VPWR sky130_fd_sc_hd__tapvpwrvgnd_1
XTAP_358 VGND VPWR sky130_fd_sc_hd__tapvpwrvgnd_1
XTAP_336 VGND VPWR sky130_fd_sc_hd__tapvpwrvgnd_1
XTAP_347 VGND VPWR sky130_fd_sc_hd__tapvpwrvgnd_1
XTAP_325 VGND VPWR sky130_fd_sc_hd__tapvpwrvgnd_1
XTAP_369 VGND VPWR sky130_fd_sc_hd__tapvpwrvgnd_1
XFILLER_0_83_34 VGND VGND VPWR VPWR sky130_fd_sc_hd__decap_4
XFILLER_0_83_78 VGND VGND VPWR VPWR sky130_fd_sc_hd__decap_3
XFILLER_0_88_141 VPWR VGND VPWR VGND sky130_ef_sc_hd__decap_12
X_6931_ _0922_ net712 _3446_ VGND VGND VPWR VPWR _3449_ sky130_fd_sc_hd__mux2_1
XFILLER_0_89_697 VGND VGND VPWR VPWR sky130_fd_sc_hd__decap_8
XFILLER_0_88_174 VPWR VGND VPWR VGND sky130_ef_sc_hd__decap_12
X_6862_ _3410_ VGND VGND VPWR VPWR _0754_ sky130_fd_sc_hd__clkbuf_1
X_5813_ _2607_ _2612_ _1092_ VGND VGND VPWR VPWR _2614_ sky130_fd_sc_hd__o21ai_1
XFILLER_0_91_306 VGND VGND VPWR VPWR sky130_fd_sc_hd__fill_1
X_6793_ _0915_ _3365_ VGND VGND VPWR VPWR _3366_ sky130_fd_sc_hd__nor2_1
X_5744_ _2548_ _2549_ VGND VGND VPWR VPWR _2551_ sky130_fd_sc_hd__and2_1
X_5675_ u_pe_array.g_pe_row\[1\].g_pe_col\[1\].u_pe.psum_out\[10\] u_pe_array.g_pe_row\[1\].g_pe_col\[1\].u_pe.move_reg\[10\]
+ _2133_ VGND VGND VPWR VPWR _2502_ sky130_fd_sc_hd__mux2_1
XFILLER_0_115_655 VPWR VGND VPWR VGND sky130_ef_sc_hd__decap_12
XFILLER_0_114_121 VPWR VGND VPWR VGND sky130_ef_sc_hd__decap_12
X_7414_ clknet_leaf_26_clk _0320_ net943 VGND VGND VPWR VPWR u_pe_array.g_pe_row\[2\].g_pe_col\[1\].u_pe.psum_out\[5\]
+ sky130_fd_sc_hd__dfrtp_2
XFILLER_0_89_3 VPWR VGND VPWR VGND sky130_ef_sc_hd__decap_12
X_4626_ _1681_ _1687_ VGND VGND VPWR VPWR _1689_ sky130_fd_sc_hd__or2_1
XFILLER_0_114_165 VPWR VGND VPWR VGND sky130_ef_sc_hd__decap_12
Xhold510 u_pe_array.g_pe_row\[1\].g_pe_col\[3\].u_pe.psum_out\[12\] VGND VGND VPWR
+ VPWR net584 sky130_fd_sc_hd__dlygate4sd3_1
X_7345_ clknet_leaf_104_clk _0251_ net944 VGND VGND VPWR VPWR u_pe_array.act_from_up\[14\]\[3\]
+ sky130_fd_sc_hd__dfrtp_1
Xhold554 _1306_ VGND VGND VPWR VPWR net628 sky130_fd_sc_hd__dlygate4sd3_1
Xhold521 u_pe_array.u_fifo1.buffer\[7\]\[5\] VGND VGND VPWR VPWR net595 sky130_fd_sc_hd__dlygate4sd3_1
Xhold543 u_pe_array.u_fifo1.buffer\[4\]\[5\] VGND VGND VPWR VPWR net617 sky130_fd_sc_hd__dlygate4sd3_1
X_4557_ u_pe_array.g_pe_row\[2\].g_pe_col\[3\].u_pe.psum_out\[2\] _1624_ VGND VGND
+ VPWR VPWR _1625_ sky130_fd_sc_hd__xnor2_1
XFILLER_0_40_472 VGND VGND VPWR VPWR sky130_fd_sc_hd__decap_4
Xhold532 u_pe_array.g_pe_row\[1\].g_pe_col\[2\].u_pe.act_val\[5\] VGND VGND VPWR VPWR
+ net606 sky130_fd_sc_hd__dlygate4sd3_1
Xhold576 u_pe_array.g_pe_row\[0\].g_pe_col\[0\].u_pe.psum_out\[3\] VGND VGND VPWR
+ VPWR net650 sky130_fd_sc_hd__dlygate4sd3_1
X_7276_ clknet_leaf_10_clk _0182_ net950 VGND VGND VPWR VPWR u_pe_array.g_pe_row\[3\].g_pe_col\[0\].u_pe.act_val\[3\]
+ sky130_fd_sc_hd__dfrtp_1
XFILLER_0_13_697 VGND VGND VPWR VPWR sky130_fd_sc_hd__decap_8
Xhold587 u_pe_array.u_fifo2.buffer\[8\]\[5\] VGND VGND VPWR VPWR net661 sky130_fd_sc_hd__dlygate4sd3_1
Xhold565 u_pe_array.u_fifo2.buffer\[1\]\[3\] VGND VGND VPWR VPWR net639 sky130_fd_sc_hd__dlygate4sd3_1
X_4488_ u_pe_array.g_pe_row\[3\].g_pe_col\[0\].u_pe.psum_out\[11\] _1587_ _1578_ VGND
+ VGND VPWR VPWR _1588_ sky130_fd_sc_hd__mux2_1
X_6227_ _2922_ _2934_ VGND VGND VPWR VPWR _2935_ sky130_fd_sc_hd__and2_1
Xhold598 u_pe_array.u_fifo1.buffer\[2\]\[3\] VGND VGND VPWR VPWR net672 sky130_fd_sc_hd__dlygate4sd3_1
X_6158_ u_pe_array.g_pe_row\[0\].g_pe_col\[3\].u_pe.act_val\[1\] _1999_ VGND VGND
+ VPWR VPWR _2872_ sky130_fd_sc_hd__and2b_1
XTAP_870 VGND VPWR sky130_fd_sc_hd__tapvpwrvgnd_1
X_5109_ _2050_ u_pe_array.g_pe_row\[2\].g_pe_col\[0\].u_pe.psum_out\[4\] _1286_ VGND
+ VGND VPWR VPWR _2052_ sky130_fd_sc_hd__and3_1
XTAP_881 VGND VPWR sky130_fd_sc_hd__tapvpwrvgnd_1
XTAP_892 VGND VPWR sky130_fd_sc_hd__tapvpwrvgnd_1
XFILLER_0_99_439 VGND VGND VPWR VPWR sky130_fd_sc_hd__fill_1
X_6089_ u_pe_array.g_pe_row\[1\].g_pe_col\[0\].u_pe.psum_out\[11\] _2834_ _2825_ VGND
+ VGND VPWR VPWR _2835_ sky130_fd_sc_hd__mux2_1
XFILLER_0_79_174 VGND VGND VPWR VPWR sky130_fd_sc_hd__decap_8
XFILLER_0_95_667 VGND VGND VPWR VPWR sky130_fd_sc_hd__decap_4
XFILLER_0_36_701 VGND VGND VPWR VPWR sky130_fd_sc_hd__decap_4
XFILLER_0_106_622 VGND VGND VPWR VPWR sky130_fd_sc_hd__fill_2
XFILLER_0_35_233 VGND VGND VPWR VPWR sky130_fd_sc_hd__fill_1
XFILLER_0_35_266 VGND VGND VPWR VPWR sky130_fd_sc_hd__fill_1
XFILLER_0_51_704 VGND VGND VPWR VPWR sky130_fd_sc_hd__fill_1
XFILLER_0_50_225 VGND VGND VPWR VPWR sky130_fd_sc_hd__decap_3
XFILLER_0_106_699 VGND VGND VPWR VPWR sky130_fd_sc_hd__fill_1
XFILLER_0_105_176 VGND VGND VPWR VPWR sky130_fd_sc_hd__fill_1
XFILLER_0_105_165 VGND VGND VPWR VPWR sky130_fd_sc_hd__decap_3
XFILLER_0_90_394 VGND VGND VPWR VPWR sky130_fd_sc_hd__decap_6
XFILLER_0_105_198 VGND VGND VPWR VPWR sky130_fd_sc_hd__decap_4
Xoutput41 net41 VGND VGND VPWR VPWR psum_out0[2] sky130_fd_sc_hd__clkbuf_4
Xoutput52 net52 VGND VGND VPWR VPWR psum_out1[12] sky130_fd_sc_hd__clkbuf_4
XFILLER_0_101_393 VGND VGND VPWR VPWR sky130_fd_sc_hd__decap_6
XFILLER_0_37_38 VGND VGND VPWR VPWR sky130_fd_sc_hd__fill_1
XFILLER_0_58_325 VGND VGND VPWR VPWR sky130_fd_sc_hd__fill_1
XFILLER_0_58_358 VGND VGND VPWR VPWR sky130_fd_sc_hd__decap_6
XFILLER_0_58_347 VGND VGND VPWR VPWR sky130_fd_sc_hd__decap_3
XFILLER_0_85_155 VGND VGND VPWR VPWR sky130_fd_sc_hd__fill_1
XFILLER_0_39_561 VPWR VGND VPWR VGND sky130_ef_sc_hd__decap_12
X_3790_ _1043_ u_pe_array.g_pe_row\[3\].g_pe_col\[3\].u_pe.psum_out\[6\] _0988_ VGND
+ VGND VPWR VPWR _1044_ sky130_fd_sc_hd__and3_1
XFILLER_0_39_594 VGND VGND VPWR VPWR sky130_fd_sc_hd__fill_2
XPHY_191 VGND VGND VPWR VPWR sky130_fd_sc_hd__decap_3
XPHY_180 VGND VGND VPWR VPWR sky130_fd_sc_hd__decap_3
XFILLER_0_5_105 VGND VGND VPWR VPWR sky130_fd_sc_hd__decap_6
XFILLER_0_14_406 VGND VGND VPWR VPWR sky130_fd_sc_hd__fill_1
XFILLER_0_5_149 VPWR VGND VPWR VGND sky130_ef_sc_hd__decap_12
X_5460_ u_pe_array.u_fifo2.buffer\[0\]\[0\] _2324_ VGND VGND VPWR VPWR _2325_ sky130_fd_sc_hd__or2_1
X_4411_ u_pe_array.g_pe_row\[3\].g_pe_col\[0\].u_pe.act_val\[4\] u_pe_array.g_pe_row\[3\].g_pe_col\[0\].u_pe.w_out\[0\]
+ VGND VGND VPWR VPWR _1518_ sky130_fd_sc_hd__nand2_1
XFILLER_0_111_113 VPWR VGND VPWR VGND sky130_ef_sc_hd__decap_12
XFILLER_0_22_461 VGND VGND VPWR VPWR sky130_fd_sc_hd__decap_6
X_5391_ u_pe_array.g_pe_row\[1\].g_pe_col\[2\].u_pe.psum_out\[2\] _1108_ _1110_ _2279_
+ VGND VGND VPWR VPWR _2280_ sky130_fd_sc_hd__o211a_1
XFILLER_0_112_669 VPWR VGND VPWR VGND sky130_ef_sc_hd__decap_12
X_7130_ clknet_leaf_20_clk _0036_ net943 VGND VGND VPWR VPWR u_pe_array.g_pe_row\[3\].g_pe_col\[3\].u_pe.move_reg\[6\]
+ sky130_fd_sc_hd__dfrtp_1
X_4342_ _1474_ VGND VGND VPWR VPWR _0170_ sky130_fd_sc_hd__clkbuf_1
XFILLER_0_10_645 VPWR VGND VPWR VGND sky130_ef_sc_hd__decap_12
XFILLER_0_111_179 VGND VGND VPWR VPWR sky130_fd_sc_hd__fill_1
X_4273_ _1423_ _1424_ _0931_ VGND VGND VPWR VPWR _1425_ sky130_fd_sc_hd__mux2_1
XFILLER_0_1_388 VGND VGND VPWR VPWR sky130_fd_sc_hd__decap_4
X_7061_ _3526_ VGND VGND VPWR VPWR _0837_ sky130_fd_sc_hd__clkbuf_1
X_6012_ _2763_ _2764_ VGND VGND VPWR VPWR _2765_ sky130_fd_sc_hd__xnor2_2
.ends
